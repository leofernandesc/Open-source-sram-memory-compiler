* Local R87 candidate: retain the asymmetric input inverter and use HD inv_2.
* Two inversions restore SCLK polarity. The strong first-stage pull-up
* restores MID on disable, and the restoring cell actively pulls OUT down.
.subckt phase3_sclk_local_v2 IN OUT VPWR VGND
XP_SKEW MID IN VPWR VPWR sky130_fd_pr__pfet_01v8 w=2.52 l=0.15 ad=0.7308 as=0.7308 pd=5.62 ps=5.62
XN_SKEW MID IN VGND VGND sky130_fd_pr__nfet_01v8 w=0.65 l=0.15 ad=0.1885 as=0.1885 pd=1.88 ps=1.88
X_RESTORE MID VGND VGND VPWR VPWR OUT sky130_fd_sc_hd__inv_2
.ends phase3_sclk_local_v2
