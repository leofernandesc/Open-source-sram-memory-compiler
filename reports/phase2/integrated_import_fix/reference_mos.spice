.model sky130_fd_pr__nfet_01v8 nmos
.model sky130_fd_pr__pfet_01v8 pmos
.model sky130_fd_pr__pfet_01v8_hvt pmos
.model sky130_fd_pr__special_nfet_01v8 nmos
.subckt sky130_fd_sc_hd__and2_1 A B VGND VNB VPB VPWR X
M0 VGND a_59_75# X VNB sky130_fd_pr__nfet_01v8 w=0.65u l=0.15u
M1 VPWR A a_59_75# VPB sky130_fd_pr__pfet_01v8_hvt w=0.42u l=0.15u
M2 a_59_75# A a_145_75# VNB sky130_fd_pr__nfet_01v8 w=0.42u l=0.15u
M3 a_59_75# B VPWR VPB sky130_fd_pr__pfet_01v8_hvt w=0.42u l=0.15u
M4 a_145_75# B VGND VNB sky130_fd_pr__nfet_01v8 w=0.42u l=0.15u
M5 VPWR a_59_75# X VPB sky130_fd_pr__pfet_01v8_hvt w=1u l=0.15u
.ends sky130_fd_sc_hd__and2_1

.model sky130_fd_pr__nfet_01v8 nmos
.model sky130_fd_pr__pfet_01v8 pmos
.model sky130_fd_pr__pfet_01v8_hvt pmos
.model sky130_fd_pr__special_nfet_01v8 nmos
.subckt sky130_fd_sc_hd__and2_4 A B VGND VNB VPB VPWR X
M0 a_27_47# B VPWR VPB sky130_fd_pr__pfet_01v8_hvt w=1u l=0.15u
M1 VPWR A a_27_47# VPB sky130_fd_pr__pfet_01v8_hvt w=1u l=0.15u
M2 a_110_47# B VGND VNB sky130_fd_pr__nfet_01v8 w=0.65u l=0.15u
M3 VGND a_27_47# X VNB sky130_fd_pr__nfet_01v8 w=0.65u l=0.15u
M4 a_27_47# A a_110_47# VNB sky130_fd_pr__nfet_01v8 w=0.65u l=0.15u
M5 X a_27_47# VGND VNB sky130_fd_pr__nfet_01v8 w=0.65u l=0.15u
M6 VPWR a_27_47# X VPB sky130_fd_pr__pfet_01v8_hvt w=1u l=0.15u
M7 VPWR a_27_47# X VPB sky130_fd_pr__pfet_01v8_hvt w=1u l=0.15u
M8 VGND a_27_47# X VNB sky130_fd_pr__nfet_01v8 w=0.65u l=0.15u
M9 X a_27_47# VPWR VPB sky130_fd_pr__pfet_01v8_hvt w=1u l=0.15u
M10 X a_27_47# VGND VNB sky130_fd_pr__nfet_01v8 w=0.65u l=0.15u
M11 X a_27_47# VPWR VPB sky130_fd_pr__pfet_01v8_hvt w=1u l=0.15u
.ends sky130_fd_sc_hd__and2_4

.model sky130_fd_pr__nfet_01v8 nmos
.model sky130_fd_pr__pfet_01v8 pmos
.model sky130_fd_pr__pfet_01v8_hvt pmos
.model sky130_fd_pr__special_nfet_01v8 nmos
.subckt sky130_fd_sc_hd__and3_2 A B C VGND VNB VPB VPWR X
M0 X a_29_311# VGND VNB sky130_fd_pr__nfet_01v8 w=0.65u l=0.15u
M1 X a_29_311# VPWR VPB sky130_fd_pr__pfet_01v8_hvt w=1u l=0.15u
M2 a_184_53# C VGND VNB sky130_fd_pr__nfet_01v8 w=0.42u l=0.15u
M3 a_29_311# A VPWR VPB sky130_fd_pr__pfet_01v8_hvt w=0.42u l=0.15u
M4 VGND a_29_311# X VNB sky130_fd_pr__nfet_01v8 w=0.65u l=0.15u
M5 a_112_53# B a_184_53# VNB sky130_fd_pr__nfet_01v8 w=0.42u l=0.15u
M6 a_29_311# A a_112_53# VNB sky130_fd_pr__nfet_01v8 w=0.42u l=0.15u
M7 VPWR a_29_311# X VPB sky130_fd_pr__pfet_01v8_hvt w=1u l=0.15u
M8 VPWR B a_29_311# VPB sky130_fd_pr__pfet_01v8_hvt w=0.42u l=0.15u
M9 a_29_311# C VPWR VPB sky130_fd_pr__pfet_01v8_hvt w=0.42u l=0.15u
.ends sky130_fd_sc_hd__and3_2

.model sky130_fd_pr__nfet_01v8 nmos
.model sky130_fd_pr__pfet_01v8 pmos
.model sky130_fd_pr__pfet_01v8_hvt pmos
.model sky130_fd_pr__special_nfet_01v8 nmos
.subckt sky130_fd_sc_hd__and3_4 A B C VGND VNB VPB VPWR X
M0 a_185_47# B a_294_47# VNB sky130_fd_pr__nfet_01v8 w=0.65u l=0.15u
M1 X a_94_47# VGND VNB sky130_fd_pr__nfet_01v8 w=0.65u l=0.15u
M2 VPWR B a_94_47# VPB sky130_fd_pr__pfet_01v8_hvt w=1u l=0.15u
M3 a_94_47# A VPWR VPB sky130_fd_pr__pfet_01v8_hvt w=1u l=0.15u
M4 a_94_47# A a_185_47# VNB sky130_fd_pr__nfet_01v8 w=0.65u l=0.15u
M5 a_94_47# C VPWR VPB sky130_fd_pr__pfet_01v8_hvt w=1u l=0.15u
M6 VGND a_94_47# X VNB sky130_fd_pr__nfet_01v8 w=0.65u l=0.15u
M7 X a_94_47# VPWR VPB sky130_fd_pr__pfet_01v8_hvt w=1u l=0.15u
M8 VPWR a_94_47# X VPB sky130_fd_pr__pfet_01v8_hvt w=1u l=0.15u
M9 a_294_47# C VGND VNB sky130_fd_pr__nfet_01v8 w=0.65u l=0.15u
M10 X a_94_47# VGND VNB sky130_fd_pr__nfet_01v8 w=0.65u l=0.15u
M11 VGND a_94_47# X VNB sky130_fd_pr__nfet_01v8 w=0.65u l=0.15u
M12 X a_94_47# VPWR VPB sky130_fd_pr__pfet_01v8_hvt w=1u l=0.15u
M13 VPWR a_94_47# X VPB sky130_fd_pr__pfet_01v8_hvt w=1u l=0.15u
.ends sky130_fd_sc_hd__and3_4

.model sky130_fd_pr__nfet_01v8 nmos
.model sky130_fd_pr__pfet_01v8 pmos
.model sky130_fd_pr__pfet_01v8_hvt pmos
.model sky130_fd_pr__special_nfet_01v8 nmos
.subckt sky130_fd_sc_hd__clkbuf_2 A VGND VNB VPB VPWR X
M0 a_27_47# A VPWR VPB sky130_fd_pr__pfet_01v8_hvt w=1u l=0.15u
M1 a_27_47# A VGND VNB sky130_fd_pr__nfet_01v8 w=0.42u l=0.15u
M2 X a_27_47# VPWR VPB sky130_fd_pr__pfet_01v8_hvt w=1u l=0.15u
M3 VPWR a_27_47# X VPB sky130_fd_pr__pfet_01v8_hvt w=1u l=0.15u
M4 X a_27_47# VGND VNB sky130_fd_pr__nfet_01v8 w=0.42u l=0.15u
M5 VGND a_27_47# X VNB sky130_fd_pr__nfet_01v8 w=0.42u l=0.15u
.ends sky130_fd_sc_hd__clkbuf_2

.model sky130_fd_pr__nfet_01v8 nmos
.model sky130_fd_pr__pfet_01v8 pmos
.model sky130_fd_pr__pfet_01v8_hvt pmos
.model sky130_fd_pr__special_nfet_01v8 nmos
.subckt sky130_fd_sc_hd__clkinv_1 A VGND VNB VPB VPWR Y
M0 Y A VPWR VPB sky130_fd_pr__pfet_01v8_hvt w=0.84u l=0.15u
M1 Y A VGND VNB sky130_fd_pr__nfet_01v8 w=0.42u l=0.15u
M2 VPWR A Y VPB sky130_fd_pr__pfet_01v8_hvt w=0.84u l=0.15u
.ends sky130_fd_sc_hd__clkinv_1

.model sky130_fd_pr__nfet_01v8 nmos
.model sky130_fd_pr__pfet_01v8 pmos
.model sky130_fd_pr__pfet_01v8_hvt pmos
.model sky130_fd_pr__special_nfet_01v8 nmos
.subckt sky130_fd_sc_hd__dfxtp_1 CLK D VGND VNB VPB VPWR Q
M0 a_891_413# a_193_47# a_975_413# VPB sky130_fd_pr__pfet_01v8_hvt w=0.42u l=0.15u
M1 a_1059_315# a_891_413# VGND VNB sky130_fd_pr__nfet_01v8 w=0.65u l=0.15u
M2 a_466_413# a_27_47# a_561_413# VPB sky130_fd_pr__pfet_01v8_hvt w=0.42u l=0.15u
M3 a_634_159# a_27_47# a_891_413# VPB sky130_fd_pr__pfet_01v8_hvt w=0.42u l=0.15u
M4 a_381_47# a_193_47# a_466_413# VPB sky130_fd_pr__pfet_01v8_hvt w=0.42u l=0.15u
M5 VPWR D a_381_47# VPB sky130_fd_pr__pfet_01v8_hvt w=0.42u l=0.15u
M6 VPWR a_466_413# a_634_159# VPB sky130_fd_pr__pfet_01v8_hvt w=0.75u l=0.15u
M7 VGND a_466_413# a_634_159# VNB sky130_fd_pr__nfet_01v8 w=0.64u l=0.15u
M8 a_1017_47# a_1059_315# VGND VNB sky130_fd_pr__nfet_01v8 w=0.42u l=0.15u
M9 a_1059_315# a_891_413# VPWR VPB sky130_fd_pr__pfet_01v8_hvt w=1u l=0.15u
M10 a_561_413# a_634_159# VPWR VPB sky130_fd_pr__pfet_01v8_hvt w=0.42u l=0.15u
M11 VPWR a_1059_315# Q VPB sky130_fd_pr__pfet_01v8_hvt w=1u l=0.15u
M12 a_891_413# a_27_47# a_1017_47# VNB sky130_fd_pr__special_nfet_01v8 w=0.36u l=0.15u
M13 a_634_159# a_193_47# a_891_413# VNB sky130_fd_pr__special_nfet_01v8 w=0.36u l=0.15u
M14 a_592_47# a_634_159# VGND VNB sky130_fd_pr__nfet_01v8 w=0.42u l=0.15u
M15 a_466_413# a_193_47# a_592_47# VNB sky130_fd_pr__special_nfet_01v8 w=0.36u l=0.15u
M16 VGND a_27_47# a_193_47# VNB sky130_fd_pr__nfet_01v8 w=0.42u l=0.15u
M17 a_381_47# a_27_47# a_466_413# VNB sky130_fd_pr__special_nfet_01v8 w=0.36u l=0.15u
M18 a_27_47# CLK VGND VNB sky130_fd_pr__nfet_01v8 w=0.42u l=0.15u
M19 a_27_47# CLK VPWR VPB sky130_fd_pr__pfet_01v8_hvt w=0.64u l=0.15u
M20 VPWR a_27_47# a_193_47# VPB sky130_fd_pr__pfet_01v8_hvt w=0.64u l=0.15u
M21 VGND D a_381_47# VNB sky130_fd_pr__nfet_01v8 w=0.42u l=0.15u
M22 a_975_413# a_1059_315# VPWR VPB sky130_fd_pr__pfet_01v8_hvt w=0.42u l=0.15u
M23 VGND a_1059_315# Q VNB sky130_fd_pr__nfet_01v8 w=0.65u l=0.15u
.ends sky130_fd_sc_hd__dfxtp_1

.model sky130_fd_pr__nfet_01v8 nmos
.model sky130_fd_pr__pfet_01v8 pmos
.model sky130_fd_pr__pfet_01v8_hvt pmos
.model sky130_fd_pr__special_nfet_01v8 nmos
.subckt sky130_fd_sc_hd__ebufn_1 A TE_B VGND VNB VPB VPWR Z
M0 VGND TE_B a_193_369# VNB sky130_fd_pr__nfet_01v8 w=0.42u l=0.15u
M1 VGND a_193_369# a_531_47# VNB sky130_fd_pr__nfet_01v8 w=0.65u l=0.15u
M2 a_531_47# a_27_47# Z VNB sky130_fd_pr__nfet_01v8 w=0.65u l=0.15u
M3 VPWR TE_B a_383_297# VPB sky130_fd_pr__pfet_01v8_hvt w=1u l=0.15u
M4 a_383_297# a_27_47# Z VPB sky130_fd_pr__pfet_01v8_hvt w=1u l=0.15u
M5 a_27_47# A VPWR VPB sky130_fd_pr__pfet_01v8_hvt w=0.64u l=0.15u
M6 VPWR TE_B a_193_369# VPB sky130_fd_pr__pfet_01v8_hvt w=0.64u l=0.15u
M7 a_27_47# A VGND VNB sky130_fd_pr__nfet_01v8 w=0.42u l=0.15u
.ends sky130_fd_sc_hd__ebufn_1

.subckt sky130_fd_sc_hd__fill_1 VGND VNB VPB VPWR
.ends

.subckt sky130_fd_sc_hd__fill_2 VGND VNB VPB VPWR
.ends

.subckt sky130_fd_sc_hd__fill_4 VGND VNB VPB VPWR
.ends

.subckt sky130_fd_sc_hd__fill_8 VGND VNB VPB VPWR
.ends

.model sky130_fd_pr__nfet_01v8 nmos
.model sky130_fd_pr__pfet_01v8 pmos
.model sky130_fd_pr__pfet_01v8_hvt pmos
.model sky130_fd_pr__special_nfet_01v8 nmos
.subckt sky130_fd_sc_hd__inv_1 A VGND VNB VPB VPWR Y
M0 VGND A Y VNB sky130_fd_pr__nfet_01v8 w=0.65u l=0.15u
M1 VPWR A Y VPB sky130_fd_pr__pfet_01v8_hvt w=1u l=0.15u
.ends sky130_fd_sc_hd__inv_1

.model sky130_fd_pr__nfet_01v8 nmos
.model sky130_fd_pr__pfet_01v8 pmos
.model sky130_fd_pr__pfet_01v8_hvt pmos
.model sky130_fd_pr__special_nfet_01v8 nmos
.subckt sky130_fd_sc_hd__mux2_1 A0 A1 S VGND VNB VPB VPWR X
M0 VPWR S a_218_374# VPB sky130_fd_pr__pfet_01v8_hvt w=0.42u l=0.15u
M1 a_76_199# A0 a_439_47# VNB sky130_fd_pr__nfet_01v8 w=0.42u l=0.15u
M2 a_535_374# a_505_21# VPWR VPB sky130_fd_pr__pfet_01v8_hvt w=0.42u l=0.15u
M3 VPWR S a_505_21# VPB sky130_fd_pr__pfet_01v8_hvt w=0.42u l=0.15u
M4 a_76_199# A1 a_535_374# VPB sky130_fd_pr__pfet_01v8_hvt w=0.42u l=0.15u
M5 a_218_47# A1 a_76_199# VNB sky130_fd_pr__nfet_01v8 w=0.42u l=0.15u
M6 a_218_374# A0 a_76_199# VPB sky130_fd_pr__pfet_01v8_hvt w=0.42u l=0.15u
M7 X a_76_199# VGND VNB sky130_fd_pr__nfet_01v8 w=0.65u l=0.15u
M8 X a_76_199# VPWR VPB sky130_fd_pr__pfet_01v8_hvt w=1u l=0.15u
M9 VGND S a_218_47# VNB sky130_fd_pr__nfet_01v8 w=0.42u l=0.15u
M10 VGND S a_505_21# VNB sky130_fd_pr__nfet_01v8 w=0.42u l=0.15u
M11 a_439_47# a_505_21# VGND VNB sky130_fd_pr__nfet_01v8 w=0.42u l=0.15u
.ends sky130_fd_sc_hd__mux2_1

.model sky130_fd_pr__nfet_01v8 nmos
.model sky130_fd_pr__pfet_01v8 pmos
.model sky130_fd_pr__pfet_01v8_hvt pmos
.model sky130_fd_pr__special_nfet_01v8 nmos
.subckt sky130_fd_sc_hd__nand2_1 A B VGND VNB VPB VPWR Y
M0 Y A VPWR VPB sky130_fd_pr__pfet_01v8_hvt w=1u l=0.15u
M1 VPWR B Y VPB sky130_fd_pr__pfet_01v8_hvt w=1u l=0.15u
M2 VGND B a_113_47# VNB sky130_fd_pr__nfet_01v8 w=0.65u l=0.15u
M3 a_113_47# A Y VNB sky130_fd_pr__nfet_01v8 w=0.65u l=0.15u
.ends sky130_fd_sc_hd__nand2_1

.model sky130_fd_pr__nfet_01v8 nmos
.model sky130_fd_pr__pfet_01v8 pmos
.model sky130_fd_pr__pfet_01v8_hvt pmos
.model sky130_fd_pr__special_nfet_01v8 nmos
.subckt sky130_fd_sc_hd__nor3b_1 A B C_N VGND VNB VPB VPWR Y
M0 Y A VGND VNB sky130_fd_pr__nfet_01v8 w=0.65u l=0.15u
M1 VPWR C_N a_91_199# VPB sky130_fd_pr__pfet_01v8_hvt w=0.42u l=0.15u
M2 a_161_297# B a_245_297# VPB sky130_fd_pr__pfet_01v8_hvt w=1u l=0.15u
M3 VGND C_N a_91_199# VNB sky130_fd_pr__nfet_01v8 w=0.42u l=0.15u
M4 Y a_91_199# a_161_297# VPB sky130_fd_pr__pfet_01v8_hvt w=1u l=0.15u
M5 a_245_297# A VPWR VPB sky130_fd_pr__pfet_01v8_hvt w=1u l=0.15u
M6 VGND B Y VNB sky130_fd_pr__nfet_01v8 w=0.65u l=0.15u
M7 Y a_91_199# VGND VNB sky130_fd_pr__nfet_01v8 w=0.65u l=0.15u
.ends sky130_fd_sc_hd__nor3b_1

.model sky130_fd_pr__nfet_01v8 nmos
.model sky130_fd_pr__pfet_01v8 pmos
.model sky130_fd_pr__pfet_01v8_hvt pmos
.model sky130_fd_pr__special_nfet_01v8 nmos
.subckt sky130_fd_sc_hd__or2_1 A B VGND VNB VPB VPWR X
M0 a_150_297# A VPWR VPB sky130_fd_pr__pfet_01v8_hvt w=0.42u l=0.15u
M1 VGND a_68_297# X VNB sky130_fd_pr__nfet_01v8 w=0.65u l=0.15u
M2 VGND B a_68_297# VNB sky130_fd_pr__nfet_01v8 w=0.42u l=0.15u
M3 a_68_297# A VGND VNB sky130_fd_pr__nfet_01v8 w=0.42u l=0.15u
M4 a_68_297# B a_150_297# VPB sky130_fd_pr__pfet_01v8_hvt w=0.42u l=0.15u
M5 VPWR a_68_297# X VPB sky130_fd_pr__pfet_01v8_hvt w=1u l=0.15u
.ends sky130_fd_sc_hd__or2_1

.subckt sky130_fd_sc_hd__tapvpwrvgnd_1 VGND VPWR
.ends

.subckt sram_4x8_wrapper CLK CSb OEb WEb ADDR0 ADDR1 DATA0 DATA1 DATA2 DATA3 DATA4 DATA5 DATA6 DATA7 VDD VSS
Xmapped12695 n16 VSS VSS VDD VDD n17 sky130_fd_sc_hd__clkinv_1
Xmapped12696 OEb CSb WEb VSS VSS VDD VDD n18 sky130_fd_sc_hd__nor3b_1
Xmapped12697 n19 n18 VSS VSS VDD VDD n20 sky130_fd_sc_hd__nand2_1
Xmapped12698 n21 n22 n19 VSS VSS VDD VDD n23 sky130_fd_sc_hd__mux2_1
Xmapped12699 n24 n25 n19 VSS VSS VDD VDD n26 sky130_fd_sc_hd__mux2_1
Xmapped12700 n27 n28 n19 VSS VSS VDD VDD n29 sky130_fd_sc_hd__mux2_1
Xmapped12701 n30 n31 n19 VSS VSS VDD VDD n32 sky130_fd_sc_hd__mux2_1
Xmapped12702 n33 n34 n19 VSS VSS VDD VDD n35 sky130_fd_sc_hd__mux2_1
Xmapped12703 n36 n37 n19 VSS VSS VDD VDD n38 sky130_fd_sc_hd__mux2_1
Xmapped12704 n39 n40 n19 VSS VSS VDD VDD n41 sky130_fd_sc_hd__mux2_1
Xmapped12705 n42 n43 n19 VSS VSS VDD VDD n44 sky130_fd_sc_hd__mux2_1
Xmapped12706 WEb CSb OEb VSS VSS VDD VDD n45 sky130_fd_sc_hd__nor3b_1
Xmapped12707 n46 DATA0 n45 VSS VSS VDD VDD n47 sky130_fd_sc_hd__mux2_1
Xmapped12708 n48 DATA1 n45 VSS VSS VDD VDD n49 sky130_fd_sc_hd__mux2_1
Xmapped12709 n50 DATA2 n45 VSS VSS VDD VDD n51 sky130_fd_sc_hd__mux2_1
Xmapped12710 n52 DATA3 n45 VSS VSS VDD VDD n53 sky130_fd_sc_hd__mux2_1
Xmapped12711 n54 DATA4 n45 VSS VSS VDD VDD n55 sky130_fd_sc_hd__mux2_1
Xmapped12712 n56 DATA5 n45 VSS VSS VDD VDD n57 sky130_fd_sc_hd__mux2_1
Xmapped12713 n58 DATA6 n45 VSS VSS VDD VDD n59 sky130_fd_sc_hd__mux2_1
Xmapped12714 n60 DATA7 n45 VSS VSS VDD VDD n61 sky130_fd_sc_hd__mux2_1
Xmapped12715 n19 n18 VSS VSS VDD VDD n62 sky130_fd_sc_hd__nand2_1
Xmapped12716 n19 n18 VSS VSS VDD VDD n63 sky130_fd_sc_hd__nand2_1
Xmapped12717 n19 n18 VSS VSS VDD VDD n64 sky130_fd_sc_hd__nand2_1
Xmapped12718 n19 n18 VSS VSS VDD VDD n65 sky130_fd_sc_hd__nand2_1
Xmapped12719 n19 n18 VSS VSS VDD VDD n66 sky130_fd_sc_hd__nand2_1
Xmapped12720 n19 n18 VSS VSS VDD VDD n67 sky130_fd_sc_hd__nand2_1
Xmapped12721 n19 n18 VSS VSS VDD VDD n68 sky130_fd_sc_hd__nand2_1
Xmapped12722 n16 VSS VSS VDD VDD n69 sky130_fd_sc_hd__clkinv_1
Xmapped12723 n16 VSS VSS VDD VDD n70 sky130_fd_sc_hd__clkinv_1
Xmapped12724 n16 VSS VSS VDD VDD n71 sky130_fd_sc_hd__clkinv_1
Xmapped12725 n72 VSS VSS VDD VDD n73 sky130_fd_sc_hd__clkinv_1
Xmapped12726 n72 VSS VSS VDD VDD n74 sky130_fd_sc_hd__clkinv_1
Xmapped12727 n72 VSS VSS VDD VDD n75 sky130_fd_sc_hd__clkinv_1
Xmapped12728 n72 VSS VSS VDD VDD n76 sky130_fd_sc_hd__clkinv_1
Xmapped12729 n16 n47 VSS VSS VDD VDD n46 sky130_fd_sc_hd__dfxtp_1
Xmapped12730 n16 n49 VSS VSS VDD VDD n48 sky130_fd_sc_hd__dfxtp_1
Xmapped12731 n16 n51 VSS VSS VDD VDD n50 sky130_fd_sc_hd__dfxtp_1
Xmapped12732 n16 n53 VSS VSS VDD VDD n52 sky130_fd_sc_hd__dfxtp_1
Xmapped12733 n72 n55 VSS VSS VDD VDD n54 sky130_fd_sc_hd__dfxtp_1
Xmapped12734 n72 n57 VSS VSS VDD VDD n56 sky130_fd_sc_hd__dfxtp_1
Xmapped12735 n72 n59 VSS VSS VDD VDD n58 sky130_fd_sc_hd__dfxtp_1
Xmapped12736 n72 n61 VSS VSS VDD VDD n60 sky130_fd_sc_hd__dfxtp_1
Xmapped12737 n17 n44 VSS VSS VDD VDD n42 sky130_fd_sc_hd__dfxtp_1
Xmapped12738 n69 n41 VSS VSS VDD VDD n39 sky130_fd_sc_hd__dfxtp_1
Xmapped12739 n70 n38 VSS VSS VDD VDD n36 sky130_fd_sc_hd__dfxtp_1
Xmapped12740 n71 n35 VSS VSS VDD VDD n33 sky130_fd_sc_hd__dfxtp_1
Xmapped12741 n73 n32 VSS VSS VDD VDD n30 sky130_fd_sc_hd__dfxtp_1
Xmapped12742 n74 n29 VSS VSS VDD VDD n27 sky130_fd_sc_hd__dfxtp_1
Xmapped12743 n75 n26 VSS VSS VDD VDD n24 sky130_fd_sc_hd__dfxtp_1
Xmapped12744 n76 n23 VSS VSS VDD VDD n21 sky130_fd_sc_hd__dfxtp_1
Xmapped12745 n16 n45 VSS VSS VDD VDD n77 sky130_fd_sc_hd__dfxtp_1
Xmapped12746 n16 n18 VSS VSS VDD VDD n19 sky130_fd_sc_hd__dfxtp_1
Xmapped12747 n16 ADDR0 VSS VSS VDD VDD n78 sky130_fd_sc_hd__dfxtp_1
Xmapped12748 n16 ADDR1 VSS VSS VDD VDD n79 sky130_fd_sc_hd__dfxtp_1
Xmapped12749 n42 n68 VSS VSS VDD VDD DATA0 sky130_fd_sc_hd__ebufn_1
Xmapped12750 n39 n67 VSS VSS VDD VDD DATA1 sky130_fd_sc_hd__ebufn_1
Xmapped12751 n36 n66 VSS VSS VDD VDD DATA2 sky130_fd_sc_hd__ebufn_1
Xmapped12752 n33 n65 VSS VSS VDD VDD DATA3 sky130_fd_sc_hd__ebufn_1
Xmapped12753 n30 n64 VSS VSS VDD VDD DATA4 sky130_fd_sc_hd__ebufn_1
Xmapped12754 n27 n63 VSS VSS VDD VDD DATA5 sky130_fd_sc_hd__ebufn_1
Xmapped12755 n24 n62 VSS VSS VDD VDD DATA6 sky130_fd_sc_hd__ebufn_1
Xmapped12756 n21 n20 VSS VSS VDD VDD DATA7 sky130_fd_sc_hd__ebufn_1
Xmapped12757 CLK VSS VSS VDD VDD n80 sky130_fd_sc_hd__clkbuf_2
Xmapped12758 n80 VSS VSS VDD VDD n16 sky130_fd_sc_hd__clkbuf_2
Xmapped12759 n80 VSS VSS VDD VDD n72 sky130_fd_sc_hd__clkbuf_2
Xmapped12760 n19 n77 VSS VSS VDD VDD n81 sky130_fd_sc_hd__or2_1
Xmapped12761 VDD VSS n78 n79 n94 n95 n100 n101 n46 n48 n50 n52 n54 n56 n58 n60 n86 n87 n88 n89 n90 n91 n92 n93 n43 n40 n37 n34 n31 n28 n25 n22 n96 n97 n98 n99 n82 n83 n84 n85 leaf_fabric
Xmapped12762 n46 VSS VSS VDD VDD n86 sky130_fd_sc_hd__inv_1
Xmapped12763 n48 VSS VSS VDD VDD n87 sky130_fd_sc_hd__inv_1
Xmapped12764 n50 VSS VSS VDD VDD n88 sky130_fd_sc_hd__inv_1
Xmapped12765 n52 VSS VSS VDD VDD n89 sky130_fd_sc_hd__inv_1
Xmapped12766 n54 VSS VSS VDD VDD n90 sky130_fd_sc_hd__inv_1
Xmapped12767 n56 VSS VSS VDD VDD n91 sky130_fd_sc_hd__inv_1
Xmapped12768 n58 VSS VSS VDD VDD n92 sky130_fd_sc_hd__inv_1
Xmapped12769 n60 VSS VSS VDD VDD n93 sky130_fd_sc_hd__inv_1
Xmapped12770 n81 n16 n102 VSS VSS VDD VDD n94 sky130_fd_sc_hd__and3_2
Xmapped12771 n72 VSS VSS VDD VDD n103 sky130_fd_sc_hd__inv_1
Xmapped12772 n104 VSS VSS VDD VDD n105 sky130_fd_sc_hd__inv_1
Xmapped12773 n105 VSS VSS VDD VDD n106 sky130_fd_sc_hd__inv_1
Xmapped12774 n106 VSS VSS VDD VDD n107 sky130_fd_sc_hd__inv_1
Xmapped12775 n107 VSS VSS VDD VDD n108 sky130_fd_sc_hd__inv_1
Xmapped12776 n108 VSS VSS VDD VDD n109 sky130_fd_sc_hd__inv_1
Xmapped12777 n109 VSS VSS VDD VDD n110 sky130_fd_sc_hd__inv_1
Xmapped12778 n110 VSS VSS VDD VDD n111 sky130_fd_sc_hd__inv_1
Xmapped12779 n111 VSS VSS VDD VDD n112 sky130_fd_sc_hd__inv_1
Xmapped12780 n112 VSS VSS VDD VDD n113 sky130_fd_sc_hd__inv_1
Xmapped12781 n113 VSS VSS VDD VDD n114 sky130_fd_sc_hd__inv_1
Xmapped12782 n103 VSS VSS VDD VDD n115 sky130_fd_sc_hd__inv_1
Xmapped12783 n114 VSS VSS VDD VDD n116 sky130_fd_sc_hd__inv_1
Xmapped12784 n116 VSS VSS VDD VDD n117 sky130_fd_sc_hd__inv_1
Xmapped12785 n117 VSS VSS VDD VDD n118 sky130_fd_sc_hd__inv_1
Xmapped12786 n118 VSS VSS VDD VDD n119 sky130_fd_sc_hd__inv_1
Xmapped12787 n119 VSS VSS VDD VDD n120 sky130_fd_sc_hd__inv_1
Xmapped12788 n120 VSS VSS VDD VDD n121 sky130_fd_sc_hd__inv_1
Xmapped12789 n121 VSS VSS VDD VDD n122 sky130_fd_sc_hd__inv_1
Xmapped12790 n122 VSS VSS VDD VDD n123 sky130_fd_sc_hd__inv_1
Xmapped12791 n123 VSS VSS VDD VDD n124 sky130_fd_sc_hd__inv_1
Xmapped12792 n124 VSS VSS VDD VDD n125 sky130_fd_sc_hd__inv_1
Xmapped12793 n115 VSS VSS VDD VDD n126 sky130_fd_sc_hd__inv_1
Xmapped12794 n125 VSS VSS VDD VDD n127 sky130_fd_sc_hd__inv_1
Xmapped12795 n127 VSS VSS VDD VDD n128 sky130_fd_sc_hd__inv_1
Xmapped12796 n128 VSS VSS VDD VDD n129 sky130_fd_sc_hd__inv_1
Xmapped12797 n129 VSS VSS VDD VDD n130 sky130_fd_sc_hd__inv_1
Xmapped12798 n130 VSS VSS VDD VDD n131 sky130_fd_sc_hd__inv_1
Xmapped12799 n131 VSS VSS VDD VDD n132 sky130_fd_sc_hd__inv_1
Xmapped12800 n132 VSS VSS VDD VDD n133 sky130_fd_sc_hd__inv_1
Xmapped12801 n133 VSS VSS VDD VDD n134 sky130_fd_sc_hd__inv_1
Xmapped12802 n134 VSS VSS VDD VDD n135 sky130_fd_sc_hd__inv_1
Xmapped12803 n135 VSS VSS VDD VDD n136 sky130_fd_sc_hd__inv_1
Xmapped12804 n126 VSS VSS VDD VDD n137 sky130_fd_sc_hd__inv_1
Xmapped12805 n136 VSS VSS VDD VDD n138 sky130_fd_sc_hd__inv_1
Xmapped12806 n138 VSS VSS VDD VDD n139 sky130_fd_sc_hd__inv_1
Xmapped12807 n139 VSS VSS VDD VDD n140 sky130_fd_sc_hd__inv_1
Xmapped12808 n140 VSS VSS VDD VDD n141 sky130_fd_sc_hd__inv_1
Xmapped12809 n141 VSS VSS VDD VDD n142 sky130_fd_sc_hd__inv_1
Xmapped12810 n142 VSS VSS VDD VDD n143 sky130_fd_sc_hd__inv_1
Xmapped12811 n143 VSS VSS VDD VDD n144 sky130_fd_sc_hd__inv_1
Xmapped12812 n144 VSS VSS VDD VDD n145 sky130_fd_sc_hd__inv_1
Xmapped12813 n145 VSS VSS VDD VDD n146 sky130_fd_sc_hd__inv_1
Xmapped12814 n146 VSS VSS VDD VDD n147 sky130_fd_sc_hd__inv_1
Xmapped12815 n137 VSS VSS VDD VDD n148 sky130_fd_sc_hd__inv_1
Xmapped12816 n147 VSS VSS VDD VDD n149 sky130_fd_sc_hd__inv_1
Xmapped12817 n149 VSS VSS VDD VDD n150 sky130_fd_sc_hd__inv_1
Xmapped12818 n150 VSS VSS VDD VDD n151 sky130_fd_sc_hd__inv_1
Xmapped12819 n151 VSS VSS VDD VDD n152 sky130_fd_sc_hd__inv_1
Xmapped12820 n152 VSS VSS VDD VDD n153 sky130_fd_sc_hd__inv_1
Xmapped12821 n153 VSS VSS VDD VDD n154 sky130_fd_sc_hd__inv_1
Xmapped12822 n154 VSS VSS VDD VDD n155 sky130_fd_sc_hd__inv_1
Xmapped12823 n155 VSS VSS VDD VDD n156 sky130_fd_sc_hd__inv_1
Xmapped12824 n156 VSS VSS VDD VDD n157 sky130_fd_sc_hd__inv_1
Xmapped12825 n157 VSS VSS VDD VDD n102 sky130_fd_sc_hd__inv_1
Xmapped12826 n148 VSS VSS VDD VDD n158 sky130_fd_sc_hd__inv_1
Xmapped12827 n102 VSS VSS VDD VDD n159 sky130_fd_sc_hd__inv_1
Xmapped12828 n159 VSS VSS VDD VDD n160 sky130_fd_sc_hd__inv_1
Xmapped12829 n160 VSS VSS VDD VDD n161 sky130_fd_sc_hd__inv_1
Xmapped12830 n161 VSS VSS VDD VDD n162 sky130_fd_sc_hd__inv_1
Xmapped12831 n162 VSS VSS VDD VDD n163 sky130_fd_sc_hd__inv_1
Xmapped12832 n163 VSS VSS VDD VDD n164 sky130_fd_sc_hd__inv_1
Xmapped12833 n164 VSS VSS VDD VDD n165 sky130_fd_sc_hd__inv_1
Xmapped12834 n165 VSS VSS VDD VDD n166 sky130_fd_sc_hd__inv_1
Xmapped12835 n166 VSS VSS VDD VDD n167 sky130_fd_sc_hd__inv_1
Xmapped12836 n167 VSS VSS VDD VDD n168 sky130_fd_sc_hd__inv_1
Xmapped12837 n158 VSS VSS VDD VDD n169 sky130_fd_sc_hd__inv_1
Xmapped12838 n168 VSS VSS VDD VDD n170 sky130_fd_sc_hd__inv_1
Xmapped12839 n170 VSS VSS VDD VDD n171 sky130_fd_sc_hd__inv_1
Xmapped12840 n171 VSS VSS VDD VDD n172 sky130_fd_sc_hd__inv_1
Xmapped12841 n172 VSS VSS VDD VDD n173 sky130_fd_sc_hd__inv_1
Xmapped12842 n173 VSS VSS VDD VDD n174 sky130_fd_sc_hd__inv_1
Xmapped12843 n174 VSS VSS VDD VDD n175 sky130_fd_sc_hd__inv_1
Xmapped12844 n175 VSS VSS VDD VDD n176 sky130_fd_sc_hd__inv_1
Xmapped12845 n176 VSS VSS VDD VDD n177 sky130_fd_sc_hd__inv_1
Xmapped12846 n177 VSS VSS VDD VDD n178 sky130_fd_sc_hd__inv_1
Xmapped12847 n178 VSS VSS VDD VDD n179 sky130_fd_sc_hd__inv_1
Xmapped12848 n169 VSS VSS VDD VDD n180 sky130_fd_sc_hd__inv_1
Xmapped12849 n180 VSS VSS VDD VDD n181 sky130_fd_sc_hd__inv_1
Xmapped12850 n181 VSS VSS VDD VDD n104 sky130_fd_sc_hd__inv_1
Xmapped12851 n81 n182 VSS VSS VDD VDD n95 sky130_fd_sc_hd__and2_4
Xmapped12852 n183 n179 VSS VSS VDD VDD n182 sky130_fd_sc_hd__or2_1
Xmapped12853 n82 n94 VSS VSS VDD VDD n96 sky130_fd_sc_hd__and2_1
Xmapped12854 n83 n94 VSS VSS VDD VDD n97 sky130_fd_sc_hd__and2_1
Xmapped12855 n84 n94 VSS VSS VDD VDD n98 sky130_fd_sc_hd__and2_1
Xmapped12856 n85 n94 VSS VSS VDD VDD n99 sky130_fd_sc_hd__and2_1
Xmapped12857 n72 n119 VSS VSS VDD VDD n183 sky130_fd_sc_hd__and2_1
Xmapped12858 n19 n179 VSS VSS VDD VDD n100 sky130_fd_sc_hd__and2_4
Xmapped12859 n77 n16 n136 VSS VSS VDD VDD n101 sky130_fd_sc_hd__and3_4
.ends sram_4x8_wrapper

.model sky130_fd_pr__nfet_01v8 nmos
.model sky130_fd_pr__pfet_01v8 pmos
.model sky130_fd_pr__pfet_01v8_hvt pmos
.model sky130_fd_pr__special_nfet_01v8 nmos
.subckt bitcell_6t VDD BL BLB VSS WL
MMPL Q QB VDD VDD sky130_fd_pr__pfet_01v8 w=0.42u l=0.15u
MMNL Q QB VSS VSS sky130_fd_pr__nfet_01v8 w=1.26u l=0.15u
MMPR QB Q VDD VDD sky130_fd_pr__pfet_01v8 w=0.42u l=0.15u
MMNR QB Q VSS VSS sky130_fd_pr__nfet_01v8 w=1.26u l=0.15u
MMAL Q WL BL VSS sky130_fd_pr__nfet_01v8 w=0.6u l=0.15u
MMAR BLB WL QB VSS sky130_fd_pr__nfet_01v8 w=0.6u l=0.15u
.ends bitcell_6t

.model sky130_fd_pr__nfet_01v8 nmos
.model sky130_fd_pr__pfet_01v8 pmos
.model sky130_fd_pr__pfet_01v8_hvt pmos
.model sky130_fd_pr__special_nfet_01v8 nmos
.subckt sense_amp VDD VSS BL BLB SCLK SA_OUT SA_OUTB
MMP1 SA_OUT SA_OUTB VDD VDD sky130_fd_pr__pfet_01v8 w=1.89u l=0.15u
MMN1 SA_OUT SA_OUTB NTAIL VSS sky130_fd_pr__nfet_01v8 w=0.975u l=0.15u
MMP2 SA_OUTB SA_OUT VDD VDD sky130_fd_pr__pfet_01v8 w=1.89u l=0.15u
MMN2 SA_OUTB SA_OUT NTAIL VSS sky130_fd_pr__nfet_01v8 w=0.975u l=0.15u
MMSAMPBL BL SCLK SA_OUT VDD sky130_fd_pr__pfet_01v8 w=2u l=0.15u
MMSAMPBLB SA_OUTB SCLK BLB VDD sky130_fd_pr__pfet_01v8 w=2u l=0.15u
MMTAIL NTAIL SCLK VSS VSS sky130_fd_pr__nfet_01v8 w=0.975u l=0.15u
.ends sense_amp

.model sky130_fd_pr__nfet_01v8 nmos
.model sky130_fd_pr__pfet_01v8 pmos
.model sky130_fd_pr__pfet_01v8_hvt pmos
.model sky130_fd_pr__special_nfet_01v8 nmos
.subckt precharge VDD BL BLB PRECH VSS
MMPBL BL PRECH VDD VDD sky130_fd_pr__pfet_01v8 w=2.52u l=0.15u
MMPBLB BLB PRECH VDD VDD sky130_fd_pr__pfet_01v8 w=2.52u l=0.15u
MMEQ BL PRECH BLB VDD sky130_fd_pr__pfet_01v8 w=2.52u l=0.15u
.ends precharge

.model sky130_fd_pr__nfet_01v8 nmos
.model sky130_fd_pr__pfet_01v8 pmos
.model sky130_fd_pr__pfet_01v8_hvt pmos
.model sky130_fd_pr__special_nfet_01v8 nmos
.subckt wl_driver VDD VSS WL_IN WL
MMP1 WL_N WL_IN VDD VDD sky130_fd_pr__pfet_01v8 w=1.68u l=0.15u
MMN1 WL_N WL_IN VSS VSS sky130_fd_pr__nfet_01v8 w=1.68u l=0.15u
MMP2 WL WL_N VDD VDD sky130_fd_pr__pfet_01v8 w=5.04u l=0.15u
MMN2 WL WL_N VSS VSS sky130_fd_pr__nfet_01v8 w=5.04u l=0.15u
.ends wl_driver

.model sky130_fd_pr__nfet_01v8 nmos
.model sky130_fd_pr__pfet_01v8 pmos
.model sky130_fd_pr__pfet_01v8_hvt pmos
.model sky130_fd_pr__special_nfet_01v8 nmos
.subckt write_driver DATA DATA_B WE BL BLB VDD VSS
MMPWEB WE_B WE VDD VDD sky130_fd_pr__pfet_01v8 w=0.84u l=0.15u
MMNWEB WE_B WE VSS VSS sky130_fd_pr__nfet_01v8 w=0.84u l=0.15u
MMPENBL net1 WE_B VDD VDD sky130_fd_pr__pfet_01v8 w=5.04u l=0.15u
MMPDBL BL DATA_B net1 VDD sky130_fd_pr__pfet_01v8 w=5.04u l=0.15u
MMNDBL BL DATA_B net2 VSS sky130_fd_pr__nfet_01v8 w=5.04u l=0.15u
MMNENBL net2 WE VSS VSS sky130_fd_pr__nfet_01v8 w=5.04u l=0.15u
MMPENBLB net3 WE_B VDD VDD sky130_fd_pr__pfet_01v8 w=5.04u l=0.15u
MMPDBLB BLB DATA net3 VDD sky130_fd_pr__pfet_01v8 w=5.04u l=0.15u
MMNDBLB BLB DATA net4 VSS sky130_fd_pr__nfet_01v8 w=5.04u l=0.15u
MMNENBLB net4 WE VSS VSS sky130_fd_pr__nfet_01v8 w=5.04u l=0.15u
.ends write_driver

.model sky130_fd_pr__nfet_01v8 nmos
.model sky130_fd_pr__pfet_01v8 pmos
.model sky130_fd_pr__pfet_01v8_hvt pmos
.model sky130_fd_pr__special_nfet_01v8 nmos
.subckt row_decoder VDD PCLK A0 A1 DEC0 DEC1 DEC3 DEC2 VSS
MM1 A0B A0 VDD VDD sky130_fd_pr__pfet_01v8 w=0.84u l=0.15u
MM2 A0B A0 VSS VSS sky130_fd_pr__nfet_01v8 w=0.84u l=0.15u
MM3 A1B A1 VDD VDD sky130_fd_pr__pfet_01v8 w=0.84u l=0.15u
MM4 A1B A1 VSS VSS sky130_fd_pr__nfet_01v8 w=0.84u l=0.15u
MM5 N0 PCLK VDD VDD sky130_fd_pr__pfet_01v8 w=1.25u l=0.15u
MM6 N0 A1B net1 VSS sky130_fd_pr__nfet_01v8 w=2u l=0.15u
MM7 net1 A0B EVAL_GND VSS sky130_fd_pr__nfet_01v8 w=2u l=0.15u
MM8 EVAL_GND PCLK VSS VSS sky130_fd_pr__nfet_01v8 w=1.5u l=0.15u
MM9 DEC0 N0 VDD VDD sky130_fd_pr__pfet_01v8 w=3u l=0.15u
MM10 DEC0 N0 VSS VSS sky130_fd_pr__nfet_01v8 w=2u l=0.15u
MM11 N1 PCLK VDD VDD sky130_fd_pr__pfet_01v8 w=1.25u l=0.15u
MM12 N1 A1B net2 VSS sky130_fd_pr__nfet_01v8 w=2u l=0.15u
MM13 net2 A0T EVAL_GND VSS sky130_fd_pr__nfet_01v8 w=2u l=0.15u
MM14 DEC1 N1 VDD VDD sky130_fd_pr__pfet_01v8 w=3u l=0.15u
MM15 DEC1 N1 VSS VSS sky130_fd_pr__nfet_01v8 w=2u l=0.15u
MM16 N2 PCLK VDD VDD sky130_fd_pr__pfet_01v8 w=1.25u l=0.15u
MM17 N2 A1T net3 VSS sky130_fd_pr__nfet_01v8 w=2u l=0.15u
MM18 net3 A0B EVAL_GND VSS sky130_fd_pr__nfet_01v8 w=2u l=0.15u
MM19 DEC2 N2 VDD VDD sky130_fd_pr__pfet_01v8 w=3u l=0.15u
MM20 DEC2 N2 VSS VSS sky130_fd_pr__nfet_01v8 w=2u l=0.15u
MM21 N3 PCLK VDD VDD sky130_fd_pr__pfet_01v8 w=1.25u l=0.15u
MM22 N3 A1T net4 VSS sky130_fd_pr__nfet_01v8 w=2u l=0.15u
MM23 net4 A0T EVAL_GND VSS sky130_fd_pr__nfet_01v8 w=2u l=0.15u
MM24 DEC3 N3 VDD VDD sky130_fd_pr__pfet_01v8 w=3u l=0.15u
MM25 DEC3 N3 VSS VSS sky130_fd_pr__nfet_01v8 w=2u l=0.15u
MM26 A0T A0B VDD VDD sky130_fd_pr__pfet_01v8 w=2u l=0.15u
MM27 A0T A0B VSS VSS sky130_fd_pr__nfet_01v8 w=2u l=0.15u
MM28 A1T A1B VDD VDD sky130_fd_pr__pfet_01v8 w=2u l=0.15u
MM29 A1T A1B VSS VSS sky130_fd_pr__nfet_01v8 w=2u l=0.15u
MM30 N0 DEC0 VDD VDD sky130_fd_pr__pfet_01v8 w=0.84u l=0.15u
MM31 N1 DEC1 VDD VDD sky130_fd_pr__pfet_01v8 w=0.84u l=0.15u
MM32 N2 DEC2 VDD VDD sky130_fd_pr__pfet_01v8 w=0.84u l=0.15u
MM33 N3 DEC3 VDD VDD sky130_fd_pr__pfet_01v8 w=0.84u l=0.15u
.ends row_decoder

.subckt leaf_fabric VDD VSS A0 A1 PCLK PRECH SCLK WE DIN0 DIN1 DIN2 DIN3 DIN4 DIN5 DIN6 DIN7 DIN_B0 DIN_B1 DIN_B2 DIN_B3 DIN_B4 DIN_B5 DIN_B6 DIN_B7 DOUT0 DOUT1 DOUT2 DOUT3 DOUT4 DOUT5 DOUT6 DOUT7 ROW0 ROW1 ROW2 ROW3 DEC0 DEC1 DEC2 DEC3
Xbit_r0_b0 VDD BL0 BLB0 VSS WL0 bitcell_6t
Xbit_r0_b1 VDD BL1 BLB1 VSS WL0 bitcell_6t
Xbit_r0_b2 VDD BL2 BLB2 VSS WL0 bitcell_6t
Xbit_r0_b3 VDD BL3 BLB3 VSS WL0 bitcell_6t
Xbit_r0_b4 VDD BL4 BLB4 VSS WL0 bitcell_6t
Xbit_r0_b5 VDD BL5 BLB5 VSS WL0 bitcell_6t
Xbit_r0_b6 VDD BL6 BLB6 VSS WL0 bitcell_6t
Xbit_r0_b7 VDD BL7 BLB7 VSS WL0 bitcell_6t
Xbit_r1_b0 VDD BL0 BLB0 VSS WL1 bitcell_6t
Xbit_r1_b1 VDD BL1 BLB1 VSS WL1 bitcell_6t
Xbit_r1_b2 VDD BL2 BLB2 VSS WL1 bitcell_6t
Xbit_r1_b3 VDD BL3 BLB3 VSS WL1 bitcell_6t
Xbit_r1_b4 VDD BL4 BLB4 VSS WL1 bitcell_6t
Xbit_r1_b5 VDD BL5 BLB5 VSS WL1 bitcell_6t
Xbit_r1_b6 VDD BL6 BLB6 VSS WL1 bitcell_6t
Xbit_r1_b7 VDD BL7 BLB7 VSS WL1 bitcell_6t
Xbit_r2_b0 VDD BL0 BLB0 VSS WL2 bitcell_6t
Xbit_r2_b1 VDD BL1 BLB1 VSS WL2 bitcell_6t
Xbit_r2_b2 VDD BL2 BLB2 VSS WL2 bitcell_6t
Xbit_r2_b3 VDD BL3 BLB3 VSS WL2 bitcell_6t
Xbit_r2_b4 VDD BL4 BLB4 VSS WL2 bitcell_6t
Xbit_r2_b5 VDD BL5 BLB5 VSS WL2 bitcell_6t
Xbit_r2_b6 VDD BL6 BLB6 VSS WL2 bitcell_6t
Xbit_r2_b7 VDD BL7 BLB7 VSS WL2 bitcell_6t
Xbit_r3_b0 VDD BL0 BLB0 VSS WL3 bitcell_6t
Xbit_r3_b1 VDD BL1 BLB1 VSS WL3 bitcell_6t
Xbit_r3_b2 VDD BL2 BLB2 VSS WL3 bitcell_6t
Xbit_r3_b3 VDD BL3 BLB3 VSS WL3 bitcell_6t
Xbit_r3_b4 VDD BL4 BLB4 VSS WL3 bitcell_6t
Xbit_r3_b5 VDD BL5 BLB5 VSS WL3 bitcell_6t
Xbit_r3_b6 VDD BL6 BLB6 VSS WL3 bitcell_6t
Xbit_r3_b7 VDD BL7 BLB7 VSS WL3 bitcell_6t
Xdecode VDD PCLK A0 A1 DEC0 DEC1 DEC3 DEC2 VSS row_decoder
Xdrive0 VDD VSS ROW0 WL0 wl_driver
Xdrive1 VDD VSS ROW1 WL1 wl_driver
Xdrive2 VDD VSS ROW2 WL2 wl_driver
Xdrive3 VDD VSS ROW3 WL3 wl_driver
Xprecharge0 VDD BL0 BLB0 PRECH VSS precharge
Xwrite0 DIN0 DIN_B0 WE BL0 BLB0 VDD VSS write_driver
Xsense0 VDD VSS BL0 BLB0 SCLK DOUT0 DOUT_B0 sense_amp
Xprecharge1 VDD BL1 BLB1 PRECH VSS precharge
Xwrite1 DIN1 DIN_B1 WE BL1 BLB1 VDD VSS write_driver
Xsense1 VDD VSS BL1 BLB1 SCLK DOUT1 DOUT_B1 sense_amp
Xprecharge2 VDD BL2 BLB2 PRECH VSS precharge
Xwrite2 DIN2 DIN_B2 WE BL2 BLB2 VDD VSS write_driver
Xsense2 VDD VSS BL2 BLB2 SCLK DOUT2 DOUT_B2 sense_amp
Xprecharge3 VDD BL3 BLB3 PRECH VSS precharge
Xwrite3 DIN3 DIN_B3 WE BL3 BLB3 VDD VSS write_driver
Xsense3 VDD VSS BL3 BLB3 SCLK DOUT3 DOUT_B3 sense_amp
Xprecharge4 VDD BL4 BLB4 PRECH VSS precharge
Xwrite4 DIN4 DIN_B4 WE BL4 BLB4 VDD VSS write_driver
Xsense4 VDD VSS BL4 BLB4 SCLK DOUT4 DOUT_B4 sense_amp
Xprecharge5 VDD BL5 BLB5 PRECH VSS precharge
Xwrite5 DIN5 DIN_B5 WE BL5 BLB5 VDD VSS write_driver
Xsense5 VDD VSS BL5 BLB5 SCLK DOUT5 DOUT_B5 sense_amp
Xprecharge6 VDD BL6 BLB6 PRECH VSS precharge
Xwrite6 DIN6 DIN_B6 WE BL6 BLB6 VDD VSS write_driver
Xsense6 VDD VSS BL6 BLB6 SCLK DOUT6 DOUT_B6 sense_amp
Xprecharge7 VDD BL7 BLB7 PRECH VSS precharge
Xwrite7 DIN7 DIN_B7 WE BL7 BLB7 VDD VSS write_driver
Xsense7 VDD VSS BL7 BLB7 SCLK DOUT7 DOUT_B7 sense_amp
.ends leaf_fabric
