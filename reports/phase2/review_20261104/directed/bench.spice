* Mapped synchronous SRAM with real HD control and all 32 bitcells
.lib "/opt/pdks/sky130A/libs.tech/ngspice/sky130.lib.spice" tt
.include "binding.spice"
.include "fabric.spice"
.temp 27
.options method=gear reltol=1e-4 vabstol=1e-8 iabstol=1e-12
VSS_SRC VSS 0 0
VDD_SRC VDD 0 PWL(0 0 1n 1.8)
.model HOST_SWITCH sw ron=1 roff=1e12 vt=.9 vh=.1
.model HOST_WEAK_SWITCH sw ron=1k roff=1e12 vt=.9 vh=.1
.options klu
V_CLK CLK 0 PWL(0n 0 10n 0 10.05n 1.8 20n 1.8 20.05n 0 30n 0 30.05n 1.8 40n 1.8 40.05n 0 50n 0 50.05n 1.8 60n 1.8 60.05n 0 70n 0 70.05n 1.8 80n 1.8 80.05n 0 90n 0 90.05n 1.8 100n 1.8 100.05n 0 110n 0 110.05n 1.8 120n 1.8 120.05n 0 130n 0 130.05n 1.8 140n 1.8 140.05n 0 150n 0 150.05n 1.8 160n 1.8 160.05n 0 170n 0 170.05n 1.8 180n 1.8 180.05n 0 190n 0 190.05n 1.8 200n 1.8 200.05n 0 210n 0 210.05n 1.8 220n 1.8 220.05n 0 230n 0 230.05n 1.8 240n 1.8 240.05n 0 250n 0 250.05n 1.8 260n 1.8 260.05n 0 270n 0 270.05n 1.8 280n 1.8 280.05n 0 290n 0 290.05n 1.8 300n 1.8 300.05n 0 310n 0 310.05n 1.8 320n 1.8 320.05n 0 330n 0 330.05n 1.8 340n 1.8 340.05n 0 350n 0 350.05n 1.8 360n 1.8 360.05n 0 370n 0 370.05n 1.8 380n 1.8 380.05n 0 390n 0 390.05n 1.8 400n 1.8 400.05n 0 410n 0 410.05n 1.8 420n 1.8 420.05n 0 430n 0 430.05n 1.8 440n 1.8 440.05n 0 450n 0 450.05n 1.8 460n 1.8 460.05n 0 470n 0 470.05n 1.8 480n 1.8 480.05n 0 490n 0 490.05n 1.8 500n 1.8 500.05n 0 510n 0 510.05n 1.8 520n 1.8 520.05n 0 530n 0 530.05n 1.8 540n 1.8 540.05n 0 550n 0 550.05n 1.8 560n 1.8 560.05n 0 570n 0 570.05n 1.8 580n 1.8 580.05n 0 590n 0 590.05n 1.8 600n 1.8 600.05n 0 610n 0 610.05n 1.8 620n 1.8 620.05n 0 630n 0 630.05n 1.8 640n 1.8 640.05n 0 650n 0 650.05n 1.8 660n 1.8 660.05n 0 670n 0 670.05n 1.8 680n 1.8 680.05n 0 690n 0 690.05n 1.8 700n 1.8 700.05n 0 710n 0 710.05n 1.8 720n 1.8 720.05n 0 730n 0 730.05n 1.8 740n 1.8 740.05n 0 750n 0 750.05n 1.8 760n 1.8 760.05n 0 770n 0 770.05n 1.8 780n 1.8 780.05n 0 790n 0 790.05n 1.8 800n 1.8 800.05n 0 810n 0 810.05n 1.8 820n 1.8 820.05n 0)
V_CSb CSb 0 PWL(0n 0 1n 1.8 7n 1.8 7.05n 1.8 27n 1.8 27.05n 1.8 47n 1.8 47.05n 0 67n 0 67.05n 0 74n 0 74.05n 1.8 87n 1.8 87.05n 0 94n 0 94.05n 1.8 101n 1.8 101.05n 0 107n 0 107.05n 0 114n 0 114.05n 1.8 127n 1.8 127.05n 0 134n 0 134.05n 1.8 141n 1.8 141.05n 0 147n 0 147.05n 0 154n 0 154.05n 1.8 167n 1.8 167.05n 0 174n 0 174.05n 1.8 181n 1.8 181.05n 0 187n 0 187.05n 0 194n 0 194.05n 1.8 207n 1.8 207.05n 0 214n 0 214.05n 1.8 221n 1.8 221.05n 0 227n 0 227.05n 0 234n 0 234.05n 1.8 247n 1.8 247.05n 0 254n 0 254.05n 1.8 261n 1.8 261.05n 0 267n 0 267.05n 0 274n 0 274.05n 1.8 287n 1.8 287.05n 0 294n 0 294.05n 1.8 301n 1.8 301.05n 0 307n 0 307.05n 0 314n 0 314.05n 1.8 327n 1.8 327.05n 0 334n 0 334.05n 1.8 341n 1.8 341.05n 0 347n 0 347.05n 0 354n 0 354.05n 1.8 367n 1.8 367.05n 0 374n 0 374.05n 1.8 381n 1.8 381.05n 0 387n 0 387.05n 0 394n 0 394.05n 1.8 407n 1.8 407.05n 0 414n 0 414.05n 1.8 421n 1.8 421.05n 0 427n 0 427.05n 0 434n 0 434.05n 1.8 447n 1.8 447.05n 0 454n 0 454.05n 1.8 461n 1.8 461.05n 0 467n 0 467.05n 0 474n 0 474.05n 1.8 487n 1.8 487.05n 0 494n 0 494.05n 1.8 501n 1.8 501.05n 0 507n 0 507.05n 0 514n 0 514.05n 1.8 527n 1.8 527.05n 0 534n 0 534.05n 1.8 541n 1.8 541.05n 0 547n 0 547.05n 0 554n 0 554.05n 1.8 567n 1.8 567.05n 0 574n 0 574.05n 1.8 581n 1.8 581.05n 0 587n 0 587.05n 0 594n 0 594.05n 1.8 607n 1.8 607.05n 0 614n 0 614.05n 1.8 621n 1.8 621.05n 0 627n 0 627.05n 0 634n 0 634.05n 1.8 647n 1.8 647.05n 0 654n 0 654.05n 1.8 661n 1.8 661.05n 0 667n 0 667.05n 0 674n 0 674.05n 1.8 687n 1.8 687.05n 0 694n 0 694.05n 1.8 701n 1.8 701.05n 0 707n 0 707.05n 1.8 727n 1.8 727.05n 1.8 747n 1.8 747.05n 0 754n 0 754.05n 1.8 761n 1.8 761.05n 0 767n 0 767.05n 0 774n 0 774.05n 1.8 781n 1.8 781.05n 0 787n 0 787.05n 0 794n 0 794.05n 1.8 801n 1.8 801.05n 0 807n 0 807.05n 0 814n 0 814.05n 1.8 821n 1.8 821.05n 0)
V_OEb OEb 0 PWL(0n 0 1n 1.8 7n 1.8 7.05n 1.8 27n 1.8 27.05n 1.8 47n 1.8 47.05n 0 67n 0 67.05n 1.8 74n 1.8 74.05n 1.8 87n 1.8 87.05n 0 94n 0 94.05n 1.8 101n 1.8 101.05n 0 107n 0 107.05n 1.8 114n 1.8 114.05n 1.8 127n 1.8 127.05n 0 134n 0 134.05n 1.8 141n 1.8 141.05n 0 147n 0 147.05n 1.8 154n 1.8 154.05n 1.8 167n 1.8 167.05n 0 174n 0 174.05n 1.8 181n 1.8 181.05n 0 187n 0 187.05n 1.8 194n 1.8 194.05n 1.8 207n 1.8 207.05n 0 214n 0 214.05n 1.8 221n 1.8 221.05n 0 227n 0 227.05n 1.8 234n 1.8 234.05n 1.8 247n 1.8 247.05n 0 254n 0 254.05n 1.8 261n 1.8 261.05n 0 267n 0 267.05n 1.8 274n 1.8 274.05n 1.8 287n 1.8 287.05n 0 294n 0 294.05n 1.8 301n 1.8 301.05n 0 307n 0 307.05n 1.8 314n 1.8 314.05n 1.8 327n 1.8 327.05n 0 334n 0 334.05n 1.8 341n 1.8 341.05n 0 347n 0 347.05n 1.8 354n 1.8 354.05n 1.8 367n 1.8 367.05n 0 374n 0 374.05n 1.8 381n 1.8 381.05n 0 387n 0 387.05n 1.8 394n 1.8 394.05n 1.8 407n 1.8 407.05n 0 414n 0 414.05n 1.8 421n 1.8 421.05n 0 427n 0 427.05n 1.8 434n 1.8 434.05n 1.8 447n 1.8 447.05n 0 454n 0 454.05n 1.8 461n 1.8 461.05n 0 467n 0 467.05n 1.8 474n 1.8 474.05n 1.8 487n 1.8 487.05n 0 494n 0 494.05n 1.8 501n 1.8 501.05n 0 507n 0 507.05n 1.8 514n 1.8 514.05n 1.8 527n 1.8 527.05n 0 534n 0 534.05n 1.8 541n 1.8 541.05n 0 547n 0 547.05n 1.8 554n 1.8 554.05n 1.8 567n 1.8 567.05n 0 574n 0 574.05n 1.8 581n 1.8 581.05n 0 587n 0 587.05n 1.8 594n 1.8 594.05n 1.8 607n 1.8 607.05n 0 614n 0 614.05n 1.8 621n 1.8 621.05n 0 627n 0 627.05n 1.8 634n 1.8 634.05n 1.8 647n 1.8 647.05n 0 654n 0 654.05n 1.8 661n 1.8 661.05n 0 667n 0 667.05n 1.8 674n 1.8 674.05n 1.8 687n 1.8 687.05n 0 694n 0 694.05n 1.8 701n 1.8 701.05n 0 707n 0 707.05n 1.8 727n 1.8 727.05n 1.8 747n 1.8 747.05n 0 754n 0 754.05n 1.8 761n 1.8 761.05n 0 767n 0 767.05n 0 774n 0 774.05n 1.8 781n 1.8 781.05n 0 787n 0 787.05n 0 794n 0 794.05n 1.8 801n 1.8 801.05n 0 807n 0 807.05n 0 814n 0 814.05n 1.8 821n 1.8 821.05n 0)
V_WEb WEb 0 PWL(0n 0 1n 1.8 7n 1.8 7.05n 1.8 27n 1.8 27.05n 1.8 47n 1.8 47.05n 1.8 67n 1.8 67.05n 0 74n 0 74.05n 1.8 87n 1.8 87.05n 1.8 94n 1.8 94.05n 1.8 101n 1.8 101.05n 1.8 107n 1.8 107.05n 0 114n 0 114.05n 1.8 127n 1.8 127.05n 1.8 134n 1.8 134.05n 1.8 141n 1.8 141.05n 1.8 147n 1.8 147.05n 0 154n 0 154.05n 1.8 167n 1.8 167.05n 1.8 174n 1.8 174.05n 1.8 181n 1.8 181.05n 1.8 187n 1.8 187.05n 0 194n 0 194.05n 1.8 207n 1.8 207.05n 1.8 214n 1.8 214.05n 1.8 221n 1.8 221.05n 1.8 227n 1.8 227.05n 0 234n 0 234.05n 1.8 247n 1.8 247.05n 1.8 254n 1.8 254.05n 1.8 261n 1.8 261.05n 1.8 267n 1.8 267.05n 0 274n 0 274.05n 1.8 287n 1.8 287.05n 1.8 294n 1.8 294.05n 1.8 301n 1.8 301.05n 1.8 307n 1.8 307.05n 0 314n 0 314.05n 1.8 327n 1.8 327.05n 1.8 334n 1.8 334.05n 1.8 341n 1.8 341.05n 1.8 347n 1.8 347.05n 0 354n 0 354.05n 1.8 367n 1.8 367.05n 1.8 374n 1.8 374.05n 1.8 381n 1.8 381.05n 1.8 387n 1.8 387.05n 0 394n 0 394.05n 1.8 407n 1.8 407.05n 1.8 414n 1.8 414.05n 1.8 421n 1.8 421.05n 1.8 427n 1.8 427.05n 0 434n 0 434.05n 1.8 447n 1.8 447.05n 1.8 454n 1.8 454.05n 1.8 461n 1.8 461.05n 1.8 467n 1.8 467.05n 0 474n 0 474.05n 1.8 487n 1.8 487.05n 1.8 494n 1.8 494.05n 1.8 501n 1.8 501.05n 1.8 507n 1.8 507.05n 0 514n 0 514.05n 1.8 527n 1.8 527.05n 1.8 534n 1.8 534.05n 1.8 541n 1.8 541.05n 1.8 547n 1.8 547.05n 0 554n 0 554.05n 1.8 567n 1.8 567.05n 1.8 574n 1.8 574.05n 1.8 581n 1.8 581.05n 1.8 587n 1.8 587.05n 0 594n 0 594.05n 1.8 607n 1.8 607.05n 1.8 614n 1.8 614.05n 1.8 621n 1.8 621.05n 1.8 627n 1.8 627.05n 0 634n 0 634.05n 1.8 647n 1.8 647.05n 1.8 654n 1.8 654.05n 1.8 661n 1.8 661.05n 1.8 667n 1.8 667.05n 0 674n 0 674.05n 1.8 687n 1.8 687.05n 1.8 694n 1.8 694.05n 1.8 701n 1.8 701.05n 1.8 707n 1.8 707.05n 1.8 727n 1.8 727.05n 1.8 747n 1.8 747.05n 1.8 754n 1.8 754.05n 1.8 761n 1.8 761.05n 1.8 767n 1.8 767.05n 1.8 774n 1.8 774.05n 1.8 781n 1.8 781.05n 1.8 787n 1.8 787.05n 1.8 794n 1.8 794.05n 1.8 801n 1.8 801.05n 1.8 807n 1.8 807.05n 1.8 814n 1.8 814.05n 1.8 821n 1.8 821.05n 1.8)
V_ADDR0 ADDR0 0 PWL(0n 0 7n 0 7.05n 0 27n 0 27.05n 0 47n 0 47.05n 0 67n 0 67.05n 0 73n 0 73.05n 1.8 87n 1.8 87.05n 0 93n 0 93.05n 1.8 107n 1.8 107.05n 1.8 113n 1.8 113.05n 0 127n 0 127.05n 1.8 133n 1.8 133.05n 0 147n 0 147.05n 0 153n 0 153.05n 1.8 167n 1.8 167.05n 0 173n 0 173.05n 1.8 187n 1.8 187.05n 1.8 193n 1.8 193.05n 0 207n 0 207.05n 1.8 213n 1.8 213.05n 0 227n 0 227.05n 0 233n 0 233.05n 1.8 247n 1.8 247.05n 0 253n 0 253.05n 1.8 267n 1.8 267.05n 1.8 273n 1.8 273.05n 0 287n 0 287.05n 1.8 293n 1.8 293.05n 0 307n 0 307.05n 0 313n 0 313.05n 1.8 327n 1.8 327.05n 0 333n 0 333.05n 1.8 347n 1.8 347.05n 1.8 353n 1.8 353.05n 0 367n 0 367.05n 1.8 373n 1.8 373.05n 0 387n 0 387.05n 0 393n 0 393.05n 1.8 407n 1.8 407.05n 0 413n 0 413.05n 1.8 427n 1.8 427.05n 1.8 433n 1.8 433.05n 0 447n 0 447.05n 1.8 453n 1.8 453.05n 0 467n 0 467.05n 0 473n 0 473.05n 1.8 487n 1.8 487.05n 0 493n 0 493.05n 1.8 507n 1.8 507.05n 1.8 513n 1.8 513.05n 0 527n 0 527.05n 1.8 533n 1.8 533.05n 0 547n 0 547.05n 0 553n 0 553.05n 1.8 567n 1.8 567.05n 0 573n 0 573.05n 1.8 587n 1.8 587.05n 1.8 593n 1.8 593.05n 0 607n 0 607.05n 1.8 613n 1.8 613.05n 0 627n 0 627.05n 0 633n 0 633.05n 1.8 647n 1.8 647.05n 0 653n 0 653.05n 1.8 667n 1.8 667.05n 1.8 673n 1.8 673.05n 0 687n 0 687.05n 1.8 693n 1.8 693.05n 0 707n 0 707.05n 0 727n 0 727.05n 0 747n 0 747.05n 0 753n 0 753.05n 1.8 767n 1.8 767.05n 1.8 773n 1.8 773.05n 0 787n 0 787.05n 0 793n 0 793.05n 1.8 807n 1.8 807.05n 1.8 813n 1.8 813.05n 0)
V_ADDR1 ADDR1 0 PWL(0n 0 7n 0 7.05n 0 27n 0 27.05n 0 47n 0 47.05n 0 67n 0 67.05n 0 73n 0 73.05n 1.8 87n 1.8 87.05n 0 93n 0 93.05n 1.8 107n 1.8 107.05n 0 113n 0 113.05n 1.8 127n 1.8 127.05n 0 133n 0 133.05n 1.8 147n 1.8 147.05n 1.8 153n 1.8 153.05n 0 167n 0 167.05n 1.8 173n 1.8 173.05n 0 187n 0 187.05n 1.8 193n 1.8 193.05n 0 207n 0 207.05n 1.8 213n 1.8 213.05n 0 227n 0 227.05n 0 233n 0 233.05n 1.8 247n 1.8 247.05n 0 253n 0 253.05n 1.8 267n 1.8 267.05n 0 273n 0 273.05n 1.8 287n 1.8 287.05n 0 293n 0 293.05n 1.8 307n 1.8 307.05n 1.8 313n 1.8 313.05n 0 327n 0 327.05n 1.8 333n 1.8 333.05n 0 347n 0 347.05n 1.8 353n 1.8 353.05n 0 367n 0 367.05n 1.8 373n 1.8 373.05n 0 387n 0 387.05n 0 393n 0 393.05n 1.8 407n 1.8 407.05n 0 413n 0 413.05n 1.8 427n 1.8 427.05n 0 433n 0 433.05n 1.8 447n 1.8 447.05n 0 453n 0 453.05n 1.8 467n 1.8 467.05n 1.8 473n 1.8 473.05n 0 487n 0 487.05n 1.8 493n 1.8 493.05n 0 507n 0 507.05n 1.8 513n 1.8 513.05n 0 527n 0 527.05n 1.8 533n 1.8 533.05n 0 547n 0 547.05n 0 553n 0 553.05n 1.8 567n 1.8 567.05n 0 573n 0 573.05n 1.8 587n 1.8 587.05n 0 593n 0 593.05n 1.8 607n 1.8 607.05n 0 613n 0 613.05n 1.8 627n 1.8 627.05n 1.8 633n 1.8 633.05n 0 647n 0 647.05n 1.8 653n 1.8 653.05n 0 667n 0 667.05n 1.8 673n 1.8 673.05n 0 687n 0 687.05n 1.8 693n 1.8 693.05n 0 707n 0 707.05n 0 727n 0 727.05n 0 747n 0 747.05n 0 753n 0 753.05n 1.8 767n 1.8 767.05n 0 773n 0 773.05n 1.8 787n 1.8 787.05n 1.8 793n 1.8 793.05n 0 807n 0 807.05n 1.8 813n 1.8 813.05n 0)
V_HOST_EN HOST_EN 0 PWL(0n 0 8n 0 8.05n 0 16n 0 16.05n 0 28n 0 28.05n 0 36n 0 36.05n 0 48n 0 48.05n 0 56n 0 56.05n 0 68n 0 68.05n 1.8 76n 1.8 76.05n 0 88n 0 88.05n 0 96n 0 96.05n 0 108n 0 108.05n 1.8 116n 1.8 116.05n 0 128n 0 128.05n 0 136n 0 136.05n 0 148n 0 148.05n 1.8 156n 1.8 156.05n 0 168n 0 168.05n 0 176n 0 176.05n 0 188n 0 188.05n 1.8 196n 1.8 196.05n 0 208n 0 208.05n 0 216n 0 216.05n 0 228n 0 228.05n 1.8 236n 1.8 236.05n 0 248n 0 248.05n 0 256n 0 256.05n 0 268n 0 268.05n 1.8 276n 1.8 276.05n 0 288n 0 288.05n 0 296n 0 296.05n 0 308n 0 308.05n 1.8 316n 1.8 316.05n 0 328n 0 328.05n 0 336n 0 336.05n 0 348n 0 348.05n 1.8 356n 1.8 356.05n 0 368n 0 368.05n 0 376n 0 376.05n 0 388n 0 388.05n 1.8 396n 1.8 396.05n 0 408n 0 408.05n 0 416n 0 416.05n 0 428n 0 428.05n 1.8 436n 1.8 436.05n 0 448n 0 448.05n 0 456n 0 456.05n 0 468n 0 468.05n 1.8 476n 1.8 476.05n 0 488n 0 488.05n 0 496n 0 496.05n 0 508n 0 508.05n 1.8 516n 1.8 516.05n 0 528n 0 528.05n 0 536n 0 536.05n 0 548n 0 548.05n 1.8 556n 1.8 556.05n 0 568n 0 568.05n 0 576n 0 576.05n 0 588n 0 588.05n 1.8 596n 1.8 596.05n 0 608n 0 608.05n 0 616n 0 616.05n 0 628n 0 628.05n 1.8 636n 1.8 636.05n 0 648n 0 648.05n 0 656n 0 656.05n 0 668n 0 668.05n 1.8 676n 1.8 676.05n 0 688n 0 688.05n 0 696n 0 696.05n 0 708n 0 708.05n 0 716n 0 716.05n 0 728n 0 728.05n 0 736n 0 736.05n 0 748n 0 748.05n 0 756n 0 756.05n 0 768n 0 768.05n 0 776n 0 776.05n 0 788n 0 788.05n 0 796n 0 796.05n 0 808n 0 808.05n 0 816n 0 816.05n 0)
V_HOST_WEAK_EN HOST_WEAK_EN 0 PWL(0n 0 95n 0 95.05n 1.8 98n 1.8 98.05n 0 135n 0 135.05n 1.8 138n 1.8 138.05n 0 175n 0 175.05n 1.8 178n 1.8 178.05n 0 215n 0 215.05n 1.8 218n 1.8 218.05n 0 255n 0 255.05n 1.8 258n 1.8 258.05n 0 295n 0 295.05n 1.8 298n 1.8 298.05n 0 335n 0 335.05n 1.8 338n 1.8 338.05n 0 375n 0 375.05n 1.8 378n 1.8 378.05n 0 415n 0 415.05n 1.8 418n 1.8 418.05n 0 455n 0 455.05n 1.8 458n 1.8 458.05n 0 495n 0 495.05n 1.8 498n 1.8 498.05n 0 535n 0 535.05n 1.8 538n 1.8 538.05n 0 575n 0 575.05n 1.8 578n 1.8 578.05n 0 615n 0 615.05n 1.8 618n 1.8 618.05n 0 655n 0 655.05n 1.8 658n 1.8 658.05n 0 695n 0 695.05n 1.8 698n 1.8 698.05n 0 755n 0 755.05n 1.8 758n 1.8 758.05n 0 775n 0 775.05n 1.8 778n 1.8 778.05n 0 795n 0 795.05n 1.8 798n 1.8 798.05n 0 815n 0 815.05n 1.8 818n 1.8 818.05n 0)
V_HOST0 HOST0 0 PWL(0n 0 7.5n 0 7.55n 1.8 27.5n 1.8 27.55n 0 47.5n 0 47.55n 1.8 67.5n 1.8 67.55n 1.8 73n 1.8 73.05n 0 87.5n 0 87.55n 1.8 107.5n 1.8 107.55n 0 113n 0 113.05n 1.8 127.5n 1.8 127.55n 1.8 147.5n 1.8 147.55n 0 153n 0 153.05n 1.8 167.5n 1.8 167.55n 1.8 187.5n 1.8 187.55n 0 193n 0 193.05n 1.8 207.5n 1.8 207.55n 1.8 227.5n 1.8 227.55n 0 233n 0 233.05n 1.8 247.5n 1.8 247.55n 1.8 267.5n 1.8 267.55n 0 273n 0 273.05n 1.8 287.5n 1.8 287.55n 1.8 307.5n 1.8 307.55n 0 313n 0 313.05n 1.8 327.5n 1.8 327.55n 1.8 347.5n 1.8 347.55n 0 353n 0 353.05n 1.8 367.5n 1.8 367.55n 1.8 387.5n 1.8 387.55n 0 393n 0 393.05n 1.8 407.5n 1.8 407.55n 1.8 427.5n 1.8 427.55n 1.8 433n 1.8 433.05n 0 447.5n 0 447.55n 1.8 467.5n 1.8 467.55n 1.8 473n 1.8 473.05n 0 487.5n 0 487.55n 1.8 507.5n 1.8 507.55n 1.8 513n 1.8 513.05n 0 527.5n 0 527.55n 1.8 547.5n 1.8 547.55n 1.8 553n 1.8 553.05n 0 567.5n 0 567.55n 1.8 587.5n 1.8 587.55n 1.8 593n 1.8 593.05n 0 607.5n 0 607.55n 1.8 627.5n 1.8 627.55n 1.8 633n 1.8 633.05n 0 647.5n 0 647.55n 1.8 667.5n 1.8 667.55n 1.8 673n 1.8 673.05n 0 687.5n 0 687.55n 1.8 707.5n 1.8 707.55n 0 727.5n 0 727.55n 1.8 747.5n 1.8 747.55n 0 767.5n 0 767.55n 1.8 787.5n 1.8 787.55n 0 807.5n 0 807.55n 1.8)
V_HOST1 HOST1 0 PWL(0n 0 7.5n 0 7.55n 0 27.5n 0 27.55n 1.8 47.5n 1.8 47.55n 0 67.5n 0 67.55n 0 73n 0 73.05n 1.8 87.5n 1.8 87.55n 0 107.5n 0 107.55n 1.8 113n 1.8 113.05n 0 127.5n 0 127.55n 0 147.5n 0 147.55n 0 153n 0 153.05n 1.8 167.5n 1.8 167.55n 0 187.5n 0 187.55n 0 193n 0 193.05n 1.8 207.5n 1.8 207.55n 0 227.5n 0 227.55n 0 233n 0 233.05n 1.8 247.5n 1.8 247.55n 0 267.5n 0 267.55n 0 273n 0 273.05n 1.8 287.5n 1.8 287.55n 0 307.5n 0 307.55n 0 313n 0 313.05n 1.8 327.5n 1.8 327.55n 0 347.5n 0 347.55n 0 353n 0 353.05n 1.8 367.5n 1.8 367.55n 0 387.5n 0 387.55n 1.8 393n 1.8 393.05n 0 407.5n 0 407.55n 0 427.5n 0 427.55n 0 433n 0 433.05n 1.8 447.5n 1.8 447.55n 0 467.5n 0 467.55n 1.8 473n 1.8 473.05n 0 487.5n 0 487.55n 0 507.5n 0 507.55n 1.8 513n 1.8 513.05n 0 527.5n 0 527.55n 0 547.5n 0 547.55n 1.8 553n 1.8 553.05n 0 567.5n 0 567.55n 0 587.5n 0 587.55n 1.8 593n 1.8 593.05n 0 607.5n 0 607.55n 0 627.5n 0 627.55n 1.8 633n 1.8 633.05n 0 647.5n 0 647.55n 0 667.5n 0 667.55n 1.8 673n 1.8 673.05n 0 687.5n 0 687.55n 0 707.5n 0 707.55n 1.8 727.5n 1.8 727.55n 0 747.5n 0 747.55n 1.8 767.5n 1.8 767.55n 0 787.5n 0 787.55n 1.8 807.5n 1.8 807.55n 0)
V_HOST2 HOST2 0 PWL(0n 0 7.5n 0 7.55n 0 27.5n 0 27.55n 1.8 47.5n 1.8 47.55n 0 67.5n 0 67.55n 0 73n 0 73.05n 1.8 87.5n 1.8 87.55n 0 107.5n 0 107.55n 0 113n 0 113.05n 1.8 127.5n 1.8 127.55n 0 147.5n 0 147.55n 1.8 153n 1.8 153.05n 0 167.5n 0 167.55n 0 187.5n 0 187.55n 0 193n 0 193.05n 1.8 207.5n 1.8 207.55n 0 227.5n 0 227.55n 0 233n 0 233.05n 1.8 247.5n 1.8 247.55n 0 267.5n 0 267.55n 0 273n 0 273.05n 1.8 287.5n 1.8 287.55n 0 307.5n 0 307.55n 0 313n 0 313.05n 1.8 327.5n 1.8 327.55n 0 347.5n 0 347.55n 0 353n 0 353.05n 1.8 367.5n 1.8 367.55n 0 387.5n 0 387.55n 1.8 393n 1.8 393.05n 0 407.5n 0 407.55n 0 427.5n 0 427.55n 1.8 433n 1.8 433.05n 0 447.5n 0 447.55n 0 467.5n 0 467.55n 0 473n 0 473.05n 1.8 487.5n 1.8 487.55n 0 507.5n 0 507.55n 1.8 513n 1.8 513.05n 0 527.5n 0 527.55n 0 547.5n 0 547.55n 1.8 553n 1.8 553.05n 0 567.5n 0 567.55n 0 587.5n 0 587.55n 1.8 593n 1.8 593.05n 0 607.5n 0 607.55n 0 627.5n 0 627.55n 1.8 633n 1.8 633.05n 0 647.5n 0 647.55n 0 667.5n 0 667.55n 1.8 673n 1.8 673.05n 0 687.5n 0 687.55n 0 707.5n 0 707.55n 1.8 727.5n 1.8 727.55n 0 747.5n 0 747.55n 1.8 767.5n 1.8 767.55n 0 787.5n 0 787.55n 1.8 807.5n 1.8 807.55n 0)
V_HOST3 HOST3 0 PWL(0n 0 7.5n 0 7.55n 1.8 27.5n 1.8 27.55n 0 47.5n 0 47.55n 1.8 67.5n 1.8 67.55n 0 73n 0 73.05n 1.8 87.5n 1.8 87.55n 1.8 107.5n 1.8 107.55n 0 113n 0 113.05n 1.8 127.5n 1.8 127.55n 1.8 147.5n 1.8 147.55n 0 153n 0 153.05n 1.8 167.5n 1.8 167.55n 1.8 187.5n 1.8 187.55n 1.8 193n 1.8 193.05n 0 207.5n 0 207.55n 1.8 227.5n 1.8 227.55n 0 233n 0 233.05n 1.8 247.5n 1.8 247.55n 1.8 267.5n 1.8 267.55n 0 273n 0 273.05n 1.8 287.5n 1.8 287.55n 1.8 307.5n 1.8 307.55n 0 313n 0 313.05n 1.8 327.5n 1.8 327.55n 1.8 347.5n 1.8 347.55n 0 353n 0 353.05n 1.8 367.5n 1.8 367.55n 1.8 387.5n 1.8 387.55n 1.8 393n 1.8 393.05n 0 407.5n 0 407.55n 1.8 427.5n 1.8 427.55n 1.8 433n 1.8 433.05n 0 447.5n 0 447.55n 1.8 467.5n 1.8 467.55n 1.8 473n 1.8 473.05n 0 487.5n 0 487.55n 1.8 507.5n 1.8 507.55n 0 513n 0 513.05n 1.8 527.5n 1.8 527.55n 1.8 547.5n 1.8 547.55n 1.8 553n 1.8 553.05n 0 567.5n 0 567.55n 1.8 587.5n 1.8 587.55n 1.8 593n 1.8 593.05n 0 607.5n 0 607.55n 1.8 627.5n 1.8 627.55n 1.8 633n 1.8 633.05n 0 647.5n 0 647.55n 1.8 667.5n 1.8 667.55n 1.8 673n 1.8 673.05n 0 687.5n 0 687.55n 1.8 707.5n 1.8 707.55n 0 727.5n 0 727.55n 1.8 747.5n 1.8 747.55n 0 767.5n 0 767.55n 1.8 787.5n 1.8 787.55n 0 807.5n 0 807.55n 1.8)
V_HOST4 HOST4 0 PWL(0n 0 7.5n 0 7.55n 0 27.5n 0 27.55n 1.8 47.5n 1.8 47.55n 0 67.5n 0 67.55n 0 73n 0 73.05n 1.8 87.5n 1.8 87.55n 0 107.5n 0 107.55n 0 113n 0 113.05n 1.8 127.5n 1.8 127.55n 0 147.5n 0 147.55n 0 153n 0 153.05n 1.8 167.5n 1.8 167.55n 0 187.5n 0 187.55n 0 193n 0 193.05n 1.8 207.5n 1.8 207.55n 0 227.5n 0 227.55n 1.8 233n 1.8 233.05n 0 247.5n 0 247.55n 0 267.5n 0 267.55n 0 273n 0 273.05n 1.8 287.5n 1.8 287.55n 0 307.5n 0 307.55n 0 313n 0 313.05n 1.8 327.5n 1.8 327.55n 0 347.5n 0 347.55n 0 353n 0 353.05n 1.8 367.5n 1.8 367.55n 0 387.5n 0 387.55n 1.8 393n 1.8 393.05n 0 407.5n 0 407.55n 0 427.5n 0 427.55n 1.8 433n 1.8 433.05n 0 447.5n 0 447.55n 0 467.5n 0 467.55n 1.8 473n 1.8 473.05n 0 487.5n 0 487.55n 0 507.5n 0 507.55n 1.8 513n 1.8 513.05n 0 527.5n 0 527.55n 0 547.5n 0 547.55n 0 553n 0 553.05n 1.8 567.5n 1.8 567.55n 0 587.5n 0 587.55n 1.8 593n 1.8 593.05n 0 607.5n 0 607.55n 0 627.5n 0 627.55n 1.8 633n 1.8 633.05n 0 647.5n 0 647.55n 0 667.5n 0 667.55n 1.8 673n 1.8 673.05n 0 687.5n 0 687.55n 0 707.5n 0 707.55n 1.8 727.5n 1.8 727.55n 0 747.5n 0 747.55n 1.8 767.5n 1.8 767.55n 0 787.5n 0 787.55n 1.8 807.5n 1.8 807.55n 0)
V_HOST5 HOST5 0 PWL(0n 0 7.5n 0 7.55n 1.8 27.5n 1.8 27.55n 0 47.5n 0 47.55n 1.8 67.5n 1.8 67.55n 0 73n 0 73.05n 1.8 87.5n 1.8 87.55n 1.8 107.5n 1.8 107.55n 0 113n 0 113.05n 1.8 127.5n 1.8 127.55n 1.8 147.5n 1.8 147.55n 0 153n 0 153.05n 1.8 167.5n 1.8 167.55n 1.8 187.5n 1.8 187.55n 0 193n 0 193.05n 1.8 207.5n 1.8 207.55n 1.8 227.5n 1.8 227.55n 0 233n 0 233.05n 1.8 247.5n 1.8 247.55n 1.8 267.5n 1.8 267.55n 1.8 273n 1.8 273.05n 0 287.5n 0 287.55n 1.8 307.5n 1.8 307.55n 0 313n 0 313.05n 1.8 327.5n 1.8 327.55n 1.8 347.5n 1.8 347.55n 0 353n 0 353.05n 1.8 367.5n 1.8 367.55n 1.8 387.5n 1.8 387.55n 1.8 393n 1.8 393.05n 0 407.5n 0 407.55n 1.8 427.5n 1.8 427.55n 1.8 433n 1.8 433.05n 0 447.5n 0 447.55n 1.8 467.5n 1.8 467.55n 1.8 473n 1.8 473.05n 0 487.5n 0 487.55n 1.8 507.5n 1.8 507.55n 1.8 513n 1.8 513.05n 0 527.5n 0 527.55n 1.8 547.5n 1.8 547.55n 1.8 553n 1.8 553.05n 0 567.5n 0 567.55n 1.8 587.5n 1.8 587.55n 0 593n 0 593.05n 1.8 607.5n 1.8 607.55n 1.8 627.5n 1.8 627.55n 1.8 633n 1.8 633.05n 0 647.5n 0 647.55n 1.8 667.5n 1.8 667.55n 1.8 673n 1.8 673.05n 0 687.5n 0 687.55n 1.8 707.5n 1.8 707.55n 0 727.5n 0 727.55n 1.8 747.5n 1.8 747.55n 0 767.5n 0 767.55n 1.8 787.5n 1.8 787.55n 0 807.5n 0 807.55n 1.8)
V_HOST6 HOST6 0 PWL(0n 0 7.5n 0 7.55n 1.8 27.5n 1.8 27.55n 0 47.5n 0 47.55n 1.8 67.5n 1.8 67.55n 0 73n 0 73.05n 1.8 87.5n 1.8 87.55n 1.8 107.5n 1.8 107.55n 0 113n 0 113.05n 1.8 127.5n 1.8 127.55n 1.8 147.5n 1.8 147.55n 0 153n 0 153.05n 1.8 167.5n 1.8 167.55n 1.8 187.5n 1.8 187.55n 0 193n 0 193.05n 1.8 207.5n 1.8 207.55n 1.8 227.5n 1.8 227.55n 0 233n 0 233.05n 1.8 247.5n 1.8 247.55n 1.8 267.5n 1.8 267.55n 0 273n 0 273.05n 1.8 287.5n 1.8 287.55n 1.8 307.5n 1.8 307.55n 1.8 313n 1.8 313.05n 0 327.5n 0 327.55n 1.8 347.5n 1.8 347.55n 0 353n 0 353.05n 1.8 367.5n 1.8 367.55n 1.8 387.5n 1.8 387.55n 1.8 393n 1.8 393.05n 0 407.5n 0 407.55n 1.8 427.5n 1.8 427.55n 1.8 433n 1.8 433.05n 0 447.5n 0 447.55n 1.8 467.5n 1.8 467.55n 1.8 473n 1.8 473.05n 0 487.5n 0 487.55n 1.8 507.5n 1.8 507.55n 1.8 513n 1.8 513.05n 0 527.5n 0 527.55n 1.8 547.5n 1.8 547.55n 1.8 553n 1.8 553.05n 0 567.5n 0 567.55n 1.8 587.5n 1.8 587.55n 1.8 593n 1.8 593.05n 0 607.5n 0 607.55n 1.8 627.5n 1.8 627.55n 0 633n 0 633.05n 1.8 647.5n 1.8 647.55n 1.8 667.5n 1.8 667.55n 1.8 673n 1.8 673.05n 0 687.5n 0 687.55n 1.8 707.5n 1.8 707.55n 0 727.5n 0 727.55n 1.8 747.5n 1.8 747.55n 0 767.5n 0 767.55n 1.8 787.5n 1.8 787.55n 0 807.5n 0 807.55n 1.8)
V_HOST7 HOST7 0 PWL(0n 0 7.5n 0 7.55n 0 27.5n 0 27.55n 1.8 47.5n 1.8 47.55n 0 67.5n 0 67.55n 0 73n 0 73.05n 1.8 87.5n 1.8 87.55n 0 107.5n 0 107.55n 0 113n 0 113.05n 1.8 127.5n 1.8 127.55n 0 147.5n 0 147.55n 0 153n 0 153.05n 1.8 167.5n 1.8 167.55n 0 187.5n 0 187.55n 0 193n 0 193.05n 1.8 207.5n 1.8 207.55n 0 227.5n 0 227.55n 0 233n 0 233.05n 1.8 247.5n 1.8 247.55n 0 267.5n 0 267.55n 0 273n 0 273.05n 1.8 287.5n 1.8 287.55n 0 307.5n 0 307.55n 0 313n 0 313.05n 1.8 327.5n 1.8 327.55n 0 347.5n 0 347.55n 1.8 353n 1.8 353.05n 0 367.5n 0 367.55n 0 387.5n 0 387.55n 1.8 393n 1.8 393.05n 0 407.5n 0 407.55n 0 427.5n 0 427.55n 1.8 433n 1.8 433.05n 0 447.5n 0 447.55n 0 467.5n 0 467.55n 1.8 473n 1.8 473.05n 0 487.5n 0 487.55n 0 507.5n 0 507.55n 1.8 513n 1.8 513.05n 0 527.5n 0 527.55n 0 547.5n 0 547.55n 1.8 553n 1.8 553.05n 0 567.5n 0 567.55n 0 587.5n 0 587.55n 1.8 593n 1.8 593.05n 0 607.5n 0 607.55n 0 627.5n 0 627.55n 1.8 633n 1.8 633.05n 0 647.5n 0 647.55n 0 667.5n 0 667.55n 0 673n 0 673.05n 1.8 687.5n 1.8 687.55n 0 707.5n 0 707.55n 1.8 727.5n 1.8 727.55n 0 747.5n 0 747.55n 1.8 767.5n 1.8 767.55n 0 787.5n 0 787.55n 1.8 807.5n 1.8 807.55n 0)
S_HOST0 DATA0 HOST0 HOST_EN 0 HOST_SWITCH
S_WEAK0 DATA0 HOST0 HOST_WEAK_EN 0 HOST_WEAK_SWITCH
S_HOST1 DATA1 HOST1 HOST_EN 0 HOST_SWITCH
S_WEAK1 DATA1 HOST1 HOST_WEAK_EN 0 HOST_WEAK_SWITCH
S_HOST2 DATA2 HOST2 HOST_EN 0 HOST_SWITCH
S_WEAK2 DATA2 HOST2 HOST_WEAK_EN 0 HOST_WEAK_SWITCH
S_HOST3 DATA3 HOST3 HOST_EN 0 HOST_SWITCH
S_WEAK3 DATA3 HOST3 HOST_WEAK_EN 0 HOST_WEAK_SWITCH
S_HOST4 DATA4 HOST4 HOST_EN 0 HOST_SWITCH
S_WEAK4 DATA4 HOST4 HOST_WEAK_EN 0 HOST_WEAK_SWITCH
S_HOST5 DATA5 HOST5 HOST_EN 0 HOST_SWITCH
S_WEAK5 DATA5 HOST5 HOST_WEAK_EN 0 HOST_WEAK_SWITCH
S_HOST6 DATA6 HOST6 HOST_EN 0 HOST_SWITCH
S_WEAK6 DATA6 HOST6 HOST_WEAK_EN 0 HOST_WEAK_SWITCH
S_HOST7 DATA7 HOST7 HOST_EN 0 HOST_SWITCH
S_WEAK7 DATA7 HOST7 HOST_WEAK_EN 0 HOST_WEAK_SWITCH
XDUT ADDR0 ADDR1 CLK CSb DATA0 DATA1 DATA2 DATA3 DATA4 DATA5 DATA6 DATA7 OEb VDD VSS WEb sram_4x8_wrapper
.save v(DATA0) v(DATA1) v(DATA2) v(DATA3) v(DATA4) v(DATA5) v(DATA6) v(DATA7) v(xdut.e635) v(xdut.e717) v(xdut.e728) v(xdut.e729) v(xdut.e606) v(xdut.e607) v(xdut.e608) v(xdut.e609) v(xdut.e26) v(xdut.e25) v(xdut.e24) v(xdut.e23) v(xdut.e22) v(xdut.e21) v(xdut.e20) v(xdut.e19) v(xdut.e69) v(xdut.e16) v(xdut.e50) v(xdut.e51) v(xdut.e52) v(xdut.e636) v(xdut.e53) v(xdut.e54) v(xdut.e55) v(xdut.e56) v(xdut.e57) v(xdut.e59) v(xdut.e60) v(xdut.e61) v(xdut.e62) v(xdut.e63) v(xdut.e64) v(xdut.e65) v(xdut.e610) v(xdut.e611) v(xdut.e28) v(xdut.e612) v(xdut.e613) v(xdut.e30) v(xdut.e614) v(xdut.e615) v(xdut.e32) v(xdut.e616) v(xdut.e617) v(xdut.e34) v(xdut.e618) v(xdut.e619) v(xdut.e36) v(xdut.e620) v(xdut.e621) v(xdut.e38) v(xdut.e622) v(xdut.e623) v(xdut.e40) v(xdut.e624) v(xdut.e625) v(xdut.e42) v(xdut.e68) v(xdut.e70) v(xdut.e58) v(xdut.e72) v(xdut.e73) v(xdut.e74) v(xdut.e75) v(xdut.e76) v(xdut.e77) v(xdut.e78)
.control
set num_threads=1
set noaskquit
set wr_singlescale
set wr_vecnames
tran 10p 830n 0 10p
wrdata waveform.dat v(DATA0) v(DATA1) v(DATA2) v(DATA3) v(DATA4) v(DATA5) v(DATA6) v(DATA7) v(xdut.e635) v(xdut.e717) v(xdut.e728) v(xdut.e729) v(xdut.e606) v(xdut.e607) v(xdut.e608) v(xdut.e609) v(xdut.e26) v(xdut.e25) v(xdut.e24) v(xdut.e23) v(xdut.e22) v(xdut.e21) v(xdut.e20) v(xdut.e19) v(xdut.e69) v(xdut.e16) v(xdut.e50) v(xdut.e51) v(xdut.e52) v(xdut.e636) v(xdut.e53) v(xdut.e54) v(xdut.e55) v(xdut.e56) v(xdut.e57) v(xdut.e59) v(xdut.e60) v(xdut.e61) v(xdut.e62) v(xdut.e63) v(xdut.e64) v(xdut.e65) v(xdut.e610) v(xdut.e611) v(xdut.e28) v(xdut.e612) v(xdut.e613) v(xdut.e30) v(xdut.e614) v(xdut.e615) v(xdut.e32) v(xdut.e616) v(xdut.e617) v(xdut.e34) v(xdut.e618) v(xdut.e619) v(xdut.e36) v(xdut.e620) v(xdut.e621) v(xdut.e38) v(xdut.e622) v(xdut.e623) v(xdut.e40) v(xdut.e624) v(xdut.e625) v(xdut.e42) v(xdut.e68) v(xdut.e70) v(xdut.e58) v(xdut.e72) v(xdut.e73) v(xdut.e74) v(xdut.e75) v(xdut.e76) v(xdut.e77) v(xdut.e78)
quit
.endc
.end
