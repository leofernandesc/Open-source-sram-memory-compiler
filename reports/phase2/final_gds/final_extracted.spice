* NGSPICE file created from final_flat.ext - technology: sky130A

.subckt final_flat ADDR[0] ADDR[1] CLK CSb DATA[0] DATA[1] DATA[2] DATA[3] DATA[4]
+ DATA[5] DATA[6] DATA[7] OEb VDD VSS WEb
X0 a_43167_45886# a_43215_45974# VDD VDD sky130_fd_pr__pfet_01v8 ad=0.1218 pd=1.42 as=0.1218 ps=1.42 w=0.42 l=0.15
X1 VDD macro_core.qualify_row\[0\].qualify.A macro_core.array_and_peripherals.row_decoder_0.N0 VDD sky130_fd_pr__pfet_01v8 ad=0.2436 pd=2.26 as=0.2436 ps=2.26 w=0.84 l=0.15
X2 macro_core.precharge_phase.X a_64836_13353# VDD VDD sky130_fd_pr__pfet_01v8_hvt ad=0.34 pd=2.68 as=0.14575 ps=1.335 w=1 l=0.15
X3 a_79167_55886# a_79215_55974# VSS VSS sky130_fd_pr__nfet_01v8 ad=0.3654 pd=3.1 as=0.3654 ps=3.1 w=1.26 l=0.15
X4 a_79167_40886# a_79215_40974# VSS VSS sky130_fd_pr__nfet_01v8 ad=0.3654 pd=3.1 as=0.3654 ps=3.1 w=1.26 l=0.15
X5 a_73793_12381# a_73259_12015# a_73698_12381# VDD sky130_fd_pr__pfet_01v8_hvt ad=0.07665 pd=0.785 as=0.06825 ps=0.745 w=0.42 l=0.15
X6 VDD a_52779_3677# a_52947_3579# VDD sky130_fd_pr__pfet_01v8_hvt ad=0.135 pd=1.27 as=0.27 ps=2.54 w=1 l=0.15
X7 macro_core.phase_delay\[36\].delay_cell.Y macro_core.phase_delay\[35\].delay_cell.Y VDD VDD sky130_fd_pr__pfet_01v8_hvt ad=0.26 pd=2.52 as=0.26 ps=2.52 w=1 l=0.15
X8 a_70941_13647# a_70407_13653# a_70846_13647# VDD sky130_fd_pr__pfet_01v8_hvt ad=0.07665 pd=0.785 as=0.06825 ps=0.745 w=0.42 l=0.15
X9 VDD _75_.Q a_52007_9839# VDD sky130_fd_pr__pfet_01v8_hvt ad=0.0864 pd=0.91 as=0.1664 ps=1.8 w=0.64 l=0.15
X10 VSS a_75792_14343# _81_.D VSS sky130_fd_pr__nfet_01v8 ad=0.11285 pd=1.045 as=0.169 ps=1.82 w=0.65 l=0.15
X11 VDD a_56202_14303# a_56129_14557# VDD sky130_fd_pr__pfet_01v8_hvt ad=0.17887 pd=1.26 as=0.07665 ps=0.785 w=0.42 l=0.15
X12 a_56651_14013# _47_.A0 a_56288_13879# VSS sky130_fd_pr__nfet_01v8 ad=0.0693 pd=0.75 as=0.09975 ps=0.895 w=0.42 l=0.15
X13 a_77723_13686# DATA[6] a_77264_13879# VDD sky130_fd_pr__pfet_01v8_hvt ad=0.0441 pd=0.63 as=0.1932 ps=1.34 w=0.42 l=0.15
X14 macro_core.phase_delay\[76\].delay_cell.Y macro_core.phase_delay\[75\].delay_cell.Y VDD VDD sky130_fd_pr__pfet_01v8_hvt ad=0.26 pd=2.52 as=0.26 ps=2.52 w=1 l=0.15
X15 a_69040_12015# a_68641_12015# a_68914_12381# VSS sky130_fd_pr__special_nfet_01v8 ad=0.0696 pd=0.765 as=0.0621 ps=0.705 w=0.36 l=0.15
X16 a_75173_10161# _35_.Y VSS VSS sky130_fd_pr__nfet_01v8 ad=0.2583 pd=2.07 as=0.09813 ps=1.005 w=0.42 l=0.15
X17 a_66985_13653# a_66819_13653# VSS VSS sky130_fd_pr__nfet_01v8 ad=0.1092 pd=1.36 as=0.0567 ps=0.69 w=0.42 l=0.15
X18 VDD a_73866_12127# a_73793_12381# VDD sky130_fd_pr__pfet_01v8_hvt ad=0.17887 pd=1.26 as=0.07665 ps=0.785 w=0.42 l=0.15
X19 macro_core.phase_delay\[2\].delay_cell.Y macro_core.phase_delay\[1\].delay_cell.Y VDD VDD sky130_fd_pr__pfet_01v8_hvt ad=0.26 pd=2.52 as=0.26 ps=2.52 w=1 l=0.15
X20 macro_core.phase_delay\[17\].delay_cell.Y macro_core.phase_delay\[16\].delay_cell.Y VSS VSS sky130_fd_pr__nfet_01v8 ad=0.169 pd=1.82 as=0.169 ps=1.82 w=0.65 l=0.15
X21 a_85215_50974# a_85167_50886# VSS VSS sky130_fd_pr__nfet_01v8 ad=0.3654 pd=3.1 as=0.3654 ps=3.1 w=1.26 l=0.15
X22 a_50415_16496# macro_core.data_complement\[1\].complement.Y macro_core.array_and_peripherals.write_driver_1.BL VSS sky130_fd_pr__nfet_01v8 ad=1.4616 pd=10.66 as=1.4616 ps=10.66 w=5.04 l=0.15
X23 macro_core.precharge_drive.X a_63599_14191# VSS VSS sky130_fd_pr__nfet_01v8 ad=0.091 pd=0.93 as=0.13813 ps=1.075 w=0.65 l=0.15
X24 _45_.A0 a_50187_12283# VSS VSS sky130_fd_pr__nfet_01v8 ad=0.169 pd=1.82 as=0.08775 ps=0.92 w=0.65 l=0.15
X25 a_75695_12015# a_75357_12337# VSS VSS sky130_fd_pr__nfet_01v8 ad=0.06825 pd=0.86 as=0.2275 ps=2 w=0.65 l=0.15
X26 _84_.Q a_58559_9269# VDD VDD sky130_fd_pr__pfet_01v8_hvt ad=0.26 pd=2.52 as=0.135 ps=1.27 w=1 l=0.15
X27 a_67167_50886# a_67215_50974# VSS VSS sky130_fd_pr__nfet_01v8 ad=0.3654 pd=3.1 as=0.3654 ps=3.1 w=1.26 l=0.15
X28 macro_core.array_and_peripherals.row_decoder_0.EVAL_GND macro_core.array_and_peripherals.row_decoder_0.A0T macro_core.array_and_peripherals.row_decoder_0.net4 VSS sky130_fd_pr__nfet_01v8 ad=0.58 pd=4.58 as=0.58 ps=4.58 w=2 l=0.15
X29 VSS a_74951_14557# a_75119_14459# VSS sky130_fd_pr__nfet_01v8 ad=0.08775 pd=0.92 as=0.169 ps=1.82 w=0.65 l=0.15
X30 macro_core.phase_delay\[79\].delay_cell.Y macro_core.phase_delay\[78\].delay_cell.Y VDD VDD sky130_fd_pr__pfet_01v8_hvt ad=0.26 pd=2.52 as=0.26 ps=2.52 w=1 l=0.15
X31 macro_core.phase_delay\[35\].delay_cell.Y macro_core.phase_delay\[34\].delay_cell.Y VSS VSS sky130_fd_pr__nfet_01v8 ad=0.169 pd=1.82 as=0.169 ps=1.82 w=0.65 l=0.15
X32 a_67258_13647# a_66819_13653# a_67173_13647# VSS sky130_fd_pr__special_nfet_01v8 ad=0.0621 pd=0.705 as=0.0813 ps=0.83 w=0.36 l=0.15
X33 macro_core.phase_delay\[4\].delay_cell.Y macro_core.phase_delay\[3\].delay_cell.Y VSS VSS sky130_fd_pr__nfet_01v8 ad=0.169 pd=1.82 as=0.169 ps=1.82 w=0.65 l=0.15
X34 _33_.Y _86_.CLK VDD VDD sky130_fd_pr__pfet_01v8_hvt ad=0.1134 pd=1.11 as=0.2184 ps=2.2 w=0.84 l=0.15
X35 VSS macro_core.qualify_row\[0\].qualify.X a_36227_41432# VSS sky130_fd_pr__nfet_01v8 ad=0.4872 pd=3.94 as=0.4872 ps=3.94 w=1.68 l=0.15
X36 a_59993_10383# _56_.Y VDD VDD sky130_fd_pr__pfet_01v8_hvt ad=0.1664 pd=1.8 as=0.0864 ps=0.91 w=0.64 l=0.15
X37 a_76799_9661# _52_.A0 a_76436_9527# VSS sky130_fd_pr__nfet_01v8 ad=0.0693 pd=0.75 as=0.09975 ps=0.895 w=0.42 l=0.15
X38 a_79367_14557# a_78503_14191# a_79110_14303# VDD sky130_fd_pr__pfet_01v8_hvt ad=0.0567 pd=0.69 as=0.1095 ps=1.075 w=0.42 l=0.15
X39 _60_.Y _86_.CLK VDD VDD sky130_fd_pr__pfet_01v8_hvt ad=0.1134 pd=1.11 as=0.2184 ps=2.2 w=0.84 l=0.15
X40 a_79037_14557# a_78503_14191# a_78942_14557# VDD sky130_fd_pr__pfet_01v8_hvt ad=0.07665 pd=0.785 as=0.06825 ps=0.745 w=0.42 l=0.15
X41 VSS macro_core.sense_drive.X a_49615_26902# VSS sky130_fd_pr__nfet_01v8 ad=0.2842 pd=2.54 as=0.2842 ps=2.54 w=0.98 l=0.15
X42 _48_.A0 a_63067_12283# VDD VDD sky130_fd_pr__pfet_01v8_hvt ad=0.26 pd=2.52 as=0.135 ps=1.27 w=1 l=0.15
X43 a_49167_55886# a_49215_55974# VDD VDD sky130_fd_pr__pfet_01v8 ad=0.1218 pd=1.42 as=0.1218 ps=1.42 w=0.42 l=0.15
X44 a_49167_40886# a_49215_40974# VDD VDD sky130_fd_pr__pfet_01v8 ad=0.1218 pd=1.42 as=0.1218 ps=1.42 w=0.42 l=0.15
X45 a_67173_13647# _79_.D VDD VDD sky130_fd_pr__pfet_01v8_hvt ad=0.05775 pd=0.695 as=0.1092 ps=1.36 w=0.42 l=0.15
X46 VSS a_69507_12283# a_69465_12015# VSS sky130_fd_pr__nfet_01v8 ad=0.1092 pd=1.36 as=0.066 ps=0.745 w=0.42 l=0.15
X47 _56_.Y _34_.Y VDD VDD sky130_fd_pr__pfet_01v8_hvt ad=0.135 pd=1.27 as=0.26 ps=2.52 w=1 l=0.15
X48 VDD macro_core.array_and_peripherals.sense_amp_7.SA_OUTB _36_.A1 VDD sky130_fd_pr__pfet_01v8 ad=0.5481 pd=4.36 as=0.5481 ps=4.36 w=1.89 l=0.15
X49 VSS macro_core.write_drive.X a_56415_16496# VSS sky130_fd_pr__nfet_01v8 ad=1.4616 pd=10.66 as=1.4616 ps=10.66 w=5.04 l=0.15
X50 a_68415_16496# macro_core.data_complement\[4\].complement.Y macro_core.array_and_peripherals.write_driver_4.BL VSS sky130_fd_pr__nfet_01v8 ad=1.4616 pd=10.66 as=1.4616 ps=10.66 w=5.04 l=0.15
X51 a_79110_14303# a_78942_14557# VSS VSS sky130_fd_pr__nfet_01v8 ad=0.0989 pd=0.995 as=0.12095 ps=1.085 w=0.64 l=0.15
X52 VSS a_67426_13621# a_67384_14025# VSS sky130_fd_pr__nfet_01v8 ad=0.12095 pd=1.085 as=0.0696 ps=0.765 w=0.42 l=0.15
X53 macro_core.phase_delay\[63\].delay_cell.A macro_core.phase_delay\[62\].delay_cell.A VDD VDD sky130_fd_pr__pfet_01v8_hvt ad=0.26 pd=2.52 as=0.26 ps=2.52 w=1 l=0.15
X54 macro_core.phase_delay\[11\].delay_cell.Y macro_core.phase_delay\[10\].delay_cell.Y VDD VDD sky130_fd_pr__pfet_01v8_hvt ad=0.26 pd=2.52 as=0.26 ps=2.52 w=1 l=0.15
X55 VDD _38_.A1 macro_core.array_and_peripherals.sense_amp_5.SA_OUTB VDD sky130_fd_pr__pfet_01v8 ad=0.5481 pd=4.36 as=0.5481 ps=4.36 w=1.89 l=0.15
X56 a_78942_14557# a_78503_14191# a_78857_14191# VSS sky130_fd_pr__special_nfet_01v8 ad=0.0621 pd=0.705 as=0.0813 ps=0.83 w=0.36 l=0.15
X57 a_62474_12381# a_62035_12015# a_62389_12015# VSS sky130_fd_pr__special_nfet_01v8 ad=0.0621 pd=0.705 as=0.0813 ps=0.83 w=0.36 l=0.15
X58 a_62899_12381# a_62201_12015# a_62642_12127# VSS sky130_fd_pr__special_nfet_01v8 ad=0.0684 pd=0.74 as=0.0989 ps=0.995 w=0.36 l=0.15
X59 macro_core.phase_delay\[72\].delay_cell.Y macro_core.phase_delay\[71\].delay_cell.Y VSS VSS sky130_fd_pr__nfet_01v8 ad=0.169 pd=1.82 as=0.169 ps=1.82 w=0.65 l=0.15
X60 a_59487_14557# a_58705_14191# a_59403_14557# VDD sky130_fd_pr__pfet_01v8_hvt ad=0.0882 pd=0.84 as=0.0567 ps=0.69 w=0.42 l=0.15
X61 macro_core.phase_delay\[61\].delay_cell.A macro_core.phase_delay\[59\].delay_cell.Y VSS VSS sky130_fd_pr__nfet_01v8 ad=0.169 pd=1.82 as=0.169 ps=1.82 w=0.65 l=0.15
X62 _50_.A0 a_74291_12283# VSS VSS sky130_fd_pr__nfet_01v8 ad=0.169 pd=1.82 as=0.08775 ps=0.92 w=0.65 l=0.15
X63 _86_.Q a_50739_3579# VDD VDD sky130_fd_pr__pfet_01v8_hvt ad=0.26 pd=2.52 as=0.135 ps=1.27 w=1 l=0.15
X64 a_53981_2767# a_53911_2999# _34_.Y VDD sky130_fd_pr__pfet_01v8_hvt ad=0.135 pd=1.27 as=0.32 ps=2.64 w=1 l=0.15
X65 macro_core.phase_delay\[19\].delay_cell.Y macro_core.phase_delay\[18\].delay_cell.Y VDD VDD sky130_fd_pr__pfet_01v8_hvt ad=0.26 pd=2.52 as=0.26 ps=2.52 w=1 l=0.15
X66 macro_core.array_and_peripherals.write_driver_1.BLB macro_core.precharge_drive.X macro_core.array_and_peripherals.write_driver_1.BL VDD sky130_fd_pr__pfet_01v8 ad=0.7308 pd=5.62 as=0.7308 ps=5.62 w=2.52 l=0.15
X67 macro_core.array_and_peripherals.row_decoder_0.net3 macro_core.array_and_peripherals.row_decoder_0.A1T macro_core.array_and_peripherals.row_decoder_0.N2 VSS sky130_fd_pr__nfet_01v8 ad=0.58 pd=4.58 as=0.58 ps=4.58 w=2 l=0.15
X68 VDD a_77693_13945# a_77723_13686# VDD sky130_fd_pr__pfet_01v8_hvt ad=0.0693 pd=0.75 as=0.0441 ps=0.63 w=0.42 l=0.15
X69 macro_core.phase_delay\[42\].delay_cell.A macro_core.phase_delay\[41\].delay_cell.A VDD VDD sky130_fd_pr__pfet_01v8_hvt ad=0.26 pd=2.52 as=0.26 ps=2.52 w=1 l=0.15
X70 a_55215_45974# a_55167_45886# VSS VSS sky130_fd_pr__nfet_01v8 ad=0.3654 pd=3.1 as=0.3654 ps=3.1 w=1.26 l=0.15
X71 a_58751_12381# a_57969_12015# a_58667_12381# VDD sky130_fd_pr__pfet_01v8_hvt ad=0.0882 pd=0.84 as=0.0567 ps=0.69 w=0.42 l=0.15
X72 VDD OEb a_54065_2767# VDD sky130_fd_pr__pfet_01v8_hvt ad=0.14575 pd=1.335 as=0.135 ps=1.27 w=1 l=0.15
X73 VDD macro_core.release_phase.X a_64918_13353# VDD sky130_fd_pr__pfet_01v8_hvt ad=0.14575 pd=1.335 as=0.0441 ps=0.63 w=0.42 l=0.15
X74 a_55949_14191# _47_.X VDD VDD sky130_fd_pr__pfet_01v8_hvt ad=0.05775 pd=0.695 as=0.1092 ps=1.36 w=0.42 l=0.15
X75 a_50103_12381# a_49321_12015# a_50019_12381# VDD sky130_fd_pr__pfet_01v8_hvt ad=0.0882 pd=0.84 as=0.0567 ps=0.69 w=0.42 l=0.15
X76 a_49873_3311# a_49707_3311# VDD VDD sky130_fd_pr__pfet_01v8_hvt ad=0.1664 pd=1.8 as=0.0864 ps=0.91 w=0.64 l=0.15
X77 a_73167_45886# macro_core.array_and_peripherals.wl_driver_1.WL macro_core.array_and_peripherals.write_driver_5.BLB VSS sky130_fd_pr__nfet_01v8 ad=0.174 pd=1.78 as=0.174 ps=1.78 w=0.6 l=0.15
X78 a_61615_26902# macro_core.array_and_peripherals.sense_amp_3.SA_OUTB _40_.A1 VSS sky130_fd_pr__nfet_01v8 ad=0.2842 pd=2.54 as=0.2842 ps=2.54 w=0.98 l=0.15
X79 DATA[1] a_51915_12015# a_52419_12015# VSS sky130_fd_pr__nfet_01v8 ad=0.286 pd=2.18 as=0.06825 ps=0.86 w=0.65 l=0.15
X80 DATA[6] a_75191_12015# a_75695_12015# VSS sky130_fd_pr__nfet_01v8 ad=0.286 pd=2.18 as=0.06825 ps=0.86 w=0.65 l=0.15
X81 VSS a_77879_12283# a_77837_12015# VSS sky130_fd_pr__nfet_01v8 ad=0.1092 pd=1.36 as=0.066 ps=0.745 w=0.42 l=0.15
X82 a_77730_9951# a_77562_10205# VDD VDD sky130_fd_pr__pfet_01v8_hvt ad=0.1095 pd=1.075 as=0.17887 ps=1.26 w=0.75 l=0.15
X83 VSS macro_core.sense_drive.X a_67615_26902# VSS sky130_fd_pr__nfet_01v8 ad=0.2842 pd=2.54 as=0.2842 ps=2.54 w=0.98 l=0.15
X84 a_77264_13879# DATA[6] a_77406_14013# VSS sky130_fd_pr__nfet_01v8 ad=0.09975 pd=0.895 as=0.0693 ps=0.75 w=0.42 l=0.15
X85 VSS macro_core.write_drive.X a_70015_16496# VSS sky130_fd_pr__nfet_01v8 ad=1.4616 pd=10.66 as=1.4616 ps=10.66 w=5.04 l=0.15
X86 a_82015_16496# _51_.A0 macro_core.array_and_peripherals.write_driver_6.BLB VSS sky130_fd_pr__nfet_01v8 ad=1.4616 pd=10.66 as=1.4616 ps=10.66 w=5.04 l=0.15
X87 a_67696_14343# _39_.A1 a_67838_14191# VSS sky130_fd_pr__nfet_01v8 ad=0.09975 pd=0.895 as=0.0693 ps=0.75 w=0.42 l=0.15
X88 a_55142_12598# _84_.Q VDD VDD sky130_fd_pr__pfet_01v8_hvt ad=0.07665 pd=0.785 as=0.15835 ps=1.395 w=0.42 l=0.15
X89 a_49509_12015# _45_.X VSS VSS sky130_fd_pr__nfet_01v8 ad=0.0813 pd=0.83 as=0.1092 ps=1.36 w=0.42 l=0.15
X90 VDD a_58134_9269# a_58061_9295# VDD sky130_fd_pr__pfet_01v8_hvt ad=0.17887 pd=1.26 as=0.07665 ps=0.785 w=0.42 l=0.15
X91 a_50399_14518# _42_.A1 a_49940_14343# VDD sky130_fd_pr__pfet_01v8_hvt ad=0.0441 pd=0.63 as=0.1932 ps=1.34 w=0.42 l=0.15
X92 VSS macro_core.array_and_peripherals.row_decoder_0.A1B macro_core.array_and_peripherals.row_decoder_0.A1T VSS sky130_fd_pr__nfet_01v8 ad=0.58 pd=4.58 as=0.58 ps=4.58 w=2 l=0.15
X93 a_43215_55974# a_43167_55886# VSS VSS sky130_fd_pr__nfet_01v8 ad=0.3654 pd=3.1 as=0.3654 ps=3.1 w=1.26 l=0.15
X94 a_43215_40974# a_43167_40886# VSS VSS sky130_fd_pr__nfet_01v8 ad=0.3654 pd=3.1 as=0.3654 ps=3.1 w=1.26 l=0.15
X95 a_71014_13621# a_70846_13647# VSS VSS sky130_fd_pr__nfet_01v8 ad=0.0989 pd=0.995 as=0.12095 ps=1.085 w=0.64 l=0.15
X96 VSS a_77264_13879# _51_.X VSS sky130_fd_pr__nfet_01v8 ad=0.11285 pd=1.045 as=0.169 ps=1.82 w=0.65 l=0.15
X97 VSS a_50019_12381# a_50187_12283# VSS sky130_fd_pr__nfet_01v8 ad=0.08775 pd=0.92 as=0.169 ps=1.82 w=0.65 l=0.15
X98 _66_.Y macro_core.phase_delay\[0\].delay_cell.A VDD VDD sky130_fd_pr__pfet_01v8_hvt ad=0.1134 pd=1.11 as=0.2184 ps=2.2 w=0.84 l=0.15
X99 a_50061_3311# ADDR[1] VDD VDD sky130_fd_pr__pfet_01v8_hvt ad=0.05775 pd=0.695 as=0.1092 ps=1.36 w=0.42 l=0.15
X100 a_79215_40974# macro_core.array_and_peripherals.wl_driver_0.WL macro_core.array_and_peripherals.write_driver_6.BL VSS sky130_fd_pr__nfet_01v8 ad=0.174 pd=1.78 as=0.174 ps=1.78 w=0.6 l=0.15
X101 macro_core.precharge_drive.X a_63599_14191# VDD VDD sky130_fd_pr__pfet_01v8_hvt ad=0.14 pd=1.28 as=0.14 ps=1.28 w=1 l=0.15
X102 VSS a_59508_12791# _78_.D VSS sky130_fd_pr__nfet_01v8 ad=0.11285 pd=1.045 as=0.169 ps=1.82 w=0.65 l=0.15
X103 a_55000_12791# _89_.A a_55142_12598# VDD sky130_fd_pr__pfet_01v8_hvt ad=0.1932 pd=1.34 as=0.07665 ps=0.785 w=0.42 l=0.15
X104 a_58061_9295# a_57527_9301# a_57966_9295# VDD sky130_fd_pr__pfet_01v8_hvt ad=0.07665 pd=0.785 as=0.06825 ps=0.745 w=0.42 l=0.15
X105 a_76865_9593# _44_.Y VSS VSS sky130_fd_pr__nfet_01v8 ad=0.1092 pd=1.36 as=0.1449 ps=1.11 w=0.42 l=0.15
X106 a_79215_55974# macro_core.array_and_peripherals.wl_driver_3.WL macro_core.array_and_peripherals.write_driver_6.BL VSS sky130_fd_pr__nfet_01v8 ad=0.174 pd=1.78 as=0.174 ps=1.78 w=0.6 l=0.15
X107 macro_core.array_and_peripherals.write_driver_4.BLB macro_core.precharge_drive.X macro_core.array_and_peripherals.write_driver_4.BL VDD sky130_fd_pr__pfet_01v8 ad=0.7308 pd=5.62 as=0.7308 ps=5.62 w=2.52 l=0.15
X108 macro_core.phase_delay\[46\].delay_cell.A macro_core.phase_delay\[44\].delay_cell.Y VSS VSS sky130_fd_pr__nfet_01v8 ad=0.169 pd=1.82 as=0.169 ps=1.82 w=0.65 l=0.15
X109 a_61167_55886# macro_core.array_and_peripherals.wl_driver_3.WL macro_core.array_and_peripherals.write_driver_3.BLB VSS sky130_fd_pr__nfet_01v8 ad=0.174 pd=1.78 as=0.174 ps=1.78 w=0.6 l=0.15
X110 a_61167_40886# macro_core.array_and_peripherals.wl_driver_0.WL macro_core.array_and_peripherals.write_driver_3.BLB VSS sky130_fd_pr__nfet_01v8 ad=0.174 pd=1.78 as=0.174 ps=1.78 w=0.6 l=0.15
X111 a_53147_14557# a_52449_14191# a_52890_14303# VSS sky130_fd_pr__special_nfet_01v8 ad=0.0684 pd=0.74 as=0.0989 ps=0.995 w=0.36 l=0.15
X112 _92_.A a_71439_13621# VDD VDD sky130_fd_pr__pfet_01v8_hvt ad=0.26 pd=2.52 as=0.135 ps=1.27 w=1 l=0.15
X113 a_50697_3311# a_49707_3311# a_50571_3677# VSS sky130_fd_pr__special_nfet_01v8 ad=0.066 pd=0.745 as=0.0684 ps=0.74 w=0.36 l=0.15
X114 a_74027_20496# macro_core.data_complement\[5\].complement.Y macro_core.array_and_peripherals.write_driver_5.BL VDD sky130_fd_pr__pfet_01v8 ad=1.4616 pd=10.66 as=1.4616 ps=10.66 w=5.04 l=0.15
X115 _92_.A a_71439_13621# VSS VSS sky130_fd_pr__nfet_01v8 ad=0.169 pd=1.82 as=0.08775 ps=0.92 w=0.65 l=0.15
X116 a_58793_12015# a_57803_12015# a_58667_12381# VSS sky130_fd_pr__special_nfet_01v8 ad=0.066 pd=0.745 as=0.0684 ps=0.74 w=0.36 l=0.15
X117 a_79615_26902# macro_core.array_and_peripherals.sense_amp_6.SA_OUTB _37_.A1 VSS sky130_fd_pr__nfet_01v8 ad=0.2842 pd=2.54 as=0.2842 ps=2.54 w=0.98 l=0.15
X118 a_51627_20496# _46_.A0 macro_core.array_and_peripherals.write_driver_1.BLB VDD sky130_fd_pr__pfet_01v8 ad=1.4616 pd=10.66 as=1.4616 ps=10.66 w=5.04 l=0.15
X119 VDD a_61227_20916# a_63627_20496# VDD sky130_fd_pr__pfet_01v8 ad=1.4616 pd=10.66 as=1.4616 ps=10.66 w=5.04 l=0.15
X120 VDD _90_.A a_59827_10383# VDD sky130_fd_pr__pfet_01v8_hvt ad=0.0864 pd=0.91 as=0.1664 ps=1.8 w=0.64 l=0.15
X121 a_74207_12381# a_73425_12015# a_74123_12381# VDD sky130_fd_pr__pfet_01v8_hvt ad=0.0882 pd=0.84 as=0.0567 ps=0.69 w=0.42 l=0.15
X122 VSS a_50739_3579# a_50697_3311# VSS sky130_fd_pr__nfet_01v8 ad=0.1092 pd=1.36 as=0.066 ps=0.745 w=0.42 l=0.15
X123 a_61215_45974# a_61167_45886# VDD VDD sky130_fd_pr__pfet_01v8 ad=0.1218 pd=1.42 as=0.1218 ps=1.42 w=0.42 l=0.15
X124 VSS macro_core.write_drive.X a_88015_16496# VSS sky130_fd_pr__nfet_01v8 ad=1.4616 pd=10.66 as=1.4616 ps=10.66 w=5.04 l=0.15
X125 VSS _84_.Q a_61156_14441# VSS sky130_fd_pr__nfet_01v8 ad=0.10025 pd=0.985 as=0.0567 ps=0.69 w=0.42 l=0.15
X126 a_56717_13945# _44_.Y VDD VDD sky130_fd_pr__pfet_01v8_hvt ad=0.1176 pd=1.4 as=0.0693 ps=0.75 w=0.42 l=0.15
X127 a_71355_13647# a_70573_13653# a_71271_13647# VDD sky130_fd_pr__pfet_01v8_hvt ad=0.0882 pd=0.84 as=0.0567 ps=0.69 w=0.42 l=0.15
X128 a_54565_11477# a_54399_11477# VSS VSS sky130_fd_pr__nfet_01v8 ad=0.1092 pd=1.36 as=0.0567 ps=0.69 w=0.42 l=0.15
X129 a_57881_9295# _34_.Y VSS VSS sky130_fd_pr__nfet_01v8 ad=0.0813 pd=0.83 as=0.1092 ps=1.36 w=0.42 l=0.15
X130 VSS macro_core.write_drive.X a_73227_20916# VSS sky130_fd_pr__nfet_01v8 ad=0.2436 pd=2.26 as=0.2436 ps=2.26 w=0.84 l=0.15
X131 VDD macro_core.evaluation.X a_14227_36833# VDD sky130_fd_pr__pfet_01v8_hvt ad=0.16655 pd=1.39 as=0.0567 ps=0.69 w=0.42 l=0.15
X132 VSS macro_core.phase_delay\[0\].delay_cell.A a_78503_14191# VSS sky130_fd_pr__nfet_01v8 ad=0.0567 pd=0.69 as=0.1092 ps=1.36 w=0.42 l=0.15
X133 VSS a_77693_13945# a_77627_14013# VSS sky130_fd_pr__nfet_01v8 ad=0.1449 pd=1.11 as=0.0693 ps=0.75 w=0.42 l=0.15
X134 VDD a_62899_12381# a_63067_12283# VDD sky130_fd_pr__pfet_01v8_hvt ad=0.135 pd=1.27 as=0.27 ps=2.54 w=1 l=0.15
X135 macro_core.phase_delay\[75\].delay_cell.Y macro_core.phase_delay\[74\].delay_cell.Y VSS VSS sky130_fd_pr__nfet_01v8 ad=0.169 pd=1.82 as=0.169 ps=1.82 w=0.65 l=0.15
X136 VDD macro_core.precharge_drive.X macro_core.array_and_peripherals.write_driver_5.BLB VDD sky130_fd_pr__pfet_01v8 ad=0.7308 pd=5.62 as=0.7308 ps=5.62 w=2.52 l=0.15
X137 VDD macro_core.precharge_drive.X macro_core.array_and_peripherals.write_driver_7.BL VDD sky130_fd_pr__pfet_01v8 ad=0.7308 pd=5.62 as=0.7308 ps=5.62 w=2.52 l=0.15
X138 a_55142_12925# _84_.Q VSS VSS sky130_fd_pr__nfet_01v8 ad=0.0693 pd=0.75 as=0.11285 ps=1.045 w=0.42 l=0.15
X139 macro_core.phase_delay\[57\].delay_cell.Y macro_core.phase_delay\[56\].delay_cell.Y VDD VDD sky130_fd_pr__pfet_01v8_hvt ad=0.26 pd=2.52 as=0.26 ps=2.52 w=1 l=0.15
X140 DATA[7] a_75007_9839# a_75363_10089# VDD sky130_fd_pr__pfet_01v8_hvt ad=0.315 pd=2.63 as=0.475 ps=1.95 w=1 l=0.15
X141 DATA[3] a_59827_10383# a_60331_10703# VSS sky130_fd_pr__nfet_01v8 ad=0.286 pd=2.18 as=0.06825 ps=0.86 w=0.65 l=0.15
X142 a_49167_50886# macro_core.array_and_peripherals.wl_driver_2.WL macro_core.array_and_peripherals.write_driver_1.BLB VSS sky130_fd_pr__nfet_01v8 ad=0.174 pd=1.78 as=0.174 ps=1.78 w=0.6 l=0.15
X143 a_76578_9334# _44_.Y VDD VDD sky130_fd_pr__pfet_01v8_hvt ad=0.07665 pd=0.785 as=0.15835 ps=1.395 w=0.42 l=0.15
X144 macro_core.phase_delay\[21\].delay_cell.Y macro_core.phase_delay\[21\].delay_cell.A VSS VSS sky130_fd_pr__nfet_01v8 ad=0.169 pd=1.82 as=0.169 ps=1.82 w=0.65 l=0.15
X145 macro_core.write_drive.X a_61642_14191# VSS VSS sky130_fd_pr__nfet_01v8 ad=0.091 pd=0.93 as=0.091 ps=0.93 w=0.65 l=0.15
X146 VDD a_79227_20916# a_80027_20496# VDD sky130_fd_pr__pfet_01v8 ad=1.4616 pd=10.66 as=1.4616 ps=10.66 w=5.04 l=0.15
X147 a_49302_13621# a_49134_13647# VSS VSS sky130_fd_pr__nfet_01v8 ad=0.0989 pd=0.995 as=0.12095 ps=1.085 w=0.64 l=0.15
X148 a_73866_12127# a_73698_12381# VDD VDD sky130_fd_pr__pfet_01v8_hvt ad=0.1095 pd=1.075 as=0.17887 ps=1.26 w=0.75 l=0.15
X149 VSS macro_core.phase_delay\[0\].delay_cell.A _66_.Y VSS sky130_fd_pr__nfet_01v8 ad=0.1197 pd=1.41 as=0.1092 ps=1.36 w=0.42 l=0.15
X150 _55_.Y _34_.Y VDD VDD sky130_fd_pr__pfet_01v8_hvt ad=0.135 pd=1.27 as=0.26 ps=2.52 w=1 l=0.15
X151 clkbuf_0_CLK.X a_62863_9295# VDD VDD sky130_fd_pr__pfet_01v8_hvt ad=0.135 pd=1.27 as=0.1625 ps=1.325 w=1 l=0.15
X152 a_50053_9839# a_49063_9839# a_49927_10205# VSS sky130_fd_pr__special_nfet_01v8 ad=0.066 pd=0.745 as=0.0684 ps=0.74 w=0.36 l=0.15
X153 macro_core.phase_delay\[0\].delay_cell.A a_66819_10383# VDD VDD sky130_fd_pr__pfet_01v8_hvt ad=0.135 pd=1.27 as=0.1625 ps=1.325 w=1 l=0.15
X154 a_56160_14191# a_55761_14191# a_56034_14557# VSS sky130_fd_pr__special_nfet_01v8 ad=0.0696 pd=0.765 as=0.0621 ps=0.705 w=0.36 l=0.15
X155 a_58667_12381# a_57803_12015# a_58410_12127# VDD sky130_fd_pr__pfet_01v8_hvt ad=0.0567 pd=0.69 as=0.1095 ps=1.075 w=0.42 l=0.15
X156 a_71401_12337# _54_.Y VSS VSS sky130_fd_pr__nfet_01v8 ad=0.2583 pd=2.07 as=0.09813 ps=1.005 w=0.42 l=0.15
X157 VSS a_66819_10383# macro_core.phase_delay\[0\].delay_cell.A VSS sky130_fd_pr__nfet_01v8 ad=0.1092 pd=1.36 as=0.0567 ps=0.69 w=0.42 l=0.15
X158 VDD macro_core.phase_delay\[59\].delay_cell.Y a_46949_14455# VDD sky130_fd_pr__pfet_01v8_hvt ad=0.15075 pd=1.345 as=0.07438 ps=0.815 w=0.42 l=0.15
X159 a_61238_14441# _83_.Q a_61156_14441# VDD sky130_fd_pr__pfet_01v8_hvt ad=0.0441 pd=0.63 as=0.1092 ps=1.36 w=0.42 l=0.15
X160 a_58337_12381# a_57803_12015# a_58242_12381# VDD sky130_fd_pr__pfet_01v8_hvt ad=0.07665 pd=0.785 as=0.06825 ps=0.745 w=0.42 l=0.15
X161 VDD a_69507_12283# a_69423_12381# VDD sky130_fd_pr__pfet_01v8_hvt ad=0.1113 pd=1.37 as=0.0882 ps=0.84 w=0.42 l=0.15
X162 a_71591_12265# _54_.Y VDD VDD sky130_fd_pr__pfet_01v8_hvt ad=0.475 pd=1.95 as=0.27 ps=2.54 w=1 l=0.15
X163 VDD macro_core.write_drive.X a_55227_20916# VDD sky130_fd_pr__pfet_01v8 ad=0.2436 pd=2.26 as=0.2436 ps=2.26 w=0.84 l=0.15
X164 a_58705_14191# a_58539_14191# VSS VSS sky130_fd_pr__nfet_01v8 ad=0.1092 pd=1.36 as=0.0567 ps=0.69 w=0.42 l=0.15
X165 VSS _86_.CLK _33_.Y VSS sky130_fd_pr__nfet_01v8 ad=0.1197 pd=1.41 as=0.1092 ps=1.36 w=0.42 l=0.15
X166 VSS a_36227_56432# macro_core.array_and_peripherals.wl_driver_3.WL VSS sky130_fd_pr__nfet_01v8 ad=1.4616 pd=10.66 as=1.4616 ps=10.66 w=5.04 l=0.15
X167 a_79215_45974# a_79167_45886# VDD VDD sky130_fd_pr__pfet_01v8 ad=0.1218 pd=1.42 as=0.1218 ps=1.42 w=0.42 l=0.15
X168 a_47032_14197# macro_core.evaluation.A a_46949_14455# VSS sky130_fd_pr__nfet_01v8 ad=0.0441 pd=0.63 as=0.1092 ps=1.36 w=0.42 l=0.15
X169 a_52449_14191# a_52283_14191# VDD VDD sky130_fd_pr__pfet_01v8_hvt ad=0.1664 pd=1.8 as=0.0864 ps=0.91 w=0.64 l=0.15
X170 a_61642_14191# _86_.CLK VDD VDD sky130_fd_pr__pfet_01v8_hvt ad=0.14 pd=1.28 as=0.1975 ps=1.395 w=1 l=0.15
X171 VDD a_69082_12127# a_69009_12381# VDD sky130_fd_pr__pfet_01v8_hvt ad=0.17887 pd=1.26 as=0.07665 ps=0.785 w=0.42 l=0.15
X172 a_49215_50974# a_49167_50886# VSS VSS sky130_fd_pr__nfet_01v8 ad=0.3654 pd=3.1 as=0.3654 ps=3.1 w=1.26 l=0.15
X173 a_49321_12015# a_49155_12015# VDD VDD sky130_fd_pr__pfet_01v8_hvt ad=0.1664 pd=1.8 as=0.0864 ps=0.91 w=0.64 l=0.15
X174 a_49720_12015# a_49321_12015# a_49594_12381# VSS sky130_fd_pr__special_nfet_01v8 ad=0.0696 pd=0.765 as=0.0621 ps=0.705 w=0.36 l=0.15
X175 a_77711_12381# a_76847_12015# a_77454_12127# VDD sky130_fd_pr__pfet_01v8_hvt ad=0.0567 pd=0.69 as=0.1095 ps=1.075 w=0.42 l=0.15
X176 a_85167_45886# a_85215_45974# VSS VSS sky130_fd_pr__nfet_01v8 ad=0.3654 pd=3.1 as=0.3654 ps=3.1 w=1.26 l=0.15
X177 a_77381_12381# a_76847_12015# a_77286_12381# VDD sky130_fd_pr__pfet_01v8_hvt ad=0.07665 pd=0.785 as=0.06825 ps=0.745 w=0.42 l=0.15
X178 VDD a_36227_56432# macro_core.array_and_peripherals.wl_driver_3.WL VDD sky130_fd_pr__pfet_01v8 ad=1.4616 pd=10.66 as=1.4616 ps=10.66 w=5.04 l=0.15
X179 a_85215_50974# macro_core.array_and_peripherals.wl_driver_2.WL macro_core.array_and_peripherals.write_driver_7.BL VSS sky130_fd_pr__nfet_01v8 ad=0.174 pd=1.78 as=0.174 ps=1.78 w=0.6 l=0.15
X180 VDD a_36227_41432# macro_core.array_and_peripherals.wl_driver_0.WL VDD sky130_fd_pr__pfet_01v8 ad=1.4616 pd=10.66 as=1.4616 ps=10.66 w=5.04 l=0.15
X181 macro_core.phase_delay\[62\].delay_cell.A macro_core.phase_delay\[61\].delay_cell.A VDD VDD sky130_fd_pr__pfet_01v8_hvt ad=0.26 pd=2.52 as=0.26 ps=2.52 w=1 l=0.15
X182 _58_.Y _84_.Q a_52737_11791# VSS sky130_fd_pr__nfet_01v8 ad=0.169 pd=1.82 as=0.08775 ps=0.92 w=0.65 l=0.15
X183 VSS a_55006_11445# a_54964_11849# VSS sky130_fd_pr__nfet_01v8 ad=0.12095 pd=1.085 as=0.0696 ps=0.765 w=0.42 l=0.15
X184 VDD a_50571_3677# a_50739_3579# VDD sky130_fd_pr__pfet_01v8_hvt ad=0.135 pd=1.27 as=0.27 ps=2.54 w=1 l=0.15
X185 a_67167_50886# macro_core.array_and_peripherals.wl_driver_2.WL macro_core.array_and_peripherals.write_driver_4.BLB VSS sky130_fd_pr__nfet_01v8 ad=0.174 pd=1.78 as=0.174 ps=1.78 w=0.6 l=0.15
X186 a_15147_37067# macro_core.qualify_row\[0\].qualify.A VDD VDD sky130_fd_pr__pfet_01v8_hvt ad=0.0567 pd=0.69 as=0.1176 ps=1.4 w=0.42 l=0.15
X187 VDD a_67696_14343# _79_.D VDD sky130_fd_pr__pfet_01v8_hvt ad=0.15835 pd=1.395 as=0.26 ps=2.52 w=1 l=0.15
X188 VDD a_68432_11703# _49_.X VDD sky130_fd_pr__pfet_01v8_hvt ad=0.15835 pd=1.395 as=0.26 ps=2.52 w=1 l=0.15
X189 a_85167_50886# a_85215_50974# VDD VDD sky130_fd_pr__pfet_01v8 ad=0.1218 pd=1.42 as=0.1218 ps=1.42 w=0.42 l=0.15
X190 a_66899_12265# _55_.Y VDD VDD sky130_fd_pr__pfet_01v8_hvt ad=0.475 pd=1.95 as=0.27 ps=2.54 w=1 l=0.15
X191 a_68641_12015# a_68475_12015# VDD VDD sky130_fd_pr__pfet_01v8_hvt ad=0.1664 pd=1.8 as=0.0864 ps=0.91 w=0.64 l=0.15
X192 _40_.A1 macro_core.sense_drive.X macro_core.array_and_peripherals.write_driver_3.BL VDD sky130_fd_pr__pfet_01v8 ad=0.58 pd=4.58 as=0.58 ps=4.58 w=2 l=0.15
X193 a_61615_26902# _40_.A1 macro_core.array_and_peripherals.sense_amp_3.SA_OUTB VSS sky130_fd_pr__nfet_01v8 ad=0.2842 pd=2.54 as=0.2842 ps=2.54 w=0.98 l=0.15
X194 macro_core.array_and_peripherals.write_driver_1.BLB macro_core.sense_drive.X macro_core.array_and_peripherals.sense_amp_1.SA_OUTB VDD sky130_fd_pr__pfet_01v8 ad=0.58 pd=4.58 as=0.58 ps=4.58 w=2 l=0.15
X195 a_55363_12925# _89_.A a_55000_12791# VSS sky130_fd_pr__nfet_01v8 ad=0.0693 pd=0.75 as=0.09975 ps=0.895 w=0.42 l=0.15
X196 VDD a_77454_12127# a_77381_12381# VDD sky130_fd_pr__pfet_01v8_hvt ad=0.17887 pd=1.26 as=0.07665 ps=0.785 w=0.42 l=0.15
X197 a_56043_10383# _57_.Y VDD VDD sky130_fd_pr__pfet_01v8_hvt ad=0.475 pd=1.95 as=0.27 ps=2.54 w=1 l=0.15
X198 a_67215_55974# a_67167_55886# VDD VDD sky130_fd_pr__pfet_01v8 ad=0.1218 pd=1.42 as=0.1218 ps=1.42 w=0.42 l=0.15
X199 a_67215_40974# a_67167_40886# VDD VDD sky130_fd_pr__pfet_01v8 ad=0.1218 pd=1.42 as=0.1218 ps=1.42 w=0.42 l=0.15
X200 VDD a_71271_13647# a_71439_13621# VDD sky130_fd_pr__pfet_01v8_hvt ad=0.135 pd=1.27 as=0.27 ps=2.54 w=1 l=0.15
X201 a_49417_9839# _75_.D VDD VDD sky130_fd_pr__pfet_01v8_hvt ad=0.05775 pd=0.695 as=0.1092 ps=1.36 w=0.42 l=0.15
X202 a_49049_13647# _76_.D VSS VSS sky130_fd_pr__nfet_01v8 ad=0.0813 pd=0.83 as=0.1092 ps=1.36 w=0.42 l=0.15
X203 a_52235_11837# _45_.A0 a_51872_11703# VSS sky130_fd_pr__nfet_01v8 ad=0.0693 pd=0.75 as=0.09975 ps=0.895 w=0.42 l=0.15
X204 a_73167_55886# a_73215_55974# VSS VSS sky130_fd_pr__nfet_01v8 ad=0.3654 pd=3.1 as=0.3654 ps=3.1 w=1.26 l=0.15
X205 a_73167_40886# a_73215_40974# VSS VSS sky130_fd_pr__nfet_01v8 ad=0.3654 pd=3.1 as=0.3654 ps=3.1 w=1.26 l=0.15
X206 VSS a_56627_14459# a_56585_14191# VSS sky130_fd_pr__nfet_01v8 ad=0.1092 pd=1.36 as=0.066 ps=0.745 w=0.42 l=0.15
X207 macro_core.phase_delay\[41\].delay_cell.A macro_core.phase_delay\[40\].delay_cell.A VDD VDD sky130_fd_pr__pfet_01v8_hvt ad=0.26 pd=2.52 as=0.26 ps=2.52 w=1 l=0.15
X208 VDD _85_.Q macro_core.array_and_peripherals.row_decoder_0.A0B VDD sky130_fd_pr__pfet_01v8 ad=0.2436 pd=2.26 as=0.2436 ps=2.26 w=0.84 l=0.15
X209 macro_core.array_and_peripherals.row_decoder_0.net4 macro_core.array_and_peripherals.row_decoder_0.A1T macro_core.array_and_peripherals.row_decoder_0.N3 VSS sky130_fd_pr__nfet_01v8 ad=0.58 pd=4.58 as=0.58 ps=4.58 w=2 l=0.15
X210 a_49594_12381# a_49321_12015# a_49509_12015# VDD sky130_fd_pr__pfet_01v8_hvt ad=0.06825 pd=0.745 as=0.05775 ps=0.695 w=0.42 l=0.15
X211 VSS a_59146_14303# a_59104_14191# VSS sky130_fd_pr__nfet_01v8 ad=0.12095 pd=1.085 as=0.0696 ps=0.765 w=0.42 l=0.15
X212 a_61156_14441# _83_.Q VSS VSS sky130_fd_pr__nfet_01v8 ad=0.0567 pd=0.69 as=0.1092 ps=1.36 w=0.42 l=0.15
X213 a_78510_12342# _84_.Q VDD VDD sky130_fd_pr__pfet_01v8_hvt ad=0.07665 pd=0.785 as=0.15835 ps=1.395 w=0.42 l=0.15
X214 VDD macro_core.array_and_peripherals.sense_amp_1.SA_OUTB _42_.A1 VDD sky130_fd_pr__pfet_01v8 ad=0.5481 pd=4.36 as=0.5481 ps=4.36 w=1.89 l=0.15
X215 VDD a_68125_14165# a_68155_14518# VDD sky130_fd_pr__pfet_01v8_hvt ad=0.0693 pd=0.75 as=0.0441 ps=0.63 w=0.42 l=0.15
X216 a_79068_14191# a_78669_14191# a_78942_14557# VSS sky130_fd_pr__special_nfet_01v8 ad=0.0696 pd=0.765 as=0.0621 ps=0.705 w=0.36 l=0.15
X217 a_52779_3677# a_52081_3311# a_52522_3423# VSS sky130_fd_pr__special_nfet_01v8 ad=0.0684 pd=0.74 as=0.0989 ps=0.995 w=0.36 l=0.15
X218 VSS macro_core.phase_delay\[0\].delay_cell.A a_77123_9839# VSS sky130_fd_pr__nfet_01v8 ad=0.0567 pd=0.69 as=0.1092 ps=1.36 w=0.42 l=0.15
X219 VSS _94_.A a_75007_9839# VSS sky130_fd_pr__nfet_01v8 ad=0.09813 pd=1.005 as=0.1092 ps=1.36 w=0.42 l=0.15
X220 macro_core.evaluation.A a_61156_14441# VSS VSS sky130_fd_pr__nfet_01v8 ad=0.169 pd=1.82 as=0.10025 ps=0.985 w=0.65 l=0.15
X221 a_78510_12015# _84_.Q VSS VSS sky130_fd_pr__nfet_01v8 ad=0.0693 pd=0.75 as=0.11285 ps=1.045 w=0.42 l=0.15
X222 macro_core.qualify_row\[2\].qualify.X a_14227_36833# VDD VDD sky130_fd_pr__pfet_01v8_hvt ad=0.475 pd=2.95 as=0.16655 ps=1.39 w=1 l=0.15
X223 _87_.TE_B _34_.Y VDD VDD sky130_fd_pr__pfet_01v8_hvt ad=0.135 pd=1.27 as=0.26 ps=2.52 w=1 l=0.15
X224 VDD _83_.Q a_61642_14191# VDD sky130_fd_pr__pfet_01v8_hvt ad=0.1975 pd=1.395 as=0.305 ps=2.61 w=1 l=0.15
X225 a_50146_3677# a_49873_3311# a_50061_3311# VDD sky130_fd_pr__pfet_01v8_hvt ad=0.06825 pd=0.745 as=0.05775 ps=0.695 w=0.42 l=0.15
X226 a_55215_50974# a_55167_50886# VDD VDD sky130_fd_pr__pfet_01v8 ad=0.1218 pd=1.42 as=0.1218 ps=1.42 w=0.42 l=0.15
X227 a_49321_12015# a_49155_12015# VSS VSS sky130_fd_pr__nfet_01v8 ad=0.1092 pd=1.36 as=0.0567 ps=0.69 w=0.42 l=0.15
X228 a_55215_45974# macro_core.array_and_peripherals.wl_driver_1.WL macro_core.array_and_peripherals.write_driver_2.BL VSS sky130_fd_pr__nfet_01v8 ad=0.174 pd=1.78 as=0.174 ps=1.78 w=0.6 l=0.15
X229 macro_core.array_and_peripherals.write_driver_4.BLB macro_core.sense_drive.X macro_core.array_and_peripherals.sense_amp_4.SA_OUTB VDD sky130_fd_pr__pfet_01v8 ad=0.58 pd=4.58 as=0.58 ps=4.58 w=2 l=0.15
X230 a_72199_14191# _92_.A a_71836_14343# VSS sky130_fd_pr__nfet_01v8 ad=0.0693 pd=0.75 as=0.09975 ps=0.895 w=0.42 l=0.15
X231 a_78368_12167# _94_.A a_78510_12342# VDD sky130_fd_pr__pfet_01v8_hvt ad=0.1932 pd=1.34 as=0.07665 ps=0.785 w=0.42 l=0.15
X232 macro_core.phase_delay\[10\].delay_cell.Y macro_core.phase_delay\[10\].delay_cell.A VDD VDD sky130_fd_pr__pfet_01v8_hvt ad=0.26 pd=2.52 as=0.26 ps=2.52 w=1 l=0.15
X233 a_76436_9527# DATA[7] a_76578_9661# VSS sky130_fd_pr__nfet_01v8 ad=0.09975 pd=0.895 as=0.0693 ps=0.75 w=0.42 l=0.15
X234 macro_core.phase_delay\[43\].delay_cell.A macro_core.phase_delay\[42\].delay_cell.A VDD VDD sky130_fd_pr__pfet_01v8_hvt ad=0.26 pd=2.52 as=0.26 ps=2.52 w=1 l=0.15
X235 a_48861_13653# a_48695_13653# VDD VDD sky130_fd_pr__pfet_01v8_hvt ad=0.1664 pd=1.8 as=0.0864 ps=0.91 w=0.64 l=0.15
X236 VDD a_56288_13879# _47_.X VDD sky130_fd_pr__pfet_01v8_hvt ad=0.15835 pd=1.395 as=0.26 ps=2.52 w=1 l=0.15
X237 VSS a_62863_9295# clkbuf_0_CLK.X VSS sky130_fd_pr__nfet_01v8 ad=0.1092 pd=1.36 as=0.0567 ps=0.69 w=0.42 l=0.15
X238 VSS clkbuf_0_CLK.X a_58539_10383# VSS sky130_fd_pr__nfet_01v8 ad=0.06825 pd=0.745 as=0.1113 ps=1.37 w=0.42 l=0.15
X239 a_61167_50886# a_61215_50974# VSS VSS sky130_fd_pr__nfet_01v8 ad=0.3654 pd=3.1 as=0.3654 ps=3.1 w=1.26 l=0.15
X240 a_77693_13945# _44_.Y VDD VDD sky130_fd_pr__pfet_01v8_hvt ad=0.1176 pd=1.4 as=0.0693 ps=0.75 w=0.42 l=0.15
X241 VDD _91_.A a_66543_12015# VDD sky130_fd_pr__pfet_01v8_hvt ad=0.0864 pd=0.91 as=0.1664 ps=1.8 w=0.64 l=0.15
X242 VSS _91_.A a_66543_12015# VSS sky130_fd_pr__nfet_01v8 ad=0.09813 pd=1.005 as=0.1092 ps=1.36 w=0.42 l=0.15
X243 VSS a_50571_3677# a_50739_3579# VSS sky130_fd_pr__nfet_01v8 ad=0.08775 pd=0.92 as=0.169 ps=1.82 w=0.65 l=0.15
X244 VDD _84_.Q _54_.Y VDD sky130_fd_pr__pfet_01v8_hvt ad=0.26 pd=2.52 as=0.135 ps=1.27 w=1 l=0.15
X245 a_55167_45886# a_55215_45974# VDD VDD sky130_fd_pr__pfet_01v8 ad=0.1218 pd=1.42 as=0.1218 ps=1.42 w=0.42 l=0.15
X246 a_46015_16496# _45_.A0 macro_core.array_and_peripherals.write_driver_0.BLB VSS sky130_fd_pr__nfet_01v8 ad=1.4616 pd=10.66 as=1.4616 ps=10.66 w=5.04 l=0.15
X247 macro_core.phase_delay\[77\].delay_cell.Y macro_core.phase_delay\[76\].delay_cell.Y VSS VSS sky130_fd_pr__nfet_01v8 ad=0.169 pd=1.82 as=0.169 ps=1.82 w=0.65 l=0.15
X248 a_68641_12015# a_68475_12015# VSS VSS sky130_fd_pr__nfet_01v8 ad=0.1092 pd=1.36 as=0.0567 ps=0.69 w=0.42 l=0.15
X249 a_52081_3311# a_51915_3311# VSS VSS sky130_fd_pr__nfet_01v8 ad=0.1092 pd=1.36 as=0.0567 ps=0.69 w=0.42 l=0.15
X250 a_68829_12015# _49_.X VDD VDD sky130_fd_pr__pfet_01v8_hvt ad=0.05775 pd=0.695 as=0.1092 ps=1.36 w=0.42 l=0.15
X251 a_69082_12127# a_68914_12381# VSS VSS sky130_fd_pr__nfet_01v8 ad=0.0989 pd=0.995 as=0.12095 ps=1.085 w=0.64 l=0.15
X252 _94_.A a_77879_12283# VSS VSS sky130_fd_pr__nfet_01v8 ad=0.169 pd=1.82 as=0.08775 ps=0.92 w=0.65 l=0.15
X253 VDD a_50095_10107# a_50011_10205# VDD sky130_fd_pr__pfet_01v8_hvt ad=0.1113 pd=1.37 as=0.0882 ps=0.84 w=0.42 l=0.15
X254 a_55949_14191# _47_.X VSS VSS sky130_fd_pr__nfet_01v8 ad=0.0813 pd=0.83 as=0.1092 ps=1.36 w=0.42 l=0.15
X255 a_72162_12342# _44_.Y VDD VDD sky130_fd_pr__pfet_01v8_hvt ad=0.07665 pd=0.785 as=0.15835 ps=1.395 w=0.42 l=0.15
X256 a_53159_13430# DATA[1] a_52700_13255# VDD sky130_fd_pr__pfet_01v8_hvt ad=0.0441 pd=0.63 as=0.1932 ps=1.34 w=0.42 l=0.15
X257 a_72162_12015# _44_.Y VSS VSS sky130_fd_pr__nfet_01v8 ad=0.0693 pd=0.75 as=0.11285 ps=1.045 w=0.42 l=0.15
X258 VDD a_61642_14191# macro_core.write_drive.X VDD sky130_fd_pr__pfet_01v8_hvt ad=0.285 pd=2.57 as=0.14 ps=1.28 w=1 l=0.15
X259 a_43215_55974# macro_core.array_and_peripherals.wl_driver_3.WL macro_core.array_and_peripherals.write_driver_0.BL VSS sky130_fd_pr__nfet_01v8 ad=0.174 pd=1.78 as=0.174 ps=1.78 w=0.6 l=0.15
X260 a_43215_40974# macro_core.array_and_peripherals.wl_driver_0.WL macro_core.array_and_peripherals.write_driver_0.BL VSS sky130_fd_pr__nfet_01v8 ad=0.174 pd=1.78 as=0.174 ps=1.78 w=0.6 l=0.15
X261 a_56717_13945# _44_.Y VSS VSS sky130_fd_pr__nfet_01v8 ad=0.1092 pd=1.36 as=0.1449 ps=1.11 w=0.42 l=0.15
X262 _88_.A a_49727_13621# VDD VDD sky130_fd_pr__pfet_01v8_hvt ad=0.26 pd=2.52 as=0.135 ps=1.27 w=1 l=0.15
X263 VSS a_53129_13077# a_53063_13103# VSS sky130_fd_pr__nfet_01v8 ad=0.1449 pd=1.11 as=0.0693 ps=0.75 w=0.42 l=0.15
X264 VSS _86_.CLK a_57527_9301# VSS sky130_fd_pr__nfet_01v8 ad=0.0567 pd=0.69 as=0.1092 ps=1.36 w=0.42 l=0.15
X265 VSS a_79535_14459# a_79493_14191# VSS sky130_fd_pr__nfet_01v8 ad=0.1092 pd=1.36 as=0.066 ps=0.745 w=0.42 l=0.15
X266 _88_.A a_49727_13621# VSS VSS sky130_fd_pr__nfet_01v8 ad=0.169 pd=1.82 as=0.08775 ps=0.92 w=0.65 l=0.15
X267 VSS a_63067_12283# a_63025_12015# VSS sky130_fd_pr__nfet_01v8 ad=0.1092 pd=1.36 as=0.066 ps=0.745 w=0.42 l=0.15
X268 macro_core.phase_delay\[13\].delay_cell.Y macro_core.phase_delay\[12\].delay_cell.Y VDD VDD sky130_fd_pr__pfet_01v8_hvt ad=0.26 pd=2.52 as=0.26 ps=2.52 w=1 l=0.15
X269 a_67696_14343# _91_.A a_67838_14518# VDD sky130_fd_pr__pfet_01v8_hvt ad=0.1932 pd=1.34 as=0.07665 ps=0.785 w=0.42 l=0.15
X270 VSS macro_core.phase_delay\[0\].delay_cell.A _63_.Y VSS sky130_fd_pr__nfet_01v8 ad=0.1197 pd=1.41 as=0.1092 ps=1.36 w=0.42 l=0.15
X271 a_72020_12167# _50_.A0 a_72162_12342# VDD sky130_fd_pr__pfet_01v8_hvt ad=0.1932 pd=1.34 as=0.07665 ps=0.785 w=0.42 l=0.15
X272 VDD a_50314_3423# a_50241_3677# VDD sky130_fd_pr__pfet_01v8_hvt ad=0.17887 pd=1.26 as=0.07665 ps=0.785 w=0.42 l=0.15
X273 a_43167_55886# a_43215_55974# VDD VDD sky130_fd_pr__pfet_01v8 ad=0.1218 pd=1.42 as=0.1218 ps=1.42 w=0.42 l=0.15
X274 a_43167_40886# a_43215_40974# VDD VDD sky130_fd_pr__pfet_01v8 ad=0.1218 pd=1.42 as=0.1218 ps=1.42 w=0.42 l=0.15
X275 VSS _86_.Q macro_core.array_and_peripherals.row_decoder_0.A1B VSS sky130_fd_pr__nfet_01v8 ad=0.2436 pd=2.26 as=0.2436 ps=2.26 w=0.84 l=0.15
X276 VDD macro_core.phase_delay\[0\].delay_cell.A a_68475_12015# VDD sky130_fd_pr__pfet_01v8_hvt ad=0.0864 pd=0.91 as=0.1664 ps=1.8 w=0.64 l=0.15
X277 macro_core.phase_delay\[16\].delay_cell.Y macro_core.phase_delay\[15\].delay_cell.Y VSS VSS sky130_fd_pr__nfet_01v8 ad=0.169 pd=1.82 as=0.169 ps=1.82 w=0.65 l=0.15
X278 a_79167_50886# a_79215_50974# VSS VSS sky130_fd_pr__nfet_01v8 ad=0.3654 pd=3.1 as=0.3654 ps=3.1 w=1.26 l=0.15
X279 VSS macro_core.write_drive.X a_50415_16496# VSS sky130_fd_pr__nfet_01v8 ad=1.4616 pd=10.66 as=1.4616 ps=10.66 w=5.04 l=0.15
X280 a_62415_16496# macro_core.data_complement\[3\].complement.Y macro_core.array_and_peripherals.write_driver_3.BL VSS sky130_fd_pr__nfet_01v8 ad=1.4616 pd=10.66 as=1.4616 ps=10.66 w=5.04 l=0.15
X281 VSS a_78368_12167# _82_.D VSS sky130_fd_pr__nfet_01v8 ad=0.11285 pd=1.045 as=0.169 ps=1.82 w=0.65 l=0.15
X282 macro_core.phase_delay\[10\].delay_cell.A macro_core.phase_delay\[8\].delay_cell.Y VDD VDD sky130_fd_pr__pfet_01v8_hvt ad=0.26 pd=2.52 as=0.26 ps=2.52 w=1 l=0.15
X283 VDD macro_core.qualify_row\[3\].qualify.A macro_core.array_and_peripherals.row_decoder_0.N3 VDD sky130_fd_pr__pfet_01v8 ad=0.2436 pd=2.26 as=0.2436 ps=2.26 w=0.84 l=0.15
X284 macro_core.phase_delay\[1\].delay_cell.A macro_core.phase_delay\[0\].delay_cell.A VSS VSS sky130_fd_pr__nfet_01v8 ad=0.169 pd=1.82 as=0.169 ps=1.82 w=0.65 l=0.15
X285 a_55853_10383# _57_.Y VDD VDD sky130_fd_pr__pfet_01v8_hvt ad=0.1664 pd=1.8 as=0.0864 ps=0.91 w=0.64 l=0.15
X286 VDD a_55431_11445# a_55347_11471# VDD sky130_fd_pr__pfet_01v8_hvt ad=0.1113 pd=1.37 as=0.0882 ps=0.84 w=0.42 l=0.15
X287 macro_core.phase_delay\[58\].delay_cell.Y macro_core.phase_delay\[57\].delay_cell.Y VSS VSS sky130_fd_pr__nfet_01v8 ad=0.169 pd=1.82 as=0.169 ps=1.82 w=0.65 l=0.15
X288 a_75357_12337# _53_.Y VSS VSS sky130_fd_pr__nfet_01v8 ad=0.2583 pd=2.07 as=0.09813 ps=1.005 w=0.42 l=0.15
X289 a_50241_3677# a_49707_3311# a_50146_3677# VDD sky130_fd_pr__pfet_01v8_hvt ad=0.07665 pd=0.785 as=0.06825 ps=0.745 w=0.42 l=0.15
X290 a_77730_9951# a_77562_10205# VSS VSS sky130_fd_pr__nfet_01v8 ad=0.0989 pd=0.995 as=0.12095 ps=1.085 w=0.64 l=0.15
X291 macro_core.data_complement\[6\].complement.Y _51_.A0 VSS VSS sky130_fd_pr__nfet_01v8 ad=0.169 pd=1.82 as=0.169 ps=1.82 w=0.65 l=0.15
X292 macro_core.phase_delay\[55\].delay_cell.Y macro_core.phase_delay\[54\].delay_cell.Y VDD VDD sky130_fd_pr__pfet_01v8_hvt ad=0.26 pd=2.52 as=0.26 ps=2.52 w=1 l=0.15
X293 VSS a_74123_12381# a_74291_12283# VSS sky130_fd_pr__nfet_01v8 ad=0.08775 pd=0.92 as=0.169 ps=1.82 w=0.65 l=0.15
X294 macro_core.phase_delay\[7\].delay_cell.Y macro_core.phase_delay\[6\].delay_cell.Y VDD VDD sky130_fd_pr__pfet_01v8_hvt ad=0.26 pd=2.52 as=0.26 ps=2.52 w=1 l=0.15
X295 VDD macro_core.precharge_drive.X macro_core.array_and_peripherals.write_driver_1.BL VDD sky130_fd_pr__pfet_01v8 ad=0.7308 pd=5.62 as=0.7308 ps=5.62 w=2.52 l=0.15
X296 VDD a_75119_14459# a_75035_14557# VDD sky130_fd_pr__pfet_01v8_hvt ad=0.1113 pd=1.37 as=0.0882 ps=0.84 w=0.42 l=0.15
X297 VDD a_76436_9527# _52_.X VDD sky130_fd_pr__pfet_01v8_hvt ad=0.15835 pd=1.395 as=0.26 ps=2.52 w=1 l=0.15
X298 VSS macro_core.evaluation.X a_12749_36833# VSS sky130_fd_pr__nfet_01v8 ad=0.1118 pd=1.04 as=0.0567 ps=0.69 w=0.42 l=0.15
X299 macro_core.data_complement\[4\].complement.Y _49_.A0 VDD VDD sky130_fd_pr__pfet_01v8_hvt ad=0.26 pd=2.52 as=0.26 ps=2.52 w=1 l=0.15
X300 a_56543_14557# a_55761_14191# a_56459_14557# VDD sky130_fd_pr__pfet_01v8_hvt ad=0.0882 pd=0.84 as=0.0567 ps=0.69 w=0.42 l=0.15
X301 VSS macro_core.sense_drive.X a_61615_26902# VSS sky130_fd_pr__nfet_01v8 ad=0.2842 pd=2.54 as=0.2842 ps=2.54 w=0.98 l=0.15
X302 _46_.A0 a_53315_14459# VDD VDD sky130_fd_pr__pfet_01v8_hvt ad=0.26 pd=2.52 as=0.135 ps=1.27 w=1 l=0.15
X303 VSS CLK a_62863_9295# VSS sky130_fd_pr__nfet_01v8 ad=0.06825 pd=0.745 as=0.1113 ps=1.37 w=0.42 l=0.15
X304 VDD a_49670_9951# a_49597_10205# VDD sky130_fd_pr__pfet_01v8_hvt ad=0.17887 pd=1.26 as=0.07665 ps=0.785 w=0.42 l=0.15
X305 VDD a_43227_20916# a_44027_20496# VDD sky130_fd_pr__pfet_01v8 ad=1.4616 pd=10.66 as=1.4616 ps=10.66 w=5.04 l=0.15
X306 macro_core.phase_delay\[59\].delay_cell.Y macro_core.phase_delay\[58\].delay_cell.Y VSS VSS sky130_fd_pr__nfet_01v8 ad=0.169 pd=1.82 as=0.169 ps=1.82 w=0.65 l=0.15
X307 a_53911_2999# WEb VDD VDD sky130_fd_pr__pfet_01v8_hvt ad=0.1092 pd=1.36 as=0.14575 ps=1.335 w=0.42 l=0.15
X308 macro_core.data_complement\[7\].complement.Y _52_.A0 VDD VDD sky130_fd_pr__pfet_01v8_hvt ad=0.26 pd=2.52 as=0.26 ps=2.52 w=1 l=0.15
X309 VSS a_52522_3423# a_52480_3311# VSS sky130_fd_pr__nfet_01v8 ad=0.12095 pd=1.085 as=0.0696 ps=0.765 w=0.42 l=0.15
X310 a_72383_12015# _50_.A0 a_72020_12167# VSS sky130_fd_pr__nfet_01v8 ad=0.0693 pd=0.75 as=0.09975 ps=0.895 w=0.42 l=0.15
X311 VSS a_48744_11703# _75_.D VSS sky130_fd_pr__nfet_01v8 ad=0.11285 pd=1.045 as=0.169 ps=1.82 w=0.65 l=0.15
X312 macro_core.phase_delay\[14\].delay_cell.Y macro_core.phase_delay\[13\].delay_cell.Y VDD VDD sky130_fd_pr__pfet_01v8_hvt ad=0.26 pd=2.52 as=0.26 ps=2.52 w=1 l=0.15
X313 macro_core.phase_delay\[32\].delay_cell.Y macro_core.phase_delay\[32\].delay_cell.A VDD VDD sky130_fd_pr__pfet_01v8_hvt ad=0.26 pd=2.52 as=0.26 ps=2.52 w=1 l=0.15
X314 VSS macro_core.write_drive.X a_68415_16496# VSS sky130_fd_pr__nfet_01v8 ad=1.4616 pd=10.66 as=1.4616 ps=10.66 w=5.04 l=0.15
X315 a_52817_14557# a_52283_14191# a_52722_14557# VDD sky130_fd_pr__pfet_01v8_hvt ad=0.07665 pd=0.785 as=0.06825 ps=0.745 w=0.42 l=0.15
X316 a_62389_12015# _48_.X VSS VSS sky130_fd_pr__nfet_01v8 ad=0.0813 pd=0.83 as=0.1092 ps=1.36 w=0.42 l=0.15
X317 VSS a_72020_12167# _50_.X VSS sky130_fd_pr__nfet_01v8 ad=0.11285 pd=1.045 as=0.169 ps=1.82 w=0.65 l=0.15
X318 macro_core.phase_delay\[30\].delay_cell.Y macro_core.phase_delay\[30\].delay_cell.A VSS VSS sky130_fd_pr__nfet_01v8 ad=0.169 pd=1.82 as=0.169 ps=1.82 w=0.65 l=0.15
X319 macro_core.qualify_row\[3\].qualify.X a_15147_35745# VDD VDD sky130_fd_pr__pfet_01v8_hvt ad=0.475 pd=2.95 as=0.16655 ps=1.39 w=1 l=0.15
X320 VDD _36_.A1 macro_core.array_and_peripherals.sense_amp_7.SA_OUTB VDD sky130_fd_pr__pfet_01v8 ad=0.5481 pd=4.36 as=0.5481 ps=4.36 w=1.89 l=0.15
X321 VSS macro_core.qualify_row\[2\].qualify.X a_36227_51432# VSS sky130_fd_pr__nfet_01v8 ad=0.4872 pd=3.94 as=0.4872 ps=3.94 w=1.68 l=0.15
X322 macro_core.data_complement\[3\].complement.Y _48_.A0 VSS VSS sky130_fd_pr__nfet_01v8 ad=0.169 pd=1.82 as=0.169 ps=1.82 w=0.65 l=0.15
X323 VDD _60_.Y a_48695_13653# VDD sky130_fd_pr__pfet_01v8_hvt ad=0.0864 pd=0.91 as=0.1664 ps=1.8 w=0.64 l=0.15
X324 macro_core.phase_delay\[6\].delay_cell.Y macro_core.phase_delay\[5\].delay_cell.Y VSS VSS sky130_fd_pr__nfet_01v8 ad=0.169 pd=1.82 as=0.169 ps=1.82 w=0.65 l=0.15
X325 macro_core.array_and_peripherals.write_driver_3.BLB macro_core.precharge_drive.X macro_core.array_and_peripherals.write_driver_3.BL VDD sky130_fd_pr__pfet_01v8 ad=0.7308 pd=5.62 as=0.7308 ps=5.62 w=2.52 l=0.15
X326 macro_core.sense_drive.X a_64611_14191# VDD VDD sky130_fd_pr__pfet_01v8_hvt ad=0.14 pd=1.28 as=0.14 ps=1.28 w=1 l=0.15
X327 a_74253_14191# a_74087_14191# VDD VDD sky130_fd_pr__pfet_01v8_hvt ad=0.1664 pd=1.8 as=0.0864 ps=0.91 w=0.64 l=0.15
X328 a_67215_45974# a_67167_45886# VSS VSS sky130_fd_pr__nfet_01v8 ad=0.3654 pd=3.1 as=0.3654 ps=3.1 w=1.26 l=0.15
X329 macro_core.phase_delay\[68\].delay_cell.Y macro_core.phase_delay\[67\].delay_cell.Y VSS VSS sky130_fd_pr__nfet_01v8 ad=0.169 pd=1.82 as=0.169 ps=1.82 w=0.65 l=0.15
X330 a_49167_45886# a_49215_45974# VSS VSS sky130_fd_pr__nfet_01v8 ad=0.3654 pd=3.1 as=0.3654 ps=3.1 w=1.26 l=0.15
X331 a_50369_14165# _84_.Q VDD VDD sky130_fd_pr__pfet_01v8_hvt ad=0.1176 pd=1.4 as=0.0693 ps=0.75 w=0.42 l=0.15
X332 a_49685_14025# a_48695_13653# a_49559_13647# VSS sky130_fd_pr__special_nfet_01v8 ad=0.066 pd=0.745 as=0.0684 ps=0.74 w=0.36 l=0.15
X333 VSS macro_core.phase_delay\[0\].delay_cell.A a_68475_12015# VSS sky130_fd_pr__nfet_01v8 ad=0.0567 pd=0.69 as=0.1092 ps=1.36 w=0.42 l=0.15
X334 VDD a_58559_9269# a_58475_9295# VDD sky130_fd_pr__pfet_01v8_hvt ad=0.1113 pd=1.37 as=0.0882 ps=0.84 w=0.42 l=0.15
X335 a_54838_11471# a_54399_11477# a_54753_11471# VSS sky130_fd_pr__special_nfet_01v8 ad=0.0621 pd=0.705 as=0.0813 ps=0.83 w=0.36 l=0.15
X336 a_85167_45886# macro_core.array_and_peripherals.wl_driver_1.WL macro_core.array_and_peripherals.write_driver_7.BLB VSS sky130_fd_pr__nfet_01v8 ad=0.174 pd=1.78 as=0.174 ps=1.78 w=0.6 l=0.15
X337 a_73615_26902# macro_core.array_and_peripherals.sense_amp_5.SA_OUTB _38_.A1 VSS sky130_fd_pr__nfet_01v8 ad=0.2842 pd=2.54 as=0.2842 ps=2.54 w=0.98 l=0.15
X338 VSS a_49727_13621# a_49685_14025# VSS sky130_fd_pr__nfet_01v8 ad=0.1092 pd=1.36 as=0.066 ps=0.745 w=0.42 l=0.15
X339 a_70761_13647# _80_.D VSS VSS sky130_fd_pr__nfet_01v8 ad=0.0813 pd=0.83 as=0.1092 ps=1.36 w=0.42 l=0.15
X340 a_77454_12127# a_77286_12381# VDD VDD sky130_fd_pr__pfet_01v8_hvt ad=0.1095 pd=1.075 as=0.17887 ps=1.26 w=0.75 l=0.15
X341 a_50082_14191# _84_.Q VSS VSS sky130_fd_pr__nfet_01v8 ad=0.0693 pd=0.75 as=0.11285 ps=1.045 w=0.42 l=0.15
X342 a_58667_12381# a_57969_12015# a_58410_12127# VSS sky130_fd_pr__special_nfet_01v8 ad=0.0684 pd=0.74 as=0.0989 ps=0.995 w=0.36 l=0.15
X343 macro_core.phase_delay\[67\].delay_cell.Y macro_core.phase_delay\[66\].delay_cell.Y VSS VSS sky130_fd_pr__nfet_01v8 ad=0.169 pd=1.82 as=0.169 ps=1.82 w=0.65 l=0.15
X344 a_49167_50886# a_49215_50974# VDD VDD sky130_fd_pr__pfet_01v8 ad=0.1218 pd=1.42 as=0.1218 ps=1.42 w=0.42 l=0.15
X345 VDD a_61642_14191# macro_core.write_drive.X VDD sky130_fd_pr__pfet_01v8_hvt ad=0.14 pd=1.28 as=0.14 ps=1.28 w=1 l=0.15
X346 macro_core.phase_delay\[32\].delay_cell.A macro_core.phase_delay\[30\].delay_cell.Y VSS VSS sky130_fd_pr__nfet_01v8 ad=0.169 pd=1.82 as=0.169 ps=1.82 w=0.65 l=0.15
X347 VSS macro_core.write_drive.X a_82015_16496# VSS sky130_fd_pr__nfet_01v8 ad=1.4616 pd=10.66 as=1.4616 ps=10.66 w=5.04 l=0.15
X348 macro_core.data_complement\[2\].complement.Y _47_.A0 VDD VDD sky130_fd_pr__pfet_01v8_hvt ad=0.26 pd=2.52 as=0.26 ps=2.52 w=1 l=0.15
X349 a_71836_14343# _38_.A1 a_71978_14191# VSS sky130_fd_pr__nfet_01v8 ad=0.09975 pd=0.895 as=0.0693 ps=0.75 w=0.42 l=0.15
X350 _93_.A a_75119_14459# VSS VSS sky130_fd_pr__nfet_01v8 ad=0.169 pd=1.82 as=0.08775 ps=0.92 w=0.65 l=0.15
X351 VSS a_67683_13647# a_67851_13621# VSS sky130_fd_pr__nfet_01v8 ad=0.08775 pd=0.92 as=0.169 ps=1.82 w=0.65 l=0.15
X352 VDD a_67683_13647# a_67851_13621# VDD sky130_fd_pr__pfet_01v8_hvt ad=0.135 pd=1.27 as=0.27 ps=2.54 w=1 l=0.15
X353 VDD _86_.CLK _33_.Y VDD sky130_fd_pr__pfet_01v8_hvt ad=0.2352 pd=2.24 as=0.1134 ps=1.11 w=0.84 l=0.15
X354 a_52269_3311# ADDR[0] VSS VSS sky130_fd_pr__nfet_01v8 ad=0.0813 pd=0.83 as=0.1092 ps=1.36 w=0.42 l=0.15
X355 a_53911_2999# WEb VSS VSS sky130_fd_pr__nfet_01v8 ad=0.1092 pd=1.36 as=0.10025 ps=0.985 w=0.42 l=0.15
X356 a_55215_55974# a_55167_55886# VSS VSS sky130_fd_pr__nfet_01v8 ad=0.3654 pd=3.1 as=0.3654 ps=3.1 w=1.26 l=0.15
X357 a_55215_40974# a_55167_40886# VSS VSS sky130_fd_pr__nfet_01v8 ad=0.3654 pd=3.1 as=0.3654 ps=3.1 w=1.26 l=0.15
X358 VSS _86_.CLK a_51915_3311# VSS sky130_fd_pr__nfet_01v8 ad=0.0567 pd=0.69 as=0.1092 ps=1.36 w=0.42 l=0.15
X359 macro_core.phase_delay\[30\].delay_cell.A macro_core.phase_delay\[28\].delay_cell.Y VSS VSS sky130_fd_pr__nfet_01v8 ad=0.169 pd=1.82 as=0.169 ps=1.82 w=0.65 l=0.15
X360 a_71978_14191# _84_.Q VSS VSS sky130_fd_pr__nfet_01v8 ad=0.0693 pd=0.75 as=0.11285 ps=1.045 w=0.42 l=0.15
X361 a_76155_14191# _93_.A a_75792_14343# VSS sky130_fd_pr__nfet_01v8 ad=0.0693 pd=0.75 as=0.09975 ps=0.895 w=0.42 l=0.15
X362 macro_core.phase_delay\[53\].delay_cell.A macro_core.phase_delay\[51\].delay_cell.Y VDD VDD sky130_fd_pr__pfet_01v8_hvt ad=0.26 pd=2.52 as=0.26 ps=2.52 w=1 l=0.15
X363 macro_core.phase_delay\[51\].delay_cell.A macro_core.phase_delay\[50\].delay_cell.A VDD VDD sky130_fd_pr__pfet_01v8_hvt ad=0.26 pd=2.52 as=0.26 ps=2.52 w=1 l=0.15
X364 VDD _89_.A a_55687_10383# VDD sky130_fd_pr__pfet_01v8_hvt ad=0.0864 pd=0.91 as=0.1664 ps=1.8 w=0.64 l=0.15
X365 a_73167_55886# macro_core.array_and_peripherals.wl_driver_3.WL macro_core.array_and_peripherals.write_driver_5.BLB VSS sky130_fd_pr__nfet_01v8 ad=0.174 pd=1.78 as=0.174 ps=1.78 w=0.6 l=0.15
X366 a_73167_40886# macro_core.array_and_peripherals.wl_driver_0.WL macro_core.array_and_peripherals.write_driver_5.BLB VSS sky130_fd_pr__nfet_01v8 ad=0.174 pd=1.78 as=0.174 ps=1.78 w=0.6 l=0.15
X367 a_67384_14025# a_66985_13653# a_67258_13647# VSS sky130_fd_pr__special_nfet_01v8 ad=0.0696 pd=0.765 as=0.0621 ps=0.705 w=0.36 l=0.15
X368 a_86027_20496# macro_core.data_complement\[7\].complement.Y macro_core.array_and_peripherals.write_driver_7.BL VDD sky130_fd_pr__pfet_01v8 ad=1.4616 pd=10.66 as=1.4616 ps=10.66 w=5.04 l=0.15
X369 a_52637_14191# _46_.X VDD VDD sky130_fd_pr__pfet_01v8_hvt ad=0.05775 pd=0.695 as=0.1092 ps=1.36 w=0.42 l=0.15
X370 VDD a_63067_12283# a_62983_12381# VDD sky130_fd_pr__pfet_01v8_hvt ad=0.1113 pd=1.37 as=0.0882 ps=0.84 w=0.42 l=0.15
X371 macro_core.release_phase.X a_65103_12043# VDD VDD sky130_fd_pr__pfet_01v8_hvt ad=0.475 pd=2.95 as=0.16655 ps=1.39 w=1 l=0.15
X372 a_63627_20496# _48_.A0 macro_core.array_and_peripherals.write_driver_3.BLB VDD sky130_fd_pr__pfet_01v8 ad=1.4616 pd=10.66 as=1.4616 ps=10.66 w=5.04 l=0.15
X373 VDD a_73227_20916# a_75627_20496# VDD sky130_fd_pr__pfet_01v8 ad=1.4616 pd=10.66 as=1.4616 ps=10.66 w=5.04 l=0.15
X374 a_77693_13945# _44_.Y VSS VSS sky130_fd_pr__nfet_01v8 ad=0.1092 pd=1.36 as=0.1449 ps=1.11 w=0.42 l=0.15
X375 VDD a_55429_12857# a_55459_12598# VDD sky130_fd_pr__pfet_01v8_hvt ad=0.0693 pd=0.75 as=0.0441 ps=0.63 w=0.42 l=0.15
X376 VSS a_52301_11769# a_52235_11837# VSS sky130_fd_pr__nfet_01v8 ad=0.1449 pd=1.11 as=0.0693 ps=0.75 w=0.42 l=0.15
X377 VDD _84_.Q _56_.Y VDD sky130_fd_pr__pfet_01v8_hvt ad=0.26 pd=2.52 as=0.135 ps=1.27 w=1 l=0.15
X378 VDD macro_core.evaluation.X macro_core.array_and_peripherals.row_decoder_0.N0 VDD sky130_fd_pr__pfet_01v8 ad=0.3625 pd=3.08 as=0.3625 ps=3.08 w=1.25 l=0.15
X379 a_73215_45974# a_73167_45886# VDD VDD sky130_fd_pr__pfet_01v8 ad=0.1218 pd=1.42 as=0.1218 ps=1.42 w=0.42 l=0.15
X380 a_12749_36833# macro_core.qualify_row\[1\].qualify.A a_12663_36833# VSS sky130_fd_pr__nfet_01v8 ad=0.0567 pd=0.69 as=0.1176 ps=1.4 w=0.42 l=0.15
X381 a_56459_14557# a_55595_14191# a_56202_14303# VDD sky130_fd_pr__pfet_01v8_hvt ad=0.0567 pd=0.69 as=0.1095 ps=1.075 w=0.42 l=0.15
X382 a_49229_9839# a_49063_9839# VDD VDD sky130_fd_pr__pfet_01v8_hvt ad=0.1664 pd=1.8 as=0.0864 ps=0.91 w=0.64 l=0.15
X383 VSS macro_core.evaluation.X a_15233_35745# VSS sky130_fd_pr__nfet_01v8 ad=0.1118 pd=1.04 as=0.0567 ps=0.69 w=0.42 l=0.15
X384 VSS macro_core.write_drive.X a_85227_20916# VSS sky130_fd_pr__nfet_01v8 ad=0.2436 pd=2.26 as=0.2436 ps=2.26 w=0.84 l=0.15
X385 a_68125_14165# _84_.Q VDD VDD sky130_fd_pr__pfet_01v8_hvt ad=0.1176 pd=1.4 as=0.0693 ps=0.75 w=0.42 l=0.15
X386 macro_core.phase_delay\[50\].delay_cell.A macro_core.phase_delay\[49\].delay_cell.A VDD VDD sky130_fd_pr__pfet_01v8_hvt ad=0.26 pd=2.52 as=0.26 ps=2.52 w=1 l=0.15
X387 a_43215_50974# a_43167_50886# VSS VSS sky130_fd_pr__nfet_01v8 ad=0.3654 pd=3.1 as=0.3654 ps=3.1 w=1.26 l=0.15
X388 VSS _90_.A a_59827_10383# VSS sky130_fd_pr__nfet_01v8 ad=0.09813 pd=1.005 as=0.1092 ps=1.36 w=0.42 l=0.15
X389 macro_core.phase_delay\[76\].delay_cell.Y macro_core.phase_delay\[75\].delay_cell.Y VSS VSS sky130_fd_pr__nfet_01v8 ad=0.169 pd=1.82 as=0.169 ps=1.82 w=0.65 l=0.15
X390 VSS macro_core.array_and_peripherals.row_decoder_0.N2 macro_core.qualify_row\[2\].qualify.A VSS sky130_fd_pr__nfet_01v8 ad=0.58 pd=4.58 as=0.58 ps=4.58 w=2 l=0.15
X391 a_50303_14191# _88_.A a_49940_14343# VSS sky130_fd_pr__nfet_01v8 ad=0.0693 pd=0.75 as=0.09975 ps=0.895 w=0.42 l=0.15
X392 a_52700_13255# DATA[1] a_52842_13103# VSS sky130_fd_pr__nfet_01v8 ad=0.09975 pd=0.895 as=0.0693 ps=0.75 w=0.42 l=0.15
X393 a_79215_50974# macro_core.array_and_peripherals.wl_driver_2.WL macro_core.array_and_peripherals.write_driver_6.BL VSS sky130_fd_pr__nfet_01v8 ad=0.174 pd=1.78 as=0.174 ps=1.78 w=0.6 l=0.15
X394 VDD macro_core.precharge_drive.X macro_core.array_and_peripherals.write_driver_7.BLB VDD sky130_fd_pr__pfet_01v8 ad=0.7308 pd=5.62 as=0.7308 ps=5.62 w=2.52 l=0.15
X395 a_61167_50886# macro_core.array_and_peripherals.wl_driver_2.WL macro_core.array_and_peripherals.write_driver_3.BLB VSS sky130_fd_pr__nfet_01v8 ad=0.174 pd=1.78 as=0.174 ps=1.78 w=0.6 l=0.15
X396 a_55761_14191# a_55595_14191# VSS VSS sky130_fd_pr__nfet_01v8 ad=0.1092 pd=1.36 as=0.0567 ps=0.69 w=0.42 l=0.15
X397 a_62201_12015# a_62035_12015# VDD VDD sky130_fd_pr__pfet_01v8_hvt ad=0.1664 pd=1.8 as=0.0864 ps=0.91 w=0.64 l=0.15
X398 a_62600_12015# a_62201_12015# a_62474_12381# VSS sky130_fd_pr__special_nfet_01v8 ad=0.0696 pd=0.765 as=0.0621 ps=0.705 w=0.36 l=0.15
X399 VSS a_72265_14165# a_72199_14191# VSS sky130_fd_pr__nfet_01v8 ad=0.1449 pd=1.11 as=0.0693 ps=0.75 w=0.42 l=0.15
X400 macro_core.phase_delay\[15\].delay_cell.Y macro_core.phase_delay\[14\].delay_cell.Y VSS VSS sky130_fd_pr__nfet_01v8 ad=0.169 pd=1.82 as=0.169 ps=1.82 w=0.65 l=0.15
X401 a_68574_11837# _44_.Y VSS VSS sky130_fd_pr__nfet_01v8 ad=0.0693 pd=0.75 as=0.11285 ps=1.045 w=0.42 l=0.15
X402 a_56202_14303# a_56034_14557# VSS VSS sky130_fd_pr__nfet_01v8 ad=0.0989 pd=0.995 as=0.12095 ps=1.085 w=0.64 l=0.15
X403 a_55429_12857# _84_.Q VDD VDD sky130_fd_pr__pfet_01v8_hvt ad=0.1176 pd=1.4 as=0.0693 ps=0.75 w=0.42 l=0.15
X404 VDD _65_.Y a_74087_14191# VDD sky130_fd_pr__pfet_01v8_hvt ad=0.0864 pd=0.91 as=0.1664 ps=1.8 w=0.64 l=0.15
X405 a_49134_13647# a_48861_13653# a_49049_13647# VDD sky130_fd_pr__pfet_01v8_hvt ad=0.06825 pd=0.745 as=0.05775 ps=0.695 w=0.42 l=0.15
X406 a_49302_13621# a_49134_13647# VDD VDD sky130_fd_pr__pfet_01v8_hvt ad=0.1095 pd=1.075 as=0.17887 ps=1.26 w=0.75 l=0.15
X407 VSS a_55000_12791# _77_.D VSS sky130_fd_pr__nfet_01v8 ad=0.11285 pd=1.045 as=0.169 ps=1.82 w=0.65 l=0.15
X408 a_59508_12791# _40_.A1 a_59650_12925# VSS sky130_fd_pr__nfet_01v8 ad=0.09975 pd=0.895 as=0.0693 ps=0.75 w=0.42 l=0.15
X409 a_59967_12598# _40_.A1 a_59508_12791# VDD sky130_fd_pr__pfet_01v8_hvt ad=0.0441 pd=0.63 as=0.1932 ps=1.34 w=0.42 l=0.15
X410 a_52331_11510# DATA[0] a_51872_11703# VDD sky130_fd_pr__pfet_01v8_hvt ad=0.0441 pd=0.63 as=0.1932 ps=1.34 w=0.42 l=0.15
X411 a_61215_55974# a_61167_55886# VDD VDD sky130_fd_pr__pfet_01v8 ad=0.1218 pd=1.42 as=0.1218 ps=1.42 w=0.42 l=0.15
X412 a_61215_40974# a_61167_40886# VDD VDD sky130_fd_pr__pfet_01v8 ad=0.1218 pd=1.42 as=0.1218 ps=1.42 w=0.42 l=0.15
X413 macro_core.qualify_row\[0\].qualify.X a_15147_37067# VSS VSS sky130_fd_pr__nfet_01v8 ad=0.182 pd=1.86 as=0.1118 ps=1.04 w=0.65 l=0.15
X414 VDD a_58667_12381# a_58835_12283# VDD sky130_fd_pr__pfet_01v8_hvt ad=0.135 pd=1.27 as=0.27 ps=2.54 w=1 l=0.15
X415 VDD macro_core.write_drive.X a_67227_20916# VDD sky130_fd_pr__pfet_01v8 ad=0.2436 pd=2.26 as=0.2436 ps=2.26 w=0.84 l=0.15
X416 VDD a_59571_14459# a_59487_14557# VDD sky130_fd_pr__pfet_01v8_hvt ad=0.1113 pd=1.37 as=0.0882 ps=0.84 w=0.42 l=0.15
X417 VSS a_71836_14343# _80_.D VSS sky130_fd_pr__nfet_01v8 ad=0.11285 pd=1.045 as=0.169 ps=1.82 w=0.65 l=0.15
X418 a_64918_13353# macro_core.phase_delay\[79\].delay_cell.Y a_64836_13353# VDD sky130_fd_pr__pfet_01v8_hvt ad=0.0441 pd=0.63 as=0.1092 ps=1.36 w=0.42 l=0.15
X419 a_73613_12015# _50_.X VSS VSS sky130_fd_pr__nfet_01v8 ad=0.0813 pd=0.83 as=0.1092 ps=1.36 w=0.42 l=0.15
X420 macro_core.phase_delay\[26\].delay_cell.A macro_core.phase_delay\[25\].delay_cell.A VDD VDD sky130_fd_pr__pfet_01v8_hvt ad=0.26 pd=2.52 as=0.26 ps=2.52 w=1 l=0.15
X421 a_52419_12015# a_52081_12337# VSS VSS sky130_fd_pr__nfet_01v8 ad=0.06825 pd=0.86 as=0.2275 ps=2 w=0.65 l=0.15
X422 _44_.Y CSb VSS VSS sky130_fd_pr__nfet_01v8 ad=0.08775 pd=0.92 as=0.08775 ps=0.92 w=0.65 l=0.15
X423 VDD macro_core.phase_delay\[0\].delay_cell.A _66_.Y VDD sky130_fd_pr__pfet_01v8_hvt ad=0.2352 pd=2.24 as=0.1134 ps=1.11 w=0.84 l=0.15
X424 macro_core.phase_delay\[0\].delay_cell.A a_66819_10383# VSS VSS sky130_fd_pr__nfet_01v8 ad=0.0567 pd=0.69 as=0.06825 ps=0.745 w=0.42 l=0.15
X425 VDD a_78155_10107# a_78071_10205# VDD sky130_fd_pr__pfet_01v8_hvt ad=0.1113 pd=1.37 as=0.0882 ps=0.84 w=0.42 l=0.15
X426 VDD macro_core.array_and_peripherals.sense_amp_0.SA_OUTB _43_.A1 VDD sky130_fd_pr__pfet_01v8 ad=0.5481 pd=4.36 as=0.5481 ps=4.36 w=1.89 l=0.15
X427 a_74694_14303# a_74526_14557# VDD VDD sky130_fd_pr__pfet_01v8_hvt ad=0.1095 pd=1.075 as=0.17887 ps=1.26 w=0.75 l=0.15
X428 VSS macro_core.array_and_peripherals.row_decoder_0.N1 macro_core.qualify_row\[1\].qualify.A VSS sky130_fd_pr__nfet_01v8 ad=0.58 pd=4.58 as=0.58 ps=4.58 w=2 l=0.15
X429 VDD _84_.Q _53_.Y VDD sky130_fd_pr__pfet_01v8_hvt ad=0.26 pd=2.52 as=0.135 ps=1.27 w=1 l=0.15
X430 a_63599_14191# macro_core.evaluation.A VDD VDD sky130_fd_pr__pfet_01v8_hvt ad=0.14 pd=1.28 as=0.265 ps=2.53 w=1 l=0.15
X431 a_71739_12015# a_71401_12337# VSS VSS sky130_fd_pr__nfet_01v8 ad=0.06825 pd=0.86 as=0.2275 ps=2 w=0.65 l=0.15
X432 macro_core.phase_delay\[12\].delay_cell.Y macro_core.phase_delay\[11\].delay_cell.Y VSS VSS sky130_fd_pr__nfet_01v8 ad=0.169 pd=1.82 as=0.169 ps=1.82 w=0.65 l=0.15
X433 a_56747_13686# DATA[2] a_56288_13879# VDD sky130_fd_pr__pfet_01v8_hvt ad=0.0441 pd=0.63 as=0.1932 ps=1.34 w=0.42 l=0.15
X434 a_62474_12381# a_62201_12015# a_62389_12015# VDD sky130_fd_pr__pfet_01v8_hvt ad=0.06825 pd=0.745 as=0.05775 ps=0.695 w=0.42 l=0.15
X435 a_68574_11510# _44_.Y VDD VDD sky130_fd_pr__pfet_01v8_hvt ad=0.07665 pd=0.785 as=0.15835 ps=1.395 w=0.42 l=0.15
X436 _38_.A1 macro_core.sense_drive.X macro_core.array_and_peripherals.write_driver_5.BL VDD sky130_fd_pr__pfet_01v8 ad=0.58 pd=4.58 as=0.58 ps=4.58 w=2 l=0.15
X437 a_73615_26902# _38_.A1 macro_core.array_and_peripherals.sense_amp_5.SA_OUTB VSS sky130_fd_pr__nfet_01v8 ad=0.2842 pd=2.54 as=0.2842 ps=2.54 w=0.98 l=0.15
X438 VSS a_78155_10107# a_78113_9839# VSS sky130_fd_pr__nfet_01v8 ad=0.1092 pd=1.36 as=0.066 ps=0.745 w=0.42 l=0.15
X439 a_49215_45974# macro_core.array_and_peripherals.wl_driver_1.WL macro_core.array_and_peripherals.write_driver_1.BL VSS sky130_fd_pr__nfet_01v8 ad=0.174 pd=1.78 as=0.174 ps=1.78 w=0.6 l=0.15
X440 macro_core.array_and_peripherals.write_driver_3.BLB macro_core.sense_drive.X macro_core.array_and_peripherals.sense_amp_3.SA_OUTB VDD sky130_fd_pr__pfet_01v8 ad=0.58 pd=4.58 as=0.58 ps=4.58 w=2 l=0.15
X441 a_74951_14557# a_74253_14191# a_74694_14303# VSS sky130_fd_pr__special_nfet_01v8 ad=0.0684 pd=0.74 as=0.0989 ps=0.995 w=0.36 l=0.15
X442 macro_core.phase_delay\[5\].delay_cell.Y macro_core.phase_delay\[4\].delay_cell.Y VDD VDD sky130_fd_pr__pfet_01v8_hvt ad=0.26 pd=2.52 as=0.26 ps=2.52 w=1 l=0.15
X443 macro_core.phase_delay\[51\].delay_cell.Y macro_core.phase_delay\[51\].delay_cell.A VSS VSS sky130_fd_pr__nfet_01v8 ad=0.169 pd=1.82 as=0.169 ps=1.82 w=0.65 l=0.15
X444 a_79215_40974# a_79167_40886# VDD VDD sky130_fd_pr__pfet_01v8 ad=0.1218 pd=1.42 as=0.1218 ps=1.42 w=0.42 l=0.15
X445 a_75077_14191# a_74087_14191# a_74951_14557# VSS sky130_fd_pr__special_nfet_01v8 ad=0.066 pd=0.745 as=0.0684 ps=0.74 w=0.36 l=0.15
X446 macro_core.phase_delay\[56\].delay_cell.Y macro_core.phase_delay\[55\].delay_cell.Y VDD VDD sky130_fd_pr__pfet_01v8_hvt ad=0.26 pd=2.52 as=0.26 ps=2.52 w=1 l=0.15
X447 VDD a_62912_11703# _48_.X VDD sky130_fd_pr__pfet_01v8_hvt ad=0.15835 pd=1.395 as=0.26 ps=2.52 w=1 l=0.15
X448 a_79215_55974# a_79167_55886# VDD VDD sky130_fd_pr__pfet_01v8 ad=0.1218 pd=1.42 as=0.1218 ps=1.42 w=0.42 l=0.15
X449 macro_core.precharge_phase.X a_64836_13353# VSS VSS sky130_fd_pr__nfet_01v8 ad=0.169 pd=1.82 as=0.10025 ps=0.985 w=0.65 l=0.15
X450 a_75173_10161# _35_.Y VDD VDD sky130_fd_pr__pfet_01v8_hvt ad=0.1664 pd=1.8 as=0.0864 ps=0.91 w=0.64 l=0.15
X451 a_68795_11837# _49_.A0 a_68432_11703# VSS sky130_fd_pr__nfet_01v8 ad=0.0693 pd=0.75 as=0.09975 ps=0.895 w=0.42 l=0.15
X452 _93_.A a_75119_14459# VDD VDD sky130_fd_pr__pfet_01v8_hvt ad=0.26 pd=2.52 as=0.135 ps=1.27 w=1 l=0.15
X453 a_78669_14191# a_78503_14191# VSS VSS sky130_fd_pr__nfet_01v8 ad=0.1092 pd=1.36 as=0.0567 ps=0.69 w=0.42 l=0.15
X454 a_55429_12857# _84_.Q VSS VSS sky130_fd_pr__nfet_01v8 ad=0.1092 pd=1.36 as=0.1449 ps=1.11 w=0.42 l=0.15
X455 a_62201_12015# a_62035_12015# VSS VSS sky130_fd_pr__nfet_01v8 ad=0.1092 pd=1.36 as=0.0567 ps=0.69 w=0.42 l=0.15
X456 a_68432_11703# _49_.A0 a_68574_11510# VDD sky130_fd_pr__pfet_01v8_hvt ad=0.1932 pd=1.34 as=0.07665 ps=0.785 w=0.42 l=0.15
X457 a_85167_55886# a_85215_55974# VSS VSS sky130_fd_pr__nfet_01v8 ad=0.3654 pd=3.1 as=0.3654 ps=3.1 w=1.26 l=0.15
X458 a_85167_40886# a_85215_40974# VSS VSS sky130_fd_pr__nfet_01v8 ad=0.3654 pd=3.1 as=0.3654 ps=3.1 w=1.26 l=0.15
X459 VDD macro_core.array_and_peripherals.row_decoder_0.N2 macro_core.qualify_row\[2\].qualify.A VDD sky130_fd_pr__pfet_01v8 ad=0.87 pd=6.58 as=0.87 ps=6.58 w=3 l=0.15
X460 VDD a_36227_51432# macro_core.array_and_peripherals.wl_driver_2.WL VDD sky130_fd_pr__pfet_01v8 ad=1.4616 pd=10.66 as=1.4616 ps=10.66 w=5.04 l=0.15
X461 VSS a_59937_12857# a_59871_12925# VSS sky130_fd_pr__nfet_01v8 ad=0.1449 pd=1.11 as=0.0693 ps=0.75 w=0.42 l=0.15
X462 a_52301_11769# _44_.Y VSS VSS sky130_fd_pr__nfet_01v8 ad=0.1092 pd=1.36 as=0.1449 ps=1.11 w=0.42 l=0.15
X463 macro_core.phase_delay\[23\].delay_cell.Y macro_core.phase_delay\[23\].delay_cell.A VDD VDD sky130_fd_pr__pfet_01v8_hvt ad=0.26 pd=2.52 as=0.26 ps=2.52 w=1 l=0.15
X464 a_69423_12381# a_68641_12015# a_69339_12381# VDD sky130_fd_pr__pfet_01v8_hvt ad=0.0882 pd=0.84 as=0.0567 ps=0.69 w=0.42 l=0.15
X465 VDD _84_.Q _55_.Y VDD sky130_fd_pr__pfet_01v8_hvt ad=0.26 pd=2.52 as=0.135 ps=1.27 w=1 l=0.15
X466 a_74621_14557# a_74087_14191# a_74526_14557# VDD sky130_fd_pr__pfet_01v8_hvt ad=0.07665 pd=0.785 as=0.06825 ps=0.745 w=0.42 l=0.15
X467 macro_core.phase_delay\[3\].delay_cell.Y macro_core.phase_delay\[2\].delay_cell.Y VDD VDD sky130_fd_pr__pfet_01v8_hvt ad=0.26 pd=2.52 as=0.26 ps=2.52 w=1 l=0.15
X468 VDD a_74291_12283# a_74207_12381# VDD sky130_fd_pr__pfet_01v8_hvt ad=0.1113 pd=1.37 as=0.0882 ps=0.84 w=0.42 l=0.15
X469 a_75792_14343# _37_.A1 a_75934_14191# VSS sky130_fd_pr__nfet_01v8 ad=0.09975 pd=0.895 as=0.0693 ps=0.75 w=0.42 l=0.15
X470 _56_.Y _84_.Q a_59821_9839# VSS sky130_fd_pr__nfet_01v8 ad=0.169 pd=1.82 as=0.08775 ps=0.92 w=0.65 l=0.15
X471 VSS _86_.CLK a_55595_14191# VSS sky130_fd_pr__nfet_01v8 ad=0.0567 pd=0.69 as=0.1092 ps=1.36 w=0.42 l=0.15
X472 VDD _86_.CLK a_62035_12015# VDD sky130_fd_pr__pfet_01v8_hvt ad=0.0864 pd=0.91 as=0.1664 ps=1.8 w=0.64 l=0.15
X473 a_53981_2473# a_53911_2375# _44_.Y VDD sky130_fd_pr__pfet_01v8_hvt ad=0.135 pd=1.27 as=0.32 ps=2.64 w=1 l=0.15
X474 macro_core.phase_delay\[34\].delay_cell.A macro_core.phase_delay\[32\].delay_cell.Y VDD VDD sky130_fd_pr__pfet_01v8_hvt ad=0.26 pd=2.52 as=0.26 ps=2.52 w=1 l=0.15
X475 macro_core.phase_delay\[64\].delay_cell.A macro_core.phase_delay\[63\].delay_cell.A VDD VDD sky130_fd_pr__pfet_01v8_hvt ad=0.26 pd=2.52 as=0.26 ps=2.52 w=1 l=0.15
X476 a_67215_50974# a_67167_50886# VDD VDD sky130_fd_pr__pfet_01v8 ad=0.1218 pd=1.42 as=0.1218 ps=1.42 w=0.42 l=0.15
X477 a_67215_45974# macro_core.array_and_peripherals.wl_driver_1.WL macro_core.array_and_peripherals.write_driver_4.BL VSS sky130_fd_pr__nfet_01v8 ad=0.174 pd=1.78 as=0.174 ps=1.78 w=0.6 l=0.15
X478 a_75934_14191# _84_.Q VSS VSS sky130_fd_pr__nfet_01v8 ad=0.0693 pd=0.75 as=0.11285 ps=1.045 w=0.42 l=0.15
X479 a_63054_11837# _44_.Y VSS VSS sky130_fd_pr__nfet_01v8 ad=0.0693 pd=0.75 as=0.11285 ps=1.045 w=0.42 l=0.15
X480 VDD a_74694_14303# a_74621_14557# VDD sky130_fd_pr__pfet_01v8_hvt ad=0.17887 pd=1.26 as=0.07665 ps=0.785 w=0.42 l=0.15
X481 VDD WEb a_54065_2473# VDD sky130_fd_pr__pfet_01v8_hvt ad=0.14575 pd=1.335 as=0.135 ps=1.27 w=1 l=0.15
X482 a_73167_50886# a_73215_50974# VSS VSS sky130_fd_pr__nfet_01v8 ad=0.3654 pd=3.1 as=0.3654 ps=3.1 w=1.26 l=0.15
X483 a_77795_12381# a_77013_12015# a_77711_12381# VDD sky130_fd_pr__pfet_01v8_hvt ad=0.0882 pd=0.84 as=0.0567 ps=0.69 w=0.42 l=0.15
X484 a_77562_10205# a_77289_9839# a_77477_9839# VDD sky130_fd_pr__pfet_01v8_hvt ad=0.06825 pd=0.745 as=0.05775 ps=0.695 w=0.42 l=0.15
X485 a_67167_45886# a_67215_45974# VDD VDD sky130_fd_pr__pfet_01v8 ad=0.1218 pd=1.42 as=0.1218 ps=1.42 w=0.42 l=0.15
X486 a_58015_16496# _47_.A0 macro_core.array_and_peripherals.write_driver_2.BLB VSS sky130_fd_pr__nfet_01v8 ad=1.4616 pd=10.66 as=1.4616 ps=10.66 w=5.04 l=0.15
X487 VSS macro_core.write_drive.X a_46015_16496# VSS sky130_fd_pr__nfet_01v8 ad=1.4616 pd=10.66 as=1.4616 ps=10.66 w=5.04 l=0.15
X488 macro_core.phase_delay\[46\].delay_cell.Y macro_core.phase_delay\[46\].delay_cell.A VSS VSS sky130_fd_pr__nfet_01v8 ad=0.169 pd=1.82 as=0.169 ps=1.82 w=0.65 l=0.15
X489 VDD macro_core.array_and_peripherals.row_decoder_0.N1 macro_core.qualify_row\[1\].qualify.A VDD sky130_fd_pr__pfet_01v8 ad=0.87 pd=6.58 as=0.87 ps=6.58 w=3 l=0.15
X490 a_71271_13647# a_70573_13653# a_71014_13621# VSS sky130_fd_pr__special_nfet_01v8 ad=0.0684 pd=0.74 as=0.0989 ps=0.995 w=0.36 l=0.15
X491 a_75511_9839# a_75173_10161# VSS VSS sky130_fd_pr__nfet_01v8 ad=0.06825 pd=0.86 as=0.2275 ps=2 w=0.65 l=0.15
X492 VSS a_79110_14303# a_79068_14191# VSS sky130_fd_pr__nfet_01v8 ad=0.12095 pd=1.085 as=0.0696 ps=0.765 w=0.42 l=0.15
X493 a_52301_11769# _44_.Y VDD VDD sky130_fd_pr__pfet_01v8_hvt ad=0.1176 pd=1.4 as=0.0693 ps=0.75 w=0.42 l=0.15
X494 VDD _84_.Q _57_.Y VDD sky130_fd_pr__pfet_01v8_hvt ad=0.26 pd=2.52 as=0.135 ps=1.27 w=1 l=0.15
X495 VDD macro_core.precharge_drive.X macro_core.array_and_peripherals.write_driver_0.BL VDD sky130_fd_pr__pfet_01v8 ad=0.7308 pd=5.62 as=0.7308 ps=5.62 w=2.52 l=0.15
X496 a_50314_3423# a_50146_3677# VDD VDD sky130_fd_pr__pfet_01v8_hvt ad=0.1095 pd=1.075 as=0.17887 ps=1.26 w=0.75 l=0.15
X497 VDD a_50739_3579# a_50655_3677# VDD sky130_fd_pr__pfet_01v8_hvt ad=0.1113 pd=1.37 as=0.0882 ps=0.84 w=0.42 l=0.15
X498 macro_core.phase_delay\[48\].delay_cell.A macro_core.phase_delay\[46\].delay_cell.Y VSS VSS sky130_fd_pr__nfet_01v8 ad=0.169 pd=1.82 as=0.169 ps=1.82 w=0.65 l=0.15
X499 macro_core.phase_delay\[23\].delay_cell.A macro_core.phase_delay\[21\].delay_cell.Y VDD VDD sky130_fd_pr__pfet_01v8_hvt ad=0.26 pd=2.52 as=0.26 ps=2.52 w=1 l=0.15
X500 _45_.A0 a_50187_12283# VDD VDD sky130_fd_pr__pfet_01v8_hvt ad=0.26 pd=2.52 as=0.135 ps=1.27 w=1 l=0.15
X501 a_50314_3423# a_50146_3677# VSS VSS sky130_fd_pr__nfet_01v8 ad=0.0989 pd=0.995 as=0.12095 ps=1.085 w=0.64 l=0.15
X502 a_52173_10161# _87_.TE_B VSS VSS sky130_fd_pr__nfet_01v8 ad=0.2583 pd=2.07 as=0.09813 ps=1.005 w=0.42 l=0.15
X503 a_55215_55974# macro_core.array_and_peripherals.wl_driver_3.WL macro_core.array_and_peripherals.write_driver_2.BL VSS sky130_fd_pr__nfet_01v8 ad=0.174 pd=1.78 as=0.174 ps=1.78 w=0.6 l=0.15
X504 a_55215_40974# macro_core.array_and_peripherals.wl_driver_0.WL macro_core.array_and_peripherals.write_driver_2.BL VSS sky130_fd_pr__nfet_01v8 ad=0.174 pd=1.78 as=0.174 ps=1.78 w=0.6 l=0.15
X505 _53_.Y _34_.Y VDD VDD sky130_fd_pr__pfet_01v8_hvt ad=0.135 pd=1.27 as=0.26 ps=2.52 w=1 l=0.15
X506 VDD a_63599_14191# macro_core.precharge_drive.X VDD sky130_fd_pr__pfet_01v8_hvt ad=0.285 pd=2.57 as=0.14 ps=1.28 w=1 l=0.15
X507 a_63054_11510# _44_.Y VDD VDD sky130_fd_pr__pfet_01v8_hvt ad=0.07665 pd=0.785 as=0.15835 ps=1.395 w=0.42 l=0.15
X508 a_55167_55886# a_55215_55974# VDD VDD sky130_fd_pr__pfet_01v8 ad=0.1218 pd=1.42 as=0.1218 ps=1.42 w=0.42 l=0.15
X509 a_55167_40886# a_55215_40974# VDD VDD sky130_fd_pr__pfet_01v8 ad=0.1218 pd=1.42 as=0.1218 ps=1.42 w=0.42 l=0.15
X510 VDD macro_core.evaluation.X macro_core.array_and_peripherals.row_decoder_0.N2 VDD sky130_fd_pr__pfet_01v8 ad=0.3625 pd=3.08 as=0.3625 ps=3.08 w=1.25 l=0.15
X511 a_74441_14191# _81_.D VDD VDD sky130_fd_pr__pfet_01v8_hvt ad=0.05775 pd=0.695 as=0.1092 ps=1.36 w=0.42 l=0.15
X512 a_48861_13653# a_48695_13653# VSS VSS sky130_fd_pr__nfet_01v8 ad=0.1092 pd=1.36 as=0.0567 ps=0.69 w=0.42 l=0.15
X513 VDD a_49727_13621# a_49643_13647# VDD sky130_fd_pr__pfet_01v8_hvt ad=0.1113 pd=1.37 as=0.0882 ps=0.84 w=0.42 l=0.15
X514 macro_core.phase_delay\[73\].delay_cell.Y macro_core.phase_delay\[72\].delay_cell.Y VDD VDD sky130_fd_pr__pfet_01v8_hvt ad=0.26 pd=2.52 as=0.26 ps=2.52 w=1 l=0.15
X515 VSS macro_core.write_drive.X a_62415_16496# VSS sky130_fd_pr__nfet_01v8 ad=1.4616 pd=10.66 as=1.4616 ps=10.66 w=5.04 l=0.15
X516 a_74415_16496# macro_core.data_complement\[5\].complement.Y macro_core.array_and_peripherals.write_driver_5.BL VSS sky130_fd_pr__nfet_01v8 ad=1.4616 pd=10.66 as=1.4616 ps=10.66 w=5.04 l=0.15
X517 VDD _86_.CLK a_58539_14191# VDD sky130_fd_pr__pfet_01v8_hvt ad=0.0864 pd=0.91 as=0.1664 ps=1.8 w=0.64 l=0.15
X518 a_71836_14343# _92_.A a_71978_14518# VDD sky130_fd_pr__pfet_01v8_hvt ad=0.1932 pd=1.34 as=0.07665 ps=0.785 w=0.42 l=0.15
X519 VSS a_76221_14165# a_76155_14191# VSS sky130_fd_pr__nfet_01v8 ad=0.1449 pd=1.11 as=0.0693 ps=0.75 w=0.42 l=0.15
X520 a_71401_12337# _54_.Y VDD VDD sky130_fd_pr__pfet_01v8_hvt ad=0.1664 pd=1.8 as=0.0864 ps=0.91 w=0.64 l=0.15
X521 a_74123_12381# a_73425_12015# a_73866_12127# VSS sky130_fd_pr__special_nfet_01v8 ad=0.0684 pd=0.74 as=0.0989 ps=0.995 w=0.36 l=0.15
X522 VDD macro_core.evaluation.X a_12663_36833# VDD sky130_fd_pr__pfet_01v8_hvt ad=0.16655 pd=1.39 as=0.0567 ps=0.69 w=0.42 l=0.15
X523 VDD _37_.A1 macro_core.array_and_peripherals.sense_amp_6.SA_OUTB VDD sky130_fd_pr__pfet_01v8 ad=0.5481 pd=4.36 as=0.5481 ps=4.36 w=1.89 l=0.15
X524 VSS a_64611_14191# macro_core.sense_drive.X VSS sky130_fd_pr__nfet_01v8 ad=0.18525 pd=1.87 as=0.091 ps=0.93 w=0.65 l=0.15
X525 VSS a_51872_11703# _45_.X VSS sky130_fd_pr__nfet_01v8 ad=0.11285 pd=1.045 as=0.169 ps=1.82 w=0.65 l=0.15
X526 VSS macro_core.phase_delay\[40\].delay_cell.A a_61842_14191# VSS sky130_fd_pr__nfet_01v8 ad=0.13813 pd=1.075 as=0.06825 ps=0.86 w=0.65 l=0.15
X527 DATA[4] a_66543_12015# a_66899_12265# VDD sky130_fd_pr__pfet_01v8_hvt ad=0.315 pd=2.63 as=0.475 ps=1.95 w=1 l=0.15
X528 VDD a_72449_11989# a_72479_12342# VDD sky130_fd_pr__pfet_01v8_hvt ad=0.0693 pd=0.75 as=0.0441 ps=0.63 w=0.42 l=0.15
X529 a_63275_11837# _48_.A0 a_62912_11703# VSS sky130_fd_pr__nfet_01v8 ad=0.0693 pd=0.75 as=0.09975 ps=0.895 w=0.42 l=0.15
X530 VDD _94_.A a_75007_9839# VDD sky130_fd_pr__pfet_01v8_hvt ad=0.0864 pd=0.91 as=0.1664 ps=1.8 w=0.64 l=0.15
X531 VDD _84_.Q _87_.TE_B VDD sky130_fd_pr__pfet_01v8_hvt ad=0.26 pd=2.52 as=0.135 ps=1.27 w=1 l=0.15
X532 a_61215_45974# a_61167_45886# VSS VSS sky130_fd_pr__nfet_01v8 ad=0.3654 pd=3.1 as=0.3654 ps=3.1 w=1.26 l=0.15
X533 VSS macro_core.write_drive.X a_49227_20916# VSS sky130_fd_pr__nfet_01v8 ad=0.2436 pd=2.26 as=0.2436 ps=2.26 w=0.84 l=0.15
X534 VDD a_74951_14557# a_75119_14459# VDD sky130_fd_pr__pfet_01v8_hvt ad=0.135 pd=1.27 as=0.27 ps=2.54 w=1 l=0.15
X535 a_67683_13647# a_66819_13653# a_67426_13621# VDD sky130_fd_pr__pfet_01v8_hvt ad=0.0567 pd=0.69 as=0.1095 ps=1.075 w=0.42 l=0.15
X536 VSS macro_core.release_phase.X a_64836_13353# VSS sky130_fd_pr__nfet_01v8 ad=0.10025 pd=0.985 as=0.0567 ps=0.69 w=0.42 l=0.15
X537 VSS _86_.CLK a_62035_12015# VSS sky130_fd_pr__nfet_01v8 ad=0.0567 pd=0.69 as=0.1092 ps=1.36 w=0.42 l=0.15
X538 a_62912_11703# _48_.A0 a_63054_11510# VDD sky130_fd_pr__pfet_01v8_hvt ad=0.1932 pd=1.34 as=0.07665 ps=0.785 w=0.42 l=0.15
X539 a_43167_45886# a_43215_45974# VSS VSS sky130_fd_pr__nfet_01v8 ad=0.3654 pd=3.1 as=0.3654 ps=3.1 w=1.26 l=0.15
X540 a_52637_14191# _46_.X VSS VSS sky130_fd_pr__nfet_01v8 ad=0.0813 pd=0.83 as=0.1092 ps=1.36 w=0.42 l=0.15
X541 a_67353_13647# a_66819_13653# a_67258_13647# VDD sky130_fd_pr__pfet_01v8_hvt ad=0.07665 pd=0.785 as=0.06825 ps=0.745 w=0.42 l=0.15
X542 a_76436_9527# _52_.A0 a_76578_9334# VDD sky130_fd_pr__pfet_01v8_hvt ad=0.1932 pd=1.34 as=0.07665 ps=0.785 w=0.42 l=0.15
X543 a_43215_50974# macro_core.array_and_peripherals.wl_driver_2.WL macro_core.array_and_peripherals.write_driver_0.BL VSS sky130_fd_pr__nfet_01v8 ad=0.174 pd=1.78 as=0.174 ps=1.78 w=0.6 l=0.15
X544 a_49134_13647# a_48695_13653# a_49049_13647# VSS sky130_fd_pr__special_nfet_01v8 ad=0.0621 pd=0.705 as=0.0813 ps=0.83 w=0.36 l=0.15
X545 a_49559_13647# a_48861_13653# a_49302_13621# VSS sky130_fd_pr__special_nfet_01v8 ad=0.0684 pd=0.74 as=0.0989 ps=0.995 w=0.36 l=0.15
X546 a_79167_45886# macro_core.array_and_peripherals.wl_driver_1.WL macro_core.array_and_peripherals.write_driver_6.BLB VSS sky130_fd_pr__nfet_01v8 ad=0.174 pd=1.78 as=0.174 ps=1.78 w=0.6 l=0.15
X547 VSS a_59403_14557# a_59571_14459# VSS sky130_fd_pr__nfet_01v8 ad=0.08775 pd=0.92 as=0.169 ps=1.82 w=0.65 l=0.15
X548 VSS macro_core.sense_drive.X a_73615_26902# VSS sky130_fd_pr__nfet_01v8 ad=0.2842 pd=2.54 as=0.2842 ps=2.54 w=0.98 l=0.15
X549 VSS a_77987_10205# a_78155_10107# VSS sky130_fd_pr__nfet_01v8 ad=0.08775 pd=0.92 as=0.169 ps=1.82 w=0.65 l=0.15
X550 a_43167_50886# a_43215_50974# VDD VDD sky130_fd_pr__pfet_01v8 ad=0.1218 pd=1.42 as=0.1218 ps=1.42 w=0.42 l=0.15
X551 VDD a_55227_20916# a_56027_20496# VDD sky130_fd_pr__pfet_01v8 ad=1.4616 pd=10.66 as=1.4616 ps=10.66 w=5.04 l=0.15
X552 a_66709_12337# _55_.Y VDD VDD sky130_fd_pr__pfet_01v8_hvt ad=0.1664 pd=1.8 as=0.0864 ps=0.91 w=0.64 l=0.15
X553 _50_.A0 a_74291_12283# VDD VDD sky130_fd_pr__pfet_01v8_hvt ad=0.26 pd=2.52 as=0.135 ps=1.27 w=1 l=0.15
X554 VDD a_67426_13621# a_67353_13647# VDD sky130_fd_pr__pfet_01v8_hvt ad=0.17887 pd=1.26 as=0.07665 ps=0.785 w=0.42 l=0.15
X555 a_52269_3311# ADDR[0] VDD VDD sky130_fd_pr__pfet_01v8_hvt ad=0.05775 pd=0.695 as=0.1092 ps=1.36 w=0.42 l=0.15
X556 macro_core.phase_delay\[44\].delay_cell.A macro_core.phase_delay\[43\].delay_cell.A VDD VDD sky130_fd_pr__pfet_01v8_hvt ad=0.26 pd=2.52 as=0.26 ps=2.52 w=1 l=0.15
X557 VDD macro_core.phase_delay\[0\].delay_cell.A _63_.Y VDD sky130_fd_pr__pfet_01v8_hvt ad=0.2352 pd=2.24 as=0.1134 ps=1.11 w=0.84 l=0.15
X558 a_73698_12381# a_73259_12015# a_73613_12015# VSS sky130_fd_pr__special_nfet_01v8 ad=0.0621 pd=0.705 as=0.0813 ps=0.83 w=0.36 l=0.15
X559 a_55006_11445# a_54838_11471# VDD VDD sky130_fd_pr__pfet_01v8_hvt ad=0.1095 pd=1.075 as=0.17887 ps=1.26 w=0.75 l=0.15
X560 a_68432_11703# DATA[4] a_68574_11837# VSS sky130_fd_pr__nfet_01v8 ad=0.09975 pd=0.895 as=0.0693 ps=0.75 w=0.42 l=0.15
X561 macro_core.array_and_peripherals.row_decoder_0.EVAL_GND macro_core.array_and_peripherals.row_decoder_0.A0B macro_core.array_and_peripherals.row_decoder_0.net3 VSS sky130_fd_pr__nfet_01v8 ad=0.58 pd=4.58 as=0.58 ps=4.58 w=2 l=0.15
X562 VSS a_56717_13945# a_56651_14013# VSS sky130_fd_pr__nfet_01v8 ad=0.1449 pd=1.11 as=0.0693 ps=0.75 w=0.42 l=0.15
X563 VSS a_63599_14191# macro_core.precharge_drive.X VSS sky130_fd_pr__nfet_01v8 ad=0.091 pd=0.93 as=0.091 ps=0.93 w=0.65 l=0.15
X564 a_79215_45974# a_79167_45886# VSS VSS sky130_fd_pr__nfet_01v8 ad=0.3654 pd=3.1 as=0.3654 ps=3.1 w=1.26 l=0.15
X565 macro_core.array_and_peripherals.write_driver_5.BLB macro_core.precharge_drive.X macro_core.array_and_peripherals.write_driver_5.BL VDD sky130_fd_pr__pfet_01v8 ad=0.7308 pd=5.62 as=0.7308 ps=5.62 w=2.52 l=0.15
X566 _34_.Y CSb VSS VSS sky130_fd_pr__nfet_01v8 ad=0.08775 pd=0.92 as=0.08775 ps=0.92 w=0.65 l=0.15
X567 VDD a_77987_10205# a_78155_10107# VDD sky130_fd_pr__pfet_01v8_hvt ad=0.135 pd=1.27 as=0.27 ps=2.54 w=1 l=0.15
X568 _85_.Q a_52947_3579# VSS VSS sky130_fd_pr__nfet_01v8 ad=0.169 pd=1.82 as=0.08775 ps=0.92 w=0.65 l=0.15
X569 a_80027_20496# macro_core.data_complement\[6\].complement.Y macro_core.array_and_peripherals.write_driver_6.BL VDD sky130_fd_pr__pfet_01v8 ad=1.4616 pd=10.66 as=1.4616 ps=10.66 w=5.04 l=0.15
X570 macro_core.sense_drive.X a_64611_14191# VDD VDD sky130_fd_pr__pfet_01v8_hvt ad=0.14 pd=1.28 as=0.1775 ps=1.355 w=1 l=0.15
X571 a_58157_12015# _78_.D VSS VSS sky130_fd_pr__nfet_01v8 ad=0.0813 pd=0.83 as=0.1092 ps=1.36 w=0.42 l=0.15
X572 macro_core.phase_delay\[38\].delay_cell.Y macro_core.phase_delay\[37\].delay_cell.Y VSS VSS sky130_fd_pr__nfet_01v8 ad=0.169 pd=1.82 as=0.169 ps=1.82 w=0.65 l=0.15
X573 a_76578_9661# _44_.Y VSS VSS sky130_fd_pr__nfet_01v8 ad=0.0693 pd=0.75 as=0.11285 ps=1.045 w=0.42 l=0.15
X574 a_85615_26902# macro_core.array_and_peripherals.sense_amp_7.SA_OUTB _36_.A1 VSS sky130_fd_pr__nfet_01v8 ad=0.2842 pd=2.54 as=0.2842 ps=2.54 w=0.98 l=0.15
X575 a_53231_14557# a_52449_14191# a_53147_14557# VDD sky130_fd_pr__pfet_01v8_hvt ad=0.0882 pd=0.84 as=0.0567 ps=0.69 w=0.42 l=0.15
X576 VDD macro_core.phase_delay\[40\].delay_cell.A a_61642_14191# VDD sky130_fd_pr__pfet_01v8_hvt ad=0.1775 pd=1.355 as=0.14 ps=1.28 w=1 l=0.15
X577 a_70573_13653# a_70407_13653# VDD VDD sky130_fd_pr__pfet_01v8_hvt ad=0.1664 pd=1.8 as=0.0864 ps=0.91 w=0.64 l=0.15
X578 _57_.Y _34_.Y VDD VDD sky130_fd_pr__pfet_01v8_hvt ad=0.135 pd=1.27 as=0.26 ps=2.52 w=1 l=0.15
X579 a_50011_10205# a_49229_9839# a_49927_10205# VDD sky130_fd_pr__pfet_01v8_hvt ad=0.0882 pd=0.84 as=0.0567 ps=0.69 w=0.42 l=0.15
X580 VDD a_50019_12381# a_50187_12283# VDD sky130_fd_pr__pfet_01v8_hvt ad=0.135 pd=1.27 as=0.27 ps=2.54 w=1 l=0.15
X581 macro_core.phase_delay\[70\].delay_cell.Y macro_core.phase_delay\[70\].delay_cell.A VDD VDD sky130_fd_pr__pfet_01v8_hvt ad=0.26 pd=2.52 as=0.26 ps=2.52 w=1 l=0.15
X582 a_77201_12015# _82_.D VSS VSS sky130_fd_pr__nfet_01v8 ad=0.0813 pd=0.83 as=0.1092 ps=1.36 w=0.42 l=0.15
X583 a_58134_9269# a_57966_9295# VSS VSS sky130_fd_pr__nfet_01v8 ad=0.0989 pd=0.995 as=0.12095 ps=1.085 w=0.64 l=0.15
X584 VSS macro_core.qualify_row\[1\].qualify.X a_36227_46432# VSS sky130_fd_pr__nfet_01v8 ad=0.4872 pd=3.94 as=0.4872 ps=3.94 w=1.68 l=0.15
X585 VDD _33_.Y a_49063_9839# VDD sky130_fd_pr__pfet_01v8_hvt ad=0.0864 pd=0.91 as=0.1664 ps=1.8 w=0.64 l=0.15
X586 a_67215_55974# a_67167_55886# VSS VSS sky130_fd_pr__nfet_01v8 ad=0.3654 pd=3.1 as=0.3654 ps=3.1 w=1.26 l=0.15
X587 a_67215_40974# a_67167_40886# VSS VSS sky130_fd_pr__nfet_01v8 ad=0.3654 pd=3.1 as=0.3654 ps=3.1 w=1.26 l=0.15
X588 a_15233_35745# macro_core.qualify_row\[3\].qualify.A a_15147_35745# VSS sky130_fd_pr__nfet_01v8 ad=0.0567 pd=0.69 as=0.1176 ps=1.4 w=0.42 l=0.15
X589 VDD macro_core.precharge_drive.X macro_core.array_and_peripherals.write_driver_6.BLB VDD sky130_fd_pr__pfet_01v8 ad=0.7308 pd=5.62 as=0.7308 ps=5.62 w=2.52 l=0.15
X590 VSS _60_.Y a_48695_13653# VSS sky130_fd_pr__nfet_01v8 ad=0.0567 pd=0.69 as=0.1092 ps=1.36 w=0.42 l=0.15
X591 VSS _92_.A a_71235_12015# VSS sky130_fd_pr__nfet_01v8 ad=0.09813 pd=1.005 as=0.1092 ps=1.36 w=0.42 l=0.15
X592 a_49167_40886# a_49215_40974# VSS VSS sky130_fd_pr__nfet_01v8 ad=0.3654 pd=3.1 as=0.3654 ps=3.1 w=1.26 l=0.15
X593 macro_core.array_and_peripherals.row_decoder_0.EVAL_GND macro_core.array_and_peripherals.row_decoder_0.A0T macro_core.array_and_peripherals.row_decoder_0.net2 VSS sky130_fd_pr__nfet_01v8 ad=0.58 pd=4.58 as=0.58 ps=4.58 w=2 l=0.15
X594 VDD _92_.A a_71235_12015# VDD sky130_fd_pr__pfet_01v8_hvt ad=0.0864 pd=0.91 as=0.1664 ps=1.8 w=0.64 l=0.15
X595 a_49873_3311# a_49707_3311# VSS VSS sky130_fd_pr__nfet_01v8 ad=0.1092 pd=1.36 as=0.0567 ps=0.69 w=0.42 l=0.15
X596 a_49167_55886# a_49215_55974# VSS VSS sky130_fd_pr__nfet_01v8 ad=0.3654 pd=3.1 as=0.3654 ps=3.1 w=1.26 l=0.15
X597 VDD macro_core.qualify_row\[1\].qualify.X a_36227_46432# VDD sky130_fd_pr__pfet_01v8 ad=0.4872 pd=3.94 as=0.4872 ps=3.94 w=1.68 l=0.15
X598 a_12663_36833# macro_core.qualify_row\[1\].qualify.A VDD VDD sky130_fd_pr__pfet_01v8_hvt ad=0.0567 pd=0.69 as=0.1176 ps=1.4 w=0.42 l=0.15
X599 macro_core.qualify_row\[1\].qualify.X a_12663_36833# VDD VDD sky130_fd_pr__pfet_01v8_hvt ad=0.475 pd=2.95 as=0.16655 ps=1.39 w=1 l=0.15
X600 VDD macro_core.evaluation.X a_15147_35745# VDD sky130_fd_pr__pfet_01v8_hvt ad=0.16655 pd=1.39 as=0.0567 ps=0.69 w=0.42 l=0.15
X601 a_57693_9301# a_57527_9301# VDD VDD sky130_fd_pr__pfet_01v8_hvt ad=0.1664 pd=1.8 as=0.0864 ps=0.91 w=0.64 l=0.15
X602 macro_core.phase_delay\[43\].delay_cell.A macro_core.phase_delay\[42\].delay_cell.A VSS VSS sky130_fd_pr__nfet_01v8 ad=0.169 pd=1.82 as=0.169 ps=1.82 w=0.65 l=0.15
X603 a_85167_55886# macro_core.array_and_peripherals.wl_driver_3.WL macro_core.array_and_peripherals.write_driver_7.BLB VSS sky130_fd_pr__nfet_01v8 ad=0.174 pd=1.78 as=0.174 ps=1.78 w=0.6 l=0.15
X604 a_85167_40886# macro_core.array_and_peripherals.wl_driver_0.WL macro_core.array_and_peripherals.write_driver_7.BLB VSS sky130_fd_pr__nfet_01v8 ad=0.174 pd=1.78 as=0.174 ps=1.78 w=0.6 l=0.15
X605 a_76221_14165# _84_.Q VSS VSS sky130_fd_pr__nfet_01v8 ad=0.1092 pd=1.36 as=0.1449 ps=1.11 w=0.42 l=0.15
X606 a_49927_10205# a_49229_9839# a_49670_9951# VSS sky130_fd_pr__special_nfet_01v8 ad=0.0684 pd=0.74 as=0.0989 ps=0.995 w=0.36 l=0.15
X607 macro_core.phase_delay\[21\].delay_cell.A macro_core.phase_delay\[19\].delay_cell.Y VDD VDD sky130_fd_pr__pfet_01v8_hvt ad=0.26 pd=2.52 as=0.26 ps=2.52 w=1 l=0.15
X608 a_60331_10703# a_59993_10383# VSS VSS sky130_fd_pr__nfet_01v8 ad=0.06825 pd=0.86 as=0.2275 ps=2 w=0.65 l=0.15
X609 VSS a_68861_11769# a_68795_11837# VSS sky130_fd_pr__nfet_01v8 ad=0.1449 pd=1.11 as=0.0693 ps=0.75 w=0.42 l=0.15
X610 VDD a_85227_20916# a_87627_20496# VDD sky130_fd_pr__pfet_01v8 ad=1.4616 pd=10.66 as=1.4616 ps=10.66 w=5.04 l=0.15
X611 a_64836_13353# macro_core.phase_delay\[79\].delay_cell.Y VSS VSS sky130_fd_pr__nfet_01v8 ad=0.0567 pd=0.69 as=0.1092 ps=1.36 w=0.42 l=0.15
X612 macro_core.phase_delay\[53\].delay_cell.Y macro_core.phase_delay\[53\].delay_cell.A VSS VSS sky130_fd_pr__nfet_01v8 ad=0.169 pd=1.82 as=0.169 ps=1.82 w=0.65 l=0.15
X613 a_75627_20496# _50_.A0 macro_core.array_and_peripherals.write_driver_5.BLB VDD sky130_fd_pr__pfet_01v8 ad=1.4616 pd=10.66 as=1.4616 ps=10.66 w=5.04 l=0.15
X614 VSS a_58134_9269# a_58092_9673# VSS sky130_fd_pr__nfet_01v8 ad=0.12095 pd=1.085 as=0.0696 ps=0.765 w=0.42 l=0.15
X615 VSS macro_core.evaluation.X a_15233_37067# VSS sky130_fd_pr__nfet_01v8 ad=0.1118 pd=1.04 as=0.0567 ps=0.69 w=0.42 l=0.15
X616 VDD macro_core.write_drive.X a_61227_20916# VDD sky130_fd_pr__pfet_01v8 ad=0.2436 pd=2.26 as=0.2436 ps=2.26 w=0.84 l=0.15
X617 VSS _89_.A a_55687_10383# VSS sky130_fd_pr__nfet_01v8 ad=0.09813 pd=1.005 as=0.1092 ps=1.36 w=0.42 l=0.15
X618 a_85215_45974# a_85167_45886# VDD VDD sky130_fd_pr__pfet_01v8 ad=0.1218 pd=1.42 as=0.1218 ps=1.42 w=0.42 l=0.15
X619 VSS _85_.Q macro_core.array_and_peripherals.row_decoder_0.A0B VSS sky130_fd_pr__nfet_01v8 ad=0.2436 pd=2.26 as=0.2436 ps=2.26 w=0.84 l=0.15
X620 a_72265_14165# _84_.Q VSS VSS sky130_fd_pr__nfet_01v8 ad=0.1092 pd=1.36 as=0.1449 ps=1.11 w=0.42 l=0.15
X621 macro_core.phase_delay\[1\].delay_cell.Y macro_core.phase_delay\[1\].delay_cell.A VSS VSS sky130_fd_pr__nfet_01v8 ad=0.169 pd=1.82 as=0.169 ps=1.82 w=0.65 l=0.15
X622 a_60183_10383# _56_.Y VDD VDD sky130_fd_pr__pfet_01v8_hvt ad=0.475 pd=1.95 as=0.27 ps=2.54 w=1 l=0.15
X623 VDD _86_.CLK _61_.Y VDD sky130_fd_pr__pfet_01v8_hvt ad=0.2352 pd=2.24 as=0.1134 ps=1.11 w=0.84 l=0.15
X624 a_49229_9839# a_49063_9839# VSS VSS sky130_fd_pr__nfet_01v8 ad=0.1092 pd=1.36 as=0.0567 ps=0.69 w=0.42 l=0.15
X625 a_55215_50974# a_55167_50886# VSS VSS sky130_fd_pr__nfet_01v8 ad=0.3654 pd=3.1 as=0.3654 ps=3.1 w=1.26 l=0.15
X626 VDD a_49940_14343# _76_.D VDD sky130_fd_pr__pfet_01v8_hvt ad=0.15835 pd=1.395 as=0.26 ps=2.52 w=1 l=0.15
X627 a_62642_12127# a_62474_12381# VSS VSS sky130_fd_pr__nfet_01v8 ad=0.0989 pd=0.995 as=0.12095 ps=1.085 w=0.64 l=0.15
X628 macro_core.phase_delay\[19\].delay_cell.Y macro_core.phase_delay\[18\].delay_cell.Y VSS VSS sky130_fd_pr__nfet_01v8 ad=0.169 pd=1.82 as=0.169 ps=1.82 w=0.65 l=0.15
X629 macro_core.phase_delay\[62\].delay_cell.A macro_core.phase_delay\[61\].delay_cell.A VSS VSS sky130_fd_pr__nfet_01v8 ad=0.169 pd=1.82 as=0.169 ps=1.82 w=0.65 l=0.15
X630 a_58134_9269# a_57966_9295# VDD VDD sky130_fd_pr__pfet_01v8_hvt ad=0.1095 pd=1.075 as=0.17887 ps=1.26 w=0.75 l=0.15
X631 a_73167_50886# macro_core.array_and_peripherals.wl_driver_2.WL macro_core.array_and_peripherals.write_driver_5.BLB VSS sky130_fd_pr__nfet_01v8 ad=0.174 pd=1.78 as=0.174 ps=1.78 w=0.6 l=0.15
X632 _63_.Y macro_core.phase_delay\[0\].delay_cell.A VDD VDD sky130_fd_pr__pfet_01v8_hvt ad=0.1134 pd=1.11 as=0.2184 ps=2.2 w=0.84 l=0.15
X633 macro_core.phase_delay\[66\].delay_cell.Y macro_core.phase_delay\[65\].delay_cell.Y VDD VDD sky130_fd_pr__pfet_01v8_hvt ad=0.26 pd=2.52 as=0.26 ps=2.52 w=1 l=0.15
X634 a_64611_14191# _84_.Q VDD VDD sky130_fd_pr__pfet_01v8_hvt ad=0.14 pd=1.28 as=0.265 ps=2.53 w=1 l=0.15
X635 a_67838_14518# _84_.Q VDD VDD sky130_fd_pr__pfet_01v8_hvt ad=0.07665 pd=0.785 as=0.15835 ps=1.395 w=0.42 l=0.15
X636 a_62912_11703# DATA[3] a_63054_11837# VSS sky130_fd_pr__nfet_01v8 ad=0.09975 pd=0.895 as=0.0693 ps=0.75 w=0.42 l=0.15
X637 macro_core.phase_delay\[17\].delay_cell.Y macro_core.phase_delay\[16\].delay_cell.Y VDD VDD sky130_fd_pr__pfet_01v8_hvt ad=0.26 pd=2.52 as=0.26 ps=2.52 w=1 l=0.15
X638 VDD a_59403_14557# a_59571_14459# VDD sky130_fd_pr__pfet_01v8_hvt ad=0.135 pd=1.27 as=0.27 ps=2.54 w=1 l=0.15
X639 a_79110_14303# a_78942_14557# VDD VDD sky130_fd_pr__pfet_01v8_hvt ad=0.1095 pd=1.075 as=0.17887 ps=1.26 w=0.75 l=0.15
X640 a_68891_11510# DATA[4] a_68432_11703# VDD sky130_fd_pr__pfet_01v8_hvt ad=0.0441 pd=0.63 as=0.1932 ps=1.34 w=0.42 l=0.15
X641 VDD macro_core.evaluation.X macro_core.array_and_peripherals.row_decoder_0.N3 VDD sky130_fd_pr__pfet_01v8 ad=0.3625 pd=3.08 as=0.3625 ps=3.08 w=1.25 l=0.15
X642 a_50145_12015# a_49155_12015# a_50019_12381# VSS sky130_fd_pr__special_nfet_01v8 ad=0.066 pd=0.745 as=0.0684 ps=0.74 w=0.36 l=0.15
X643 a_73215_40974# a_73167_40886# VDD VDD sky130_fd_pr__pfet_01v8 ad=0.1218 pd=1.42 as=0.1218 ps=1.42 w=0.42 l=0.15
X644 _91_.A a_67851_13621# VSS VSS sky130_fd_pr__nfet_01v8 ad=0.169 pd=1.82 as=0.08775 ps=0.92 w=0.65 l=0.15
X645 _91_.A a_67851_13621# VDD VDD sky130_fd_pr__pfet_01v8_hvt ad=0.26 pd=2.52 as=0.135 ps=1.27 w=1 l=0.15
X646 a_54964_11849# a_54565_11477# a_54838_11471# VSS sky130_fd_pr__special_nfet_01v8 ad=0.0696 pd=0.765 as=0.0621 ps=0.705 w=0.36 l=0.15
X647 a_52363_10089# _87_.TE_B VDD VDD sky130_fd_pr__pfet_01v8_hvt ad=0.475 pd=1.95 as=0.27 ps=2.54 w=1 l=0.15
X648 a_73215_55974# a_73167_55886# VDD VDD sky130_fd_pr__pfet_01v8 ad=0.1218 pd=1.42 as=0.1218 ps=1.42 w=0.42 l=0.15
X649 VDD macro_core.write_drive.X a_79227_20916# VDD sky130_fd_pr__pfet_01v8 ad=0.2436 pd=2.26 as=0.2436 ps=2.26 w=0.84 l=0.15
X650 macro_core.phase_delay\[41\].delay_cell.A macro_core.phase_delay\[40\].delay_cell.A VSS VSS sky130_fd_pr__nfet_01v8 ad=0.169 pd=1.82 as=0.169 ps=1.82 w=0.65 l=0.15
X651 a_53147_14557# a_52283_14191# a_52890_14303# VDD sky130_fd_pr__pfet_01v8_hvt ad=0.0567 pd=0.69 as=0.1095 ps=1.075 w=0.42 l=0.15
X652 VDD _64_.Y a_70407_13653# VDD sky130_fd_pr__pfet_01v8_hvt ad=0.0864 pd=0.91 as=0.1664 ps=1.8 w=0.64 l=0.15
X653 VDD a_58391_9295# a_58559_9269# VDD sky130_fd_pr__pfet_01v8_hvt ad=0.135 pd=1.27 as=0.27 ps=2.54 w=1 l=0.15
X654 macro_core.phase_delay\[28\].delay_cell.A macro_core.phase_delay\[26\].delay_cell.Y VSS VSS sky130_fd_pr__nfet_01v8 ad=0.169 pd=1.82 as=0.169 ps=1.82 w=0.65 l=0.15
X655 macro_core.phase_delay\[78\].delay_cell.Y macro_core.phase_delay\[77\].delay_cell.Y VDD VDD sky130_fd_pr__pfet_01v8_hvt ad=0.26 pd=2.52 as=0.26 ps=2.52 w=1 l=0.15
X656 _64_.Y macro_core.phase_delay\[0\].delay_cell.A VDD VDD sky130_fd_pr__pfet_01v8_hvt ad=0.1134 pd=1.11 as=0.2184 ps=2.2 w=0.84 l=0.15
X657 a_71397_14025# a_70407_13653# a_71271_13647# VSS sky130_fd_pr__special_nfet_01v8 ad=0.066 pd=0.745 as=0.0684 ps=0.74 w=0.36 l=0.15
X658 macro_core.phase_delay\[74\].delay_cell.Y macro_core.phase_delay\[73\].delay_cell.Y VDD VDD sky130_fd_pr__pfet_01v8_hvt ad=0.26 pd=2.52 as=0.26 ps=2.52 w=1 l=0.15
X659 a_49927_10205# a_49063_9839# a_49670_9951# VDD sky130_fd_pr__pfet_01v8_hvt ad=0.0567 pd=0.69 as=0.1095 ps=1.075 w=0.42 l=0.15
X660 a_49597_10205# a_49063_9839# a_49502_10205# VDD sky130_fd_pr__pfet_01v8_hvt ad=0.07665 pd=0.785 as=0.06825 ps=0.745 w=0.42 l=0.15
X661 VDD _43_.A1 macro_core.array_and_peripherals.sense_amp_0.SA_OUTB VDD sky130_fd_pr__pfet_01v8 ad=0.5481 pd=4.36 as=0.5481 ps=4.36 w=1.89 l=0.15
X662 VDD macro_core.array_and_peripherals.sense_amp_2.SA_OUTB _41_.A1 VDD sky130_fd_pr__pfet_01v8 ad=0.5481 pd=4.36 as=0.5481 ps=4.36 w=1.89 l=0.15
X663 a_52081_12337# _58_.Y VSS VSS sky130_fd_pr__nfet_01v8 ad=0.2583 pd=2.07 as=0.09813 ps=1.005 w=0.42 l=0.15
X664 a_52863_3677# a_52081_3311# a_52779_3677# VDD sky130_fd_pr__pfet_01v8_hvt ad=0.0882 pd=0.84 as=0.0567 ps=0.69 w=0.42 l=0.15
X665 a_57966_9295# a_57527_9301# a_57881_9295# VSS sky130_fd_pr__special_nfet_01v8 ad=0.0621 pd=0.705 as=0.0813 ps=0.83 w=0.36 l=0.15
X666 a_52271_12265# _58_.Y VDD VDD sky130_fd_pr__pfet_01v8_hvt ad=0.475 pd=1.95 as=0.27 ps=2.54 w=1 l=0.15
X667 a_75547_12265# _53_.Y VDD VDD sky130_fd_pr__pfet_01v8_hvt ad=0.475 pd=1.95 as=0.27 ps=2.54 w=1 l=0.15
X668 VSS a_71439_13621# a_71397_14025# VSS sky130_fd_pr__nfet_01v8 ad=0.1092 pd=1.36 as=0.066 ps=0.745 w=0.42 l=0.15
X669 DATA[5] a_71235_12015# a_71591_12265# VDD sky130_fd_pr__pfet_01v8_hvt ad=0.315 pd=2.63 as=0.475 ps=1.95 w=1 l=0.15
X670 a_52890_14303# a_52722_14557# VSS VSS sky130_fd_pr__nfet_01v8 ad=0.0989 pd=0.995 as=0.12095 ps=1.085 w=0.64 l=0.15
X671 a_68155_14518# _39_.A1 a_67696_14343# VDD sky130_fd_pr__pfet_01v8_hvt ad=0.0441 pd=0.63 as=0.1932 ps=1.34 w=0.42 l=0.15
X672 a_61215_50974# a_61167_50886# VDD VDD sky130_fd_pr__pfet_01v8 ad=0.1218 pd=1.42 as=0.1218 ps=1.42 w=0.42 l=0.15
X673 a_85615_26902# _36_.A1 macro_core.array_and_peripherals.sense_amp_7.SA_OUTB VSS sky130_fd_pr__nfet_01v8 ad=0.2842 pd=2.54 as=0.2842 ps=2.54 w=0.98 l=0.15
X674 a_52722_14557# a_52283_14191# a_52637_14191# VSS sky130_fd_pr__special_nfet_01v8 ad=0.0621 pd=0.705 as=0.0813 ps=0.83 w=0.36 l=0.15
X675 a_74441_14191# _81_.D VSS VSS sky130_fd_pr__nfet_01v8 ad=0.0813 pd=0.83 as=0.1092 ps=1.36 w=0.42 l=0.15
X676 VSS a_69082_12127# a_69040_12015# VSS sky130_fd_pr__nfet_01v8 ad=0.12095 pd=1.085 as=0.0696 ps=0.765 w=0.42 l=0.15
X677 macro_core.phase_delay\[18\].delay_cell.Y macro_core.phase_delay\[17\].delay_cell.Y VSS VSS sky130_fd_pr__nfet_01v8 ad=0.169 pd=1.82 as=0.169 ps=1.82 w=0.65 l=0.15
X678 a_61215_45974# macro_core.array_and_peripherals.wl_driver_1.WL macro_core.array_and_peripherals.write_driver_3.BL VSS sky130_fd_pr__nfet_01v8 ad=0.174 pd=1.78 as=0.174 ps=1.78 w=0.6 l=0.15
X679 macro_core.array_and_peripherals.write_driver_5.BLB macro_core.sense_drive.X macro_core.array_and_peripherals.sense_amp_5.SA_OUTB VDD sky130_fd_pr__pfet_01v8 ad=0.58 pd=4.58 as=0.58 ps=4.58 w=2 l=0.15
X680 _36_.A1 macro_core.sense_drive.X macro_core.array_and_peripherals.write_driver_7.BL VDD sky130_fd_pr__pfet_01v8 ad=0.58 pd=4.58 as=0.58 ps=4.58 w=2 l=0.15
X681 a_43167_45886# macro_core.array_and_peripherals.wl_driver_1.WL macro_core.array_and_peripherals.write_driver_0.BLB VSS sky130_fd_pr__nfet_01v8 ad=0.174 pd=1.78 as=0.174 ps=1.78 w=0.6 l=0.15
X682 VSS macro_core.phase_delay\[0\].delay_cell.A _64_.Y VSS sky130_fd_pr__nfet_01v8 ad=0.1197 pd=1.41 as=0.1092 ps=1.36 w=0.42 l=0.15
X683 a_58391_9295# a_57527_9301# a_58134_9269# VDD sky130_fd_pr__pfet_01v8_hvt ad=0.0567 pd=0.69 as=0.1095 ps=1.075 w=0.42 l=0.15
X684 VDD clkbuf_0_CLK.X a_66819_10383# VDD sky130_fd_pr__pfet_01v8_hvt ad=0.1625 pd=1.325 as=0.265 ps=2.53 w=1 l=0.15
X685 VDD a_79535_14459# a_79451_14557# VDD sky130_fd_pr__pfet_01v8_hvt ad=0.1113 pd=1.37 as=0.0882 ps=0.84 w=0.42 l=0.15
X686 macro_core.phase_delay\[61\].delay_cell.A macro_core.phase_delay\[59\].delay_cell.Y VDD VDD sky130_fd_pr__pfet_01v8_hvt ad=0.26 pd=2.52 as=0.26 ps=2.52 w=1 l=0.15
X687 VSS a_63341_11769# a_63275_11837# VSS sky130_fd_pr__nfet_01v8 ad=0.1449 pd=1.11 as=0.0693 ps=0.75 w=0.42 l=0.15
X688 a_61167_45886# a_61215_45974# VDD VDD sky130_fd_pr__pfet_01v8 ad=0.1218 pd=1.42 as=0.1218 ps=1.42 w=0.42 l=0.15
X689 a_52015_16496# _46_.A0 macro_core.array_and_peripherals.write_driver_1.BLB VSS sky130_fd_pr__nfet_01v8 ad=1.4616 pd=10.66 as=1.4616 ps=10.66 w=5.04 l=0.15
X690 a_58242_12381# a_57969_12015# a_58157_12015# VDD sky130_fd_pr__pfet_01v8_hvt ad=0.06825 pd=0.745 as=0.05775 ps=0.695 w=0.42 l=0.15
X691 a_74249_12015# a_73259_12015# a_74123_12381# VSS sky130_fd_pr__special_nfet_01v8 ad=0.066 pd=0.745 as=0.0684 ps=0.74 w=0.36 l=0.15
X692 a_55000_12791# _41_.A1 a_55142_12925# VSS sky130_fd_pr__nfet_01v8 ad=0.09975 pd=0.895 as=0.0693 ps=0.75 w=0.42 l=0.15
X693 a_55459_12598# _41_.A1 a_55000_12791# VDD sky130_fd_pr__pfet_01v8_hvt ad=0.0441 pd=0.63 as=0.1932 ps=1.34 w=0.42 l=0.15
X694 _75_.Q a_50095_10107# VDD VDD sky130_fd_pr__pfet_01v8_hvt ad=0.26 pd=2.52 as=0.135 ps=1.27 w=1 l=0.15
X695 a_52354_3677# a_51915_3311# a_52269_3311# VSS sky130_fd_pr__special_nfet_01v8 ad=0.0621 pd=0.705 as=0.0813 ps=0.83 w=0.36 l=0.15
X696 VSS _75_.Q a_52007_9839# VSS sky130_fd_pr__nfet_01v8 ad=0.09813 pd=1.005 as=0.1092 ps=1.36 w=0.42 l=0.15
X697 DATA[2] a_55687_10383# a_56043_10383# VDD sky130_fd_pr__pfet_01v8_hvt ad=0.315 pd=2.63 as=0.475 ps=1.95 w=1 l=0.15
X698 VDD a_68861_11769# a_68891_11510# VDD sky130_fd_pr__pfet_01v8_hvt ad=0.0693 pd=0.75 as=0.0441 ps=0.63 w=0.42 l=0.15
X699 _90_.A a_58835_12283# VDD VDD sky130_fd_pr__pfet_01v8_hvt ad=0.26 pd=2.52 as=0.135 ps=1.27 w=1 l=0.15
X700 DATA[7] a_75007_9839# a_75511_9839# VSS sky130_fd_pr__nfet_01v8 ad=0.286 pd=2.18 as=0.06825 ps=0.86 w=0.65 l=0.15
X701 a_49215_55974# macro_core.array_and_peripherals.wl_driver_3.WL macro_core.array_and_peripherals.write_driver_1.BL VSS sky130_fd_pr__nfet_01v8 ad=0.174 pd=1.78 as=0.174 ps=1.78 w=0.6 l=0.15
X702 a_49215_40974# macro_core.array_and_peripherals.wl_driver_0.WL macro_core.array_and_peripherals.write_driver_1.BL VSS sky130_fd_pr__nfet_01v8 ad=0.174 pd=1.78 as=0.174 ps=1.78 w=0.6 l=0.15
X703 VSS _86_.CLK _62_.Y VSS sky130_fd_pr__nfet_01v8 ad=0.1197 pd=1.41 as=0.1092 ps=1.36 w=0.42 l=0.15
X704 VDD _86_.CLK a_49707_3311# VDD sky130_fd_pr__pfet_01v8_hvt ad=0.0864 pd=0.91 as=0.1664 ps=1.8 w=0.64 l=0.15
X705 a_69009_12381# a_68475_12015# a_68914_12381# VDD sky130_fd_pr__pfet_01v8_hvt ad=0.07665 pd=0.785 as=0.06825 ps=0.745 w=0.42 l=0.15
X706 a_79215_50974# a_79167_50886# VDD VDD sky130_fd_pr__pfet_01v8 ad=0.1218 pd=1.42 as=0.1218 ps=1.42 w=0.42 l=0.15
X707 a_58242_12381# a_57803_12015# a_58157_12015# VSS sky130_fd_pr__special_nfet_01v8 ad=0.0621 pd=0.705 as=0.0813 ps=0.83 w=0.36 l=0.15
X708 VDD _93_.A a_75191_12015# VDD sky130_fd_pr__pfet_01v8_hvt ad=0.0864 pd=0.91 as=0.1664 ps=1.8 w=0.64 l=0.15
X709 VSS _93_.A a_75191_12015# VSS sky130_fd_pr__nfet_01v8 ad=0.09813 pd=1.005 as=0.1092 ps=1.36 w=0.42 l=0.15
X710 a_44027_20496# macro_core.data_complement\[0\].complement.Y macro_core.array_and_peripherals.write_driver_0.BL VDD sky130_fd_pr__pfet_01v8 ad=1.4616 pd=10.66 as=1.4616 ps=10.66 w=5.04 l=0.15
X711 a_52449_3677# a_51915_3311# a_52354_3677# VDD sky130_fd_pr__pfet_01v8_hvt ad=0.07665 pd=0.785 as=0.06825 ps=0.745 w=0.42 l=0.15
X712 a_85167_50886# a_85215_50974# VSS VSS sky130_fd_pr__nfet_01v8 ad=0.3654 pd=3.1 as=0.3654 ps=3.1 w=1.26 l=0.15
X713 a_49615_26902# macro_core.array_and_peripherals.sense_amp_1.SA_OUTB _42_.A1 VSS sky130_fd_pr__nfet_01v8 ad=0.2842 pd=2.54 as=0.2842 ps=2.54 w=0.98 l=0.15
X714 VDD a_77264_13879# _51_.X VDD sky130_fd_pr__pfet_01v8_hvt ad=0.15835 pd=1.395 as=0.26 ps=2.52 w=1 l=0.15
X715 _94_.A a_77879_12283# VDD VDD sky130_fd_pr__pfet_01v8_hvt ad=0.26 pd=2.52 as=0.135 ps=1.27 w=1 l=0.15
X716 a_52480_3311# a_52081_3311# a_52354_3677# VSS sky130_fd_pr__special_nfet_01v8 ad=0.0696 pd=0.765 as=0.0621 ps=0.705 w=0.36 l=0.15
X717 a_63371_11510# DATA[3] a_62912_11703# VDD sky130_fd_pr__pfet_01v8_hvt ad=0.0441 pd=0.63 as=0.1932 ps=1.34 w=0.42 l=0.15
X718 a_79167_45886# a_79215_45974# VDD VDD sky130_fd_pr__pfet_01v8 ad=0.1218 pd=1.42 as=0.1218 ps=1.42 w=0.42 l=0.15
X719 VDD a_59508_12791# _78_.D VDD sky130_fd_pr__pfet_01v8_hvt ad=0.15835 pd=1.395 as=0.26 ps=2.52 w=1 l=0.15
X720 a_77289_9839# a_77123_9839# VSS VSS sky130_fd_pr__nfet_01v8 ad=0.1092 pd=1.36 as=0.0567 ps=0.69 w=0.42 l=0.15
X721 VSS macro_core.write_drive.X a_58015_16496# VSS sky130_fd_pr__nfet_01v8 ad=1.4616 pd=10.66 as=1.4616 ps=10.66 w=5.04 l=0.15
X722 a_70015_16496# _49_.A0 macro_core.array_and_peripherals.write_driver_4.BLB VSS sky130_fd_pr__nfet_01v8 ad=1.4616 pd=10.66 as=1.4616 ps=10.66 w=5.04 l=0.15
X723 VDD a_75792_14343# _81_.D VDD sky130_fd_pr__pfet_01v8_hvt ad=0.15835 pd=1.395 as=0.26 ps=2.52 w=1 l=0.15
X724 a_54838_11471# a_54565_11477# a_54753_11471# VDD sky130_fd_pr__pfet_01v8_hvt ad=0.06825 pd=0.745 as=0.05775 ps=0.695 w=0.42 l=0.15
X725 VSS macro_core.write_drive.X a_43227_20916# VSS sky130_fd_pr__nfet_01v8 ad=0.2436 pd=2.26 as=0.2436 ps=2.26 w=0.84 l=0.15
X726 a_77286_12381# a_76847_12015# a_77201_12015# VSS sky130_fd_pr__special_nfet_01v8 ad=0.0621 pd=0.705 as=0.0813 ps=0.83 w=0.36 l=0.15
X727 _51_.A0 a_79535_14459# VSS VSS sky130_fd_pr__nfet_01v8 ad=0.169 pd=1.82 as=0.08775 ps=0.92 w=0.65 l=0.15
X728 VDD macro_core.precharge_drive.X macro_core.array_and_peripherals.write_driver_2.BL VDD sky130_fd_pr__pfet_01v8 ad=0.7308 pd=5.62 as=0.7308 ps=5.62 w=2.52 l=0.15
X729 a_71014_13621# a_70846_13647# VDD VDD sky130_fd_pr__pfet_01v8_hvt ad=0.1095 pd=1.075 as=0.17887 ps=1.26 w=0.75 l=0.15
X730 VDD macro_core.precharge_drive.X macro_core.array_and_peripherals.write_driver_0.BLB VDD sky130_fd_pr__pfet_01v8 ad=0.7308 pd=5.62 as=0.7308 ps=5.62 w=2.52 l=0.15
X731 VSS a_55429_12857# a_55363_12925# VSS sky130_fd_pr__nfet_01v8 ad=0.1449 pd=1.11 as=0.0693 ps=0.75 w=0.42 l=0.15
X732 macro_core.phase_delay\[71\].delay_cell.Y macro_core.phase_delay\[70\].delay_cell.Y VDD VDD sky130_fd_pr__pfet_01v8_hvt ad=0.26 pd=2.52 as=0.26 ps=2.52 w=1 l=0.15
X733 a_67215_55974# macro_core.array_and_peripherals.wl_driver_3.WL macro_core.array_and_peripherals.write_driver_4.BL VSS sky130_fd_pr__nfet_01v8 ad=0.174 pd=1.78 as=0.174 ps=1.78 w=0.6 l=0.15
X734 a_67215_40974# macro_core.array_and_peripherals.wl_driver_0.WL macro_core.array_and_peripherals.write_driver_4.BL VSS sky130_fd_pr__nfet_01v8 ad=0.174 pd=1.78 as=0.174 ps=1.78 w=0.6 l=0.15
X735 macro_core.precharge_drive.X a_63599_14191# VDD VDD sky130_fd_pr__pfet_01v8_hvt ad=0.14 pd=1.28 as=0.1775 ps=1.355 w=1 l=0.15
X736 VDD a_49227_20916# a_50027_20496# VDD sky130_fd_pr__pfet_01v8 ad=1.4616 pd=10.66 as=1.4616 ps=10.66 w=5.04 l=0.15
X737 VSS _86_.CLK a_52283_14191# VSS sky130_fd_pr__nfet_01v8 ad=0.0567 pd=0.69 as=0.1092 ps=1.36 w=0.42 l=0.15
X738 a_59146_14303# a_58978_14557# VDD VDD sky130_fd_pr__pfet_01v8_hvt ad=0.1095 pd=1.075 as=0.17887 ps=1.26 w=0.75 l=0.15
X739 a_78942_14557# a_78669_14191# a_78857_14191# VDD sky130_fd_pr__pfet_01v8_hvt ad=0.06825 pd=0.745 as=0.05775 ps=0.695 w=0.42 l=0.15
X740 a_49509_12015# _45_.X VDD VDD sky130_fd_pr__pfet_01v8_hvt ad=0.05775 pd=0.695 as=0.1092 ps=1.36 w=0.42 l=0.15
X741 a_67167_55886# a_67215_55974# VDD VDD sky130_fd_pr__pfet_01v8 ad=0.1218 pd=1.42 as=0.1218 ps=1.42 w=0.42 l=0.15
X742 a_67167_40886# a_67215_40974# VDD VDD sky130_fd_pr__pfet_01v8 ad=0.1218 pd=1.42 as=0.1218 ps=1.42 w=0.42 l=0.15
X743 VSS macro_core.write_drive.X a_74415_16496# VSS sky130_fd_pr__nfet_01v8 ad=1.4616 pd=10.66 as=1.4616 ps=10.66 w=5.04 l=0.15
X744 a_86415_16496# macro_core.data_complement\[7\].complement.Y macro_core.array_and_peripherals.write_driver_7.BL VSS sky130_fd_pr__nfet_01v8 ad=1.4616 pd=10.66 as=1.4616 ps=10.66 w=5.04 l=0.15
X745 VDD a_76221_14165# a_76251_14518# VDD sky130_fd_pr__pfet_01v8_hvt ad=0.0693 pd=0.75 as=0.0441 ps=0.63 w=0.42 l=0.15
X746 VDD a_74123_12381# a_74291_12283# VDD sky130_fd_pr__pfet_01v8_hvt ad=0.135 pd=1.27 as=0.27 ps=2.54 w=1 l=0.15
X747 macro_core.phase_delay\[4\].delay_cell.Y macro_core.phase_delay\[3\].delay_cell.Y VDD VDD sky130_fd_pr__pfet_01v8_hvt ad=0.26 pd=2.52 as=0.26 ps=2.52 w=1 l=0.15
X748 a_59403_14557# a_58705_14191# a_59146_14303# VSS sky130_fd_pr__special_nfet_01v8 ad=0.0684 pd=0.74 as=0.0989 ps=0.995 w=0.36 l=0.15
X749 a_49215_45974# a_49167_45886# VDD VDD sky130_fd_pr__pfet_01v8 ad=0.1218 pd=1.42 as=0.1218 ps=1.42 w=0.42 l=0.15
X750 a_78368_12167# _36_.A1 a_78510_12015# VSS sky130_fd_pr__nfet_01v8 ad=0.09975 pd=0.895 as=0.0693 ps=0.75 w=0.42 l=0.15
X751 a_73215_45974# a_73167_45886# VSS VSS sky130_fd_pr__nfet_01v8 ad=0.3654 pd=3.1 as=0.3654 ps=3.1 w=1.26 l=0.15
X752 macro_core.array_and_peripherals.row_decoder_0.net2 macro_core.array_and_peripherals.row_decoder_0.A1B macro_core.array_and_peripherals.row_decoder_0.N1 VSS sky130_fd_pr__nfet_01v8 ad=0.58 pd=4.58 as=0.58 ps=4.58 w=2 l=0.15
X753 VSS a_64611_14191# macro_core.sense_drive.X VSS sky130_fd_pr__nfet_01v8 ad=0.091 pd=0.93 as=0.091 ps=0.93 w=0.65 l=0.15
X754 macro_core.phase_delay\[28\].delay_cell.Y macro_core.phase_delay\[28\].delay_cell.A VDD VDD sky130_fd_pr__pfet_01v8_hvt ad=0.26 pd=2.52 as=0.26 ps=2.52 w=1 l=0.15
X755 a_55167_45886# a_55215_45974# VSS VSS sky130_fd_pr__nfet_01v8 ad=0.3654 pd=3.1 as=0.3654 ps=3.1 w=1.26 l=0.15
X756 macro_core.qualify_row\[2\].qualify.X a_14227_36833# VSS VSS sky130_fd_pr__nfet_01v8 ad=0.182 pd=1.86 as=0.1118 ps=1.04 w=0.65 l=0.15
X757 _35_.Y _84_.Q a_74357_9839# VSS sky130_fd_pr__nfet_01v8 ad=0.169 pd=1.82 as=0.08775 ps=0.92 w=0.65 l=0.15
X758 a_52921_10703# _34_.Y VSS VSS sky130_fd_pr__nfet_01v8 ad=0.08775 pd=0.92 as=0.169 ps=1.82 w=0.65 l=0.15
X759 a_55215_50974# macro_core.array_and_peripherals.wl_driver_2.WL macro_core.array_and_peripherals.write_driver_2.BL VSS sky130_fd_pr__nfet_01v8 ad=0.174 pd=1.78 as=0.174 ps=1.78 w=0.6 l=0.15
X760 VDD _86_.CLK a_49155_12015# VDD sky130_fd_pr__pfet_01v8_hvt ad=0.0864 pd=0.91 as=0.1664 ps=1.8 w=0.64 l=0.15
X761 VSS macro_core.sense_drive.X a_85615_26902# VSS sky130_fd_pr__nfet_01v8 ad=0.2842 pd=2.54 as=0.2842 ps=2.54 w=0.98 l=0.15
X762 a_52737_11791# _34_.Y VSS VSS sky130_fd_pr__nfet_01v8 ad=0.08775 pd=0.92 as=0.169 ps=1.82 w=0.65 l=0.15
X763 a_55167_50886# a_55215_50974# VDD VDD sky130_fd_pr__pfet_01v8 ad=0.1218 pd=1.42 as=0.1218 ps=1.42 w=0.42 l=0.15
X764 VDD a_46949_14455# macro_core.evaluation.X VDD sky130_fd_pr__pfet_01v8_hvt ad=0.26 pd=2.52 as=0.135 ps=1.27 w=1 l=0.15
X765 VDD a_63341_11769# a_63371_11510# VDD sky130_fd_pr__pfet_01v8_hvt ad=0.0693 pd=0.75 as=0.0441 ps=0.63 w=0.42 l=0.15
X766 VDD a_67227_20916# a_68027_20496# VDD sky130_fd_pr__pfet_01v8 ad=1.4616 pd=10.66 as=1.4616 ps=10.66 w=5.04 l=0.15
X767 macro_core.write_drive.X a_61642_14191# VSS VSS sky130_fd_pr__nfet_01v8 ad=0.091 pd=0.93 as=0.13813 ps=1.075 w=0.65 l=0.15
X768 a_78731_12015# _94_.A a_78368_12167# VSS sky130_fd_pr__nfet_01v8 ad=0.0693 pd=0.75 as=0.09975 ps=0.895 w=0.42 l=0.15
X769 VDD macro_core.phase_delay\[0\].delay_cell.A a_78503_14191# VDD sky130_fd_pr__pfet_01v8_hvt ad=0.0864 pd=0.91 as=0.1664 ps=1.8 w=0.64 l=0.15
X770 VDD _84_.Q _58_.Y VDD sky130_fd_pr__pfet_01v8_hvt ad=0.26 pd=2.52 as=0.135 ps=1.27 w=1 l=0.15
X771 VDD macro_core.qualify_row\[2\].qualify.A macro_core.array_and_peripherals.row_decoder_0.N2 VDD sky130_fd_pr__pfet_01v8 ad=0.2436 pd=2.26 as=0.2436 ps=2.26 w=0.84 l=0.15
X772 VDD a_58835_12283# a_58751_12381# VDD sky130_fd_pr__pfet_01v8_hvt ad=0.1113 pd=1.37 as=0.0882 ps=0.84 w=0.42 l=0.15
X773 a_61215_55974# a_61167_55886# VSS VSS sky130_fd_pr__nfet_01v8 ad=0.3654 pd=3.1 as=0.3654 ps=3.1 w=1.26 l=0.15
X774 a_61215_40974# a_61167_40886# VSS VSS sky130_fd_pr__nfet_01v8 ad=0.3654 pd=3.1 as=0.3654 ps=3.1 w=1.26 l=0.15
X775 a_43167_40886# a_43215_40974# VSS VSS sky130_fd_pr__nfet_01v8 ad=0.3654 pd=3.1 as=0.3654 ps=3.1 w=1.26 l=0.15
X776 VDD a_50187_12283# a_50103_12381# VDD sky130_fd_pr__pfet_01v8_hvt ad=0.1113 pd=1.37 as=0.0882 ps=0.84 w=0.42 l=0.15
X777 a_72020_12167# DATA[5] a_72162_12015# VSS sky130_fd_pr__nfet_01v8 ad=0.09975 pd=0.895 as=0.0693 ps=0.75 w=0.42 l=0.15
X778 VDD a_77711_12381# a_77879_12283# VDD sky130_fd_pr__pfet_01v8_hvt ad=0.135 pd=1.27 as=0.27 ps=2.54 w=1 l=0.15
X779 macro_core.phase_delay\[65\].delay_cell.Y macro_core.phase_delay\[64\].delay_cell.Y VDD VDD sky130_fd_pr__pfet_01v8_hvt ad=0.26 pd=2.52 as=0.26 ps=2.52 w=1 l=0.15
X780 a_43167_55886# a_43215_55974# VSS VSS sky130_fd_pr__nfet_01v8 ad=0.3654 pd=3.1 as=0.3654 ps=3.1 w=1.26 l=0.15
X781 macro_core.array_and_peripherals.write_driver_7.BLB macro_core.precharge_drive.X macro_core.array_and_peripherals.write_driver_7.BL VDD sky130_fd_pr__pfet_01v8 ad=0.7308 pd=5.62 as=0.7308 ps=5.62 w=2.52 l=0.15
X782 a_79167_55886# macro_core.array_and_peripherals.wl_driver_3.WL macro_core.array_and_peripherals.write_driver_6.BLB VSS sky130_fd_pr__nfet_01v8 ad=0.174 pd=1.78 as=0.174 ps=1.78 w=0.6 l=0.15
X783 a_79167_40886# macro_core.array_and_peripherals.wl_driver_0.WL macro_core.array_and_peripherals.write_driver_6.BLB VSS sky130_fd_pr__nfet_01v8 ad=0.174 pd=1.78 as=0.174 ps=1.78 w=0.6 l=0.15
X784 a_67426_13621# a_67258_13647# VSS VSS sky130_fd_pr__nfet_01v8 ad=0.0989 pd=0.995 as=0.12095 ps=1.085 w=0.64 l=0.15
X785 macro_core.release_phase.X a_65103_12043# VSS VSS sky130_fd_pr__nfet_01v8 ad=0.182 pd=1.86 as=0.1118 ps=1.04 w=0.65 l=0.15
X786 macro_core.phase_delay\[49\].delay_cell.A macro_core.phase_delay\[48\].delay_cell.A VDD VDD sky130_fd_pr__pfet_01v8_hvt ad=0.26 pd=2.52 as=0.26 ps=2.52 w=1 l=0.15
X787 macro_core.phase_delay\[56\].delay_cell.Y macro_core.phase_delay\[55\].delay_cell.Y VSS VSS sky130_fd_pr__nfet_01v8 ad=0.169 pd=1.82 as=0.169 ps=1.82 w=0.65 l=0.15
X788 a_78827_12342# _36_.A1 a_78368_12167# VDD sky130_fd_pr__pfet_01v8_hvt ad=0.0441 pd=0.63 as=0.1932 ps=1.34 w=0.42 l=0.15
X789 a_15147_35745# macro_core.qualify_row\[3\].qualify.A VDD VDD sky130_fd_pr__pfet_01v8_hvt ad=0.0567 pd=0.69 as=0.1176 ps=1.4 w=0.42 l=0.15
X790 a_69627_20496# _49_.A0 macro_core.array_and_peripherals.write_driver_4.BLB VDD sky130_fd_pr__pfet_01v8 ad=1.4616 pd=10.66 as=1.4616 ps=10.66 w=5.04 l=0.15
X791 VDD a_79227_20916# a_81627_20496# VDD sky130_fd_pr__pfet_01v8 ad=1.4616 pd=10.66 as=1.4616 ps=10.66 w=5.04 l=0.15
X792 VSS a_79367_14557# a_79535_14459# VSS sky130_fd_pr__nfet_01v8 ad=0.08775 pd=0.92 as=0.169 ps=1.82 w=0.65 l=0.15
X793 a_58705_14191# a_58539_14191# VDD VDD sky130_fd_pr__pfet_01v8_hvt ad=0.1664 pd=1.8 as=0.0864 ps=0.91 w=0.64 l=0.15
X794 VSS a_78797_11989# a_78731_12015# VSS sky130_fd_pr__nfet_01v8 ad=0.1449 pd=1.11 as=0.0693 ps=0.75 w=0.42 l=0.15
X795 VSS a_58391_9295# a_58559_9269# VSS sky130_fd_pr__nfet_01v8 ad=0.08775 pd=0.92 as=0.169 ps=1.82 w=0.65 l=0.15
X796 a_78113_9839# a_77123_9839# a_77987_10205# VSS sky130_fd_pr__special_nfet_01v8 ad=0.066 pd=0.745 as=0.0684 ps=0.74 w=0.36 l=0.15
X797 VSS a_56202_14303# a_56160_14191# VSS sky130_fd_pr__nfet_01v8 ad=0.12095 pd=1.085 as=0.0696 ps=0.765 w=0.42 l=0.15
X798 macro_core.data_complement\[6\].complement.Y _51_.A0 VDD VDD sky130_fd_pr__pfet_01v8_hvt ad=0.26 pd=2.52 as=0.26 ps=2.52 w=1 l=0.15
X799 a_74526_14557# a_74087_14191# a_74441_14191# VSS sky130_fd_pr__special_nfet_01v8 ad=0.0621 pd=0.705 as=0.0813 ps=0.83 w=0.36 l=0.15
X800 a_76895_9334# DATA[7] a_76436_9527# VDD sky130_fd_pr__pfet_01v8_hvt ad=0.0441 pd=0.63 as=0.1932 ps=1.34 w=0.42 l=0.15
X801 a_69082_12127# a_68914_12381# VDD VDD sky130_fd_pr__pfet_01v8_hvt ad=0.1095 pd=1.075 as=0.17887 ps=1.26 w=0.75 l=0.15
X802 a_15233_37067# macro_core.qualify_row\[0\].qualify.A a_15147_37067# VSS sky130_fd_pr__nfet_01v8 ad=0.0567 pd=0.69 as=0.1176 ps=1.4 w=0.42 l=0.15
X803 VSS _86_.CLK a_49155_12015# VSS sky130_fd_pr__nfet_01v8 ad=0.0567 pd=0.69 as=0.1092 ps=1.36 w=0.42 l=0.15
X804 a_79493_14191# a_78503_14191# a_79367_14557# VSS sky130_fd_pr__special_nfet_01v8 ad=0.066 pd=0.745 as=0.0684 ps=0.74 w=0.36 l=0.15
X805 a_67767_13647# a_66985_13653# a_67683_13647# VDD sky130_fd_pr__pfet_01v8_hvt ad=0.0882 pd=0.84 as=0.0567 ps=0.69 w=0.42 l=0.15
X806 VSS a_49762_12127# a_49720_12015# VSS sky130_fd_pr__nfet_01v8 ad=0.12095 pd=1.085 as=0.0696 ps=0.765 w=0.42 l=0.15
X807 a_79215_40974# a_79167_40886# VSS VSS sky130_fd_pr__nfet_01v8 ad=0.3654 pd=3.1 as=0.3654 ps=3.1 w=1.26 l=0.15
X808 VDD macro_core.qualify_row\[1\].qualify.A macro_core.array_and_peripherals.row_decoder_0.N1 VDD sky130_fd_pr__pfet_01v8 ad=0.2436 pd=2.26 as=0.2436 ps=2.26 w=0.84 l=0.15
X809 macro_core.phase_delay\[8\].delay_cell.Y macro_core.phase_delay\[7\].delay_cell.Y VSS VSS sky130_fd_pr__nfet_01v8 ad=0.169 pd=1.82 as=0.169 ps=1.82 w=0.65 l=0.15
X810 macro_core.phase_delay\[55\].delay_cell.Y macro_core.phase_delay\[54\].delay_cell.Y VSS VSS sky130_fd_pr__nfet_01v8 ad=0.169 pd=1.82 as=0.169 ps=1.82 w=0.65 l=0.15
X811 a_79215_55974# a_79167_55886# VSS VSS sky130_fd_pr__nfet_01v8 ad=0.3654 pd=3.1 as=0.3654 ps=3.1 w=1.26 l=0.15
X812 a_52722_14557# a_52449_14191# a_52637_14191# VDD sky130_fd_pr__pfet_01v8_hvt ad=0.06825 pd=0.745 as=0.05775 ps=0.695 w=0.42 l=0.15
X813 macro_core.phase_delay\[2\].delay_cell.Y macro_core.phase_delay\[1\].delay_cell.Y VSS VSS sky130_fd_pr__nfet_01v8 ad=0.169 pd=1.82 as=0.169 ps=1.82 w=0.65 l=0.15
X814 _83_.Q a_59571_14459# VSS VSS sky130_fd_pr__nfet_01v8 ad=0.169 pd=1.82 as=0.08775 ps=0.92 w=0.65 l=0.15
X815 macro_core.phase_delay\[34\].delay_cell.Y macro_core.phase_delay\[34\].delay_cell.A VDD VDD sky130_fd_pr__pfet_01v8_hvt ad=0.26 pd=2.52 as=0.26 ps=2.52 w=1 l=0.15
X816 VSS a_76436_9527# _52_.X VSS sky130_fd_pr__nfet_01v8 ad=0.11285 pd=1.045 as=0.169 ps=1.82 w=0.65 l=0.15
X817 macro_core.data_complement\[5\].complement.Y _50_.A0 VSS VSS sky130_fd_pr__nfet_01v8 ad=0.169 pd=1.82 as=0.169 ps=1.82 w=0.65 l=0.15
X818 a_72479_12342# DATA[5] a_72020_12167# VDD sky130_fd_pr__pfet_01v8_hvt ad=0.0441 pd=0.63 as=0.1932 ps=1.34 w=0.42 l=0.15
X819 VDD _84_.Q a_61238_14441# VDD sky130_fd_pr__pfet_01v8_hvt ad=0.14575 pd=1.335 as=0.0441 ps=0.63 w=0.42 l=0.15
X820 a_70573_13653# a_70407_13653# VSS VSS sky130_fd_pr__nfet_01v8 ad=0.1092 pd=1.36 as=0.0567 ps=0.69 w=0.42 l=0.15
X821 VDD a_71439_13621# a_71355_13647# VDD sky130_fd_pr__pfet_01v8_hvt ad=0.1113 pd=1.37 as=0.0882 ps=0.84 w=0.42 l=0.15
X822 VDD a_49762_12127# a_49689_12381# VDD sky130_fd_pr__pfet_01v8_hvt ad=0.17887 pd=1.26 as=0.07665 ps=0.785 w=0.42 l=0.15
X823 a_87627_20496# _52_.A0 macro_core.array_and_peripherals.write_driver_7.BLB VDD sky130_fd_pr__pfet_01v8 ad=1.4616 pd=10.66 as=1.4616 ps=10.66 w=5.04 l=0.15
X824 macro_core.data_complement\[7\].complement.Y _52_.A0 VSS VSS sky130_fd_pr__nfet_01v8 ad=0.169 pd=1.82 as=0.169 ps=1.82 w=0.65 l=0.15
X825 macro_core.data_complement\[0\].complement.Y _45_.A0 VSS VSS sky130_fd_pr__nfet_01v8 ad=0.169 pd=1.82 as=0.169 ps=1.82 w=0.65 l=0.15
X826 macro_core.data_complement\[3\].complement.Y _48_.A0 VDD VDD sky130_fd_pr__pfet_01v8_hvt ad=0.26 pd=2.52 as=0.26 ps=2.52 w=1 l=0.15
X827 a_49260_14025# a_48861_13653# a_49134_13647# VSS sky130_fd_pr__special_nfet_01v8 ad=0.0696 pd=0.765 as=0.0621 ps=0.705 w=0.36 l=0.15
X828 VSS a_72449_11989# a_72383_12015# VSS sky130_fd_pr__nfet_01v8 ad=0.1449 pd=1.11 as=0.0693 ps=0.75 w=0.42 l=0.15
X829 a_50571_3677# a_49707_3311# a_50314_3423# VDD sky130_fd_pr__pfet_01v8_hvt ad=0.0567 pd=0.69 as=0.1095 ps=1.075 w=0.42 l=0.15
X830 a_71413_11791# _34_.Y VSS VSS sky130_fd_pr__nfet_01v8 ad=0.08775 pd=0.92 as=0.169 ps=1.82 w=0.65 l=0.15
X831 macro_core.phase_delay\[77\].delay_cell.Y macro_core.phase_delay\[76\].delay_cell.Y VDD VDD sky130_fd_pr__pfet_01v8_hvt ad=0.26 pd=2.52 as=0.26 ps=2.52 w=1 l=0.15
X832 VDD macro_core.write_drive.X a_73227_20916# VDD sky130_fd_pr__pfet_01v8 ad=0.2436 pd=2.26 as=0.2436 ps=2.26 w=0.84 l=0.15
X833 a_58978_14557# a_58705_14191# a_58893_14191# VDD sky130_fd_pr__pfet_01v8_hvt ad=0.06825 pd=0.745 as=0.05775 ps=0.695 w=0.42 l=0.15
X834 a_67173_13647# _79_.D VSS VSS sky130_fd_pr__nfet_01v8 ad=0.0813 pd=0.83 as=0.1092 ps=1.36 w=0.42 l=0.15
X835 a_50019_12381# a_49321_12015# a_49762_12127# VSS sky130_fd_pr__special_nfet_01v8 ad=0.0684 pd=0.74 as=0.0989 ps=0.995 w=0.36 l=0.15
X836 macro_core.phase_delay\[32\].delay_cell.Y macro_core.phase_delay\[32\].delay_cell.A VSS VSS sky130_fd_pr__nfet_01v8 ad=0.169 pd=1.82 as=0.169 ps=1.82 w=0.65 l=0.15
X837 VSS macro_core.qualify_row\[3\].qualify.X a_36227_56432# VSS sky130_fd_pr__nfet_01v8 ad=0.4872 pd=3.94 as=0.4872 ps=3.94 w=1.68 l=0.15
X838 macro_core.evaluation.X a_46949_14455# VDD VDD sky130_fd_pr__pfet_01v8_hvt ad=0.135 pd=1.27 as=0.15075 ps=1.345 w=1 l=0.15
X839 a_77711_12381# a_77013_12015# a_77454_12127# VSS sky130_fd_pr__special_nfet_01v8 ad=0.0684 pd=0.74 as=0.0989 ps=0.995 w=0.36 l=0.15
X840 macro_core.phase_delay\[72\].delay_cell.Y macro_core.phase_delay\[71\].delay_cell.Y VDD VDD sky130_fd_pr__pfet_01v8_hvt ad=0.26 pd=2.52 as=0.26 ps=2.52 w=1 l=0.15
X841 _52_.A0 a_78155_10107# VDD VDD sky130_fd_pr__pfet_01v8_hvt ad=0.26 pd=2.52 as=0.135 ps=1.27 w=1 l=0.15
X842 a_67215_50974# a_67167_50886# VSS VSS sky130_fd_pr__nfet_01v8 ad=0.3654 pd=3.1 as=0.3654 ps=3.1 w=1.26 l=0.15
X843 VSS a_53315_14459# a_53273_14191# VSS sky130_fd_pr__nfet_01v8 ad=0.1092 pd=1.36 as=0.066 ps=0.745 w=0.42 l=0.15
X844 VSS macro_core.phase_delay\[0\].delay_cell.A _65_.Y VSS sky130_fd_pr__nfet_01v8 ad=0.1197 pd=1.41 as=0.1092 ps=1.36 w=0.42 l=0.15
X845 a_49167_50886# a_49215_50974# VSS VSS sky130_fd_pr__nfet_01v8 ad=0.3654 pd=3.1 as=0.3654 ps=3.1 w=1.26 l=0.15
X846 macro_core.write_drive.X a_61642_14191# VDD VDD sky130_fd_pr__pfet_01v8_hvt ad=0.14 pd=1.28 as=0.14 ps=1.28 w=1 l=0.15
X847 VDD a_78797_11989# a_78827_12342# VDD sky130_fd_pr__pfet_01v8_hvt ad=0.0693 pd=0.75 as=0.0441 ps=0.63 w=0.42 l=0.15
X848 clkbuf_0_CLK.X a_62863_9295# VSS VSS sky130_fd_pr__nfet_01v8 ad=0.0567 pd=0.69 as=0.06825 ps=0.745 w=0.42 l=0.15
X849 VDD macro_core.qualify_row\[3\].qualify.X a_36227_56432# VDD sky130_fd_pr__pfet_01v8 ad=0.4872 pd=3.94 as=0.4872 ps=3.94 w=1.68 l=0.15
X850 a_85167_50886# macro_core.array_and_peripherals.wl_driver_2.WL macro_core.array_and_peripherals.write_driver_7.BLB VSS sky130_fd_pr__nfet_01v8 ad=0.174 pd=1.78 as=0.174 ps=1.78 w=0.6 l=0.15
X851 VDD macro_core.qualify_row\[0\].qualify.X a_36227_41432# VDD sky130_fd_pr__pfet_01v8 ad=0.4872 pd=3.94 as=0.4872 ps=3.94 w=1.68 l=0.15
X852 a_73425_12015# a_73259_12015# VDD VDD sky130_fd_pr__pfet_01v8_hvt ad=0.1664 pd=1.8 as=0.0864 ps=0.91 w=0.64 l=0.15
X853 a_73824_12015# a_73425_12015# a_73698_12381# VSS sky130_fd_pr__special_nfet_01v8 ad=0.0696 pd=0.765 as=0.0621 ps=0.705 w=0.36 l=0.15
X854 VSS a_58559_9269# a_58517_9673# VSS sky130_fd_pr__nfet_01v8 ad=0.1092 pd=1.36 as=0.066 ps=0.745 w=0.42 l=0.15
X855 VSS a_36227_41432# macro_core.array_and_peripherals.wl_driver_0.WL VSS sky130_fd_pr__nfet_01v8 ad=1.4616 pd=10.66 as=1.4616 ps=10.66 w=5.04 l=0.15
X856 a_49940_14343# _42_.A1 a_50082_14191# VSS sky130_fd_pr__nfet_01v8 ad=0.09975 pd=0.895 as=0.0693 ps=0.75 w=0.42 l=0.15
X857 _37_.A1 macro_core.sense_drive.X macro_core.array_and_peripherals.write_driver_6.BL VDD sky130_fd_pr__pfet_01v8 ad=0.58 pd=4.58 as=0.58 ps=4.58 w=2 l=0.15
X858 a_79615_26902# _37_.A1 macro_core.array_and_peripherals.sense_amp_6.SA_OUTB VSS sky130_fd_pr__nfet_01v8 ad=0.2842 pd=2.54 as=0.2842 ps=2.54 w=0.98 l=0.15
X859 a_54753_11471# _77_.D VDD VDD sky130_fd_pr__pfet_01v8_hvt ad=0.05775 pd=0.695 as=0.1092 ps=1.36 w=0.42 l=0.15
X860 a_58410_12127# a_58242_12381# VSS VSS sky130_fd_pr__nfet_01v8 ad=0.0989 pd=0.995 as=0.12095 ps=1.085 w=0.64 l=0.15
X861 a_49229_13647# a_48695_13653# a_49134_13647# VDD sky130_fd_pr__pfet_01v8_hvt ad=0.07665 pd=0.785 as=0.06825 ps=0.745 w=0.42 l=0.15
X862 a_85215_55974# a_85167_55886# VDD VDD sky130_fd_pr__pfet_01v8 ad=0.1218 pd=1.42 as=0.1218 ps=1.42 w=0.42 l=0.15
X863 a_85215_40974# a_85167_40886# VDD VDD sky130_fd_pr__pfet_01v8 ad=0.1218 pd=1.42 as=0.1218 ps=1.42 w=0.42 l=0.15
X864 VDD macro_core.phase_delay\[0\].delay_cell.A a_77123_9839# VDD sky130_fd_pr__pfet_01v8_hvt ad=0.0864 pd=0.91 as=0.1664 ps=1.8 w=0.64 l=0.15
X865 VSS a_71014_13621# a_70972_14025# VSS sky130_fd_pr__nfet_01v8 ad=0.12095 pd=1.085 as=0.0696 ps=0.765 w=0.42 l=0.15
X866 VDD a_58539_10383# _86_.CLK VDD sky130_fd_pr__pfet_01v8_hvt ad=0.26 pd=2.52 as=0.135 ps=1.27 w=1 l=0.15
X867 a_56034_14557# a_55761_14191# a_55949_14191# VDD sky130_fd_pr__pfet_01v8_hvt ad=0.06825 pd=0.745 as=0.05775 ps=0.695 w=0.42 l=0.15
X868 macro_core.phase_delay\[53\].delay_cell.A macro_core.phase_delay\[51\].delay_cell.Y VSS VSS sky130_fd_pr__nfet_01v8 ad=0.169 pd=1.82 as=0.169 ps=1.82 w=0.65 l=0.15
X869 VDD _41_.A1 macro_core.array_and_peripherals.sense_amp_2.SA_OUTB VDD sky130_fd_pr__pfet_01v8 ad=0.5481 pd=4.36 as=0.5481 ps=4.36 w=1.89 l=0.15
X870 VDD macro_core.array_and_peripherals.sense_amp_4.SA_OUTB _39_.A1 VDD sky130_fd_pr__pfet_01v8 ad=0.5481 pd=4.36 as=0.5481 ps=4.36 w=1.89 l=0.15
X871 macro_core.data_complement\[1\].complement.Y _46_.A0 VSS VSS sky130_fd_pr__nfet_01v8 ad=0.169 pd=1.82 as=0.169 ps=1.82 w=0.65 l=0.15
X872 VDD _62_.Y a_57803_12015# VDD sky130_fd_pr__pfet_01v8_hvt ad=0.0864 pd=0.91 as=0.1664 ps=1.8 w=0.64 l=0.15
X873 _85_.Q a_52947_3579# VDD VDD sky130_fd_pr__pfet_01v8_hvt ad=0.26 pd=2.52 as=0.135 ps=1.27 w=1 l=0.15
X874 macro_core.phase_delay\[59\].delay_cell.Y macro_core.phase_delay\[58\].delay_cell.Y VDD VDD sky130_fd_pr__pfet_01v8_hvt ad=0.26 pd=2.52 as=0.26 ps=2.52 w=1 l=0.15
X875 a_73698_12381# a_73425_12015# a_73613_12015# VDD sky130_fd_pr__pfet_01v8_hvt ad=0.06825 pd=0.745 as=0.05775 ps=0.695 w=0.42 l=0.15
X876 macro_core.phase_delay\[37\].delay_cell.Y macro_core.phase_delay\[36\].delay_cell.Y VDD VDD sky130_fd_pr__pfet_01v8_hvt ad=0.26 pd=2.52 as=0.26 ps=2.52 w=1 l=0.15
X877 a_70846_13647# a_70573_13653# a_70761_13647# VDD sky130_fd_pr__pfet_01v8_hvt ad=0.06825 pd=0.745 as=0.05775 ps=0.695 w=0.42 l=0.15
X878 VSS a_53911_2375# _44_.Y VSS sky130_fd_pr__nfet_01v8 ad=0.08775 pd=0.92 as=0.221 ps=1.98 w=0.65 l=0.15
X879 VDD a_49927_10205# a_50095_10107# VDD sky130_fd_pr__pfet_01v8_hvt ad=0.135 pd=1.27 as=0.27 ps=2.54 w=1 l=0.15
X880 VDD a_79367_14557# a_79535_14459# VDD sky130_fd_pr__pfet_01v8_hvt ad=0.135 pd=1.27 as=0.27 ps=2.54 w=1 l=0.15
X881 _49_.A0 a_69507_12283# VSS VSS sky130_fd_pr__nfet_01v8 ad=0.169 pd=1.82 as=0.08775 ps=0.92 w=0.65 l=0.15
X882 VDD a_48744_11703# _75_.D VDD sky130_fd_pr__pfet_01v8_hvt ad=0.15835 pd=1.395 as=0.26 ps=2.52 w=1 l=0.15
X883 VSS WEb _44_.Y VSS sky130_fd_pr__nfet_01v8 ad=0.10025 pd=0.985 as=0.08775 ps=0.92 w=0.65 l=0.15
X884 macro_core.phase_delay\[70\].delay_cell.A macro_core.phase_delay\[68\].delay_cell.Y VDD VDD sky130_fd_pr__pfet_01v8_hvt ad=0.26 pd=2.52 as=0.26 ps=2.52 w=1 l=0.15
X885 a_73215_50974# a_73167_50886# VDD VDD sky130_fd_pr__pfet_01v8 ad=0.1218 pd=1.42 as=0.1218 ps=1.42 w=0.42 l=0.15
X886 a_73215_45974# macro_core.array_and_peripherals.wl_driver_1.WL macro_core.array_and_peripherals.write_driver_5.BL VSS sky130_fd_pr__nfet_01v8 ad=0.174 pd=1.78 as=0.174 ps=1.78 w=0.6 l=0.15
X887 VDD macro_core.array_and_peripherals.row_decoder_0.A0B macro_core.array_and_peripherals.row_decoder_0.A0T VDD sky130_fd_pr__pfet_01v8 ad=0.58 pd=4.58 as=0.58 ps=4.58 w=2 l=0.15
X888 macro_core.array_and_peripherals.write_driver_7.BLB macro_core.sense_drive.X macro_core.array_and_peripherals.sense_amp_7.SA_OUTB VDD sky130_fd_pr__pfet_01v8 ad=0.58 pd=4.58 as=0.58 ps=4.58 w=2 l=0.15
X889 macro_core.precharge_drive.X a_63599_14191# VSS VSS sky130_fd_pr__nfet_01v8 ad=0.091 pd=0.93 as=0.091 ps=0.93 w=0.65 l=0.15
X890 a_55167_45886# macro_core.array_and_peripherals.wl_driver_1.WL macro_core.array_and_peripherals.write_driver_2.BLB VSS sky130_fd_pr__nfet_01v8 ad=0.174 pd=1.78 as=0.174 ps=1.78 w=0.6 l=0.15
X891 a_43615_26902# macro_core.array_and_peripherals.sense_amp_0.SA_OUTB _43_.A1 VSS sky130_fd_pr__nfet_01v8 ad=0.2842 pd=2.54 as=0.2842 ps=2.54 w=0.98 l=0.15
X892 VSS a_50369_14165# a_50303_14191# VSS sky130_fd_pr__nfet_01v8 ad=0.1449 pd=1.11 as=0.0693 ps=0.75 w=0.42 l=0.15
X893 a_49762_12127# a_49594_12381# VSS VSS sky130_fd_pr__nfet_01v8 ad=0.0989 pd=0.995 as=0.12095 ps=1.085 w=0.64 l=0.15
X894 macro_core.phase_delay\[6\].delay_cell.Y macro_core.phase_delay\[5\].delay_cell.Y VDD VDD sky130_fd_pr__pfet_01v8_hvt ad=0.26 pd=2.52 as=0.26 ps=2.52 w=1 l=0.15
X895 a_73167_45886# a_73215_45974# VDD VDD sky130_fd_pr__pfet_01v8 ad=0.1218 pd=1.42 as=0.1218 ps=1.42 w=0.42 l=0.15
X896 VSS _64_.Y a_70407_13653# VSS sky130_fd_pr__nfet_01v8 ad=0.0567 pd=0.69 as=0.1092 ps=1.36 w=0.42 l=0.15
X897 a_73425_12015# a_73259_12015# VSS VSS sky130_fd_pr__nfet_01v8 ad=0.1092 pd=1.36 as=0.0567 ps=0.69 w=0.42 l=0.15
X898 VSS macro_core.write_drive.X a_52015_16496# VSS sky130_fd_pr__nfet_01v8 ad=1.4616 pd=10.66 as=1.4616 ps=10.66 w=5.04 l=0.15
X899 a_64015_16496# _48_.A0 macro_core.array_and_peripherals.write_driver_3.BLB VSS sky130_fd_pr__nfet_01v8 ad=1.4616 pd=10.66 as=1.4616 ps=10.66 w=5.04 l=0.15
X900 macro_core.phase_delay\[40\].delay_cell.A macro_core.phase_delay\[38\].delay_cell.Y VDD VDD sky130_fd_pr__pfet_01v8_hvt ad=0.26 pd=2.52 as=0.26 ps=2.52 w=1 l=0.15
X901 a_52522_3423# a_52354_3677# VSS VSS sky130_fd_pr__nfet_01v8 ad=0.0989 pd=0.995 as=0.12095 ps=1.085 w=0.64 l=0.15
X902 macro_core.evaluation.A a_61156_14441# VDD VDD sky130_fd_pr__pfet_01v8_hvt ad=0.34 pd=2.68 as=0.14575 ps=1.335 w=1 l=0.15
X903 a_59529_14191# a_58539_14191# a_59403_14557# VSS sky130_fd_pr__special_nfet_01v8 ad=0.066 pd=0.745 as=0.0684 ps=0.74 w=0.36 l=0.15
X904 VSS clkbuf_0_CLK.X a_66819_10383# VSS sky130_fd_pr__nfet_01v8 ad=0.06825 pd=0.745 as=0.1113 ps=1.37 w=0.42 l=0.15
X905 VSS macro_core.array_and_peripherals.row_decoder_0.N0 macro_core.qualify_row\[0\].qualify.A VSS sky130_fd_pr__nfet_01v8 ad=0.58 pd=4.58 as=0.58 ps=4.58 w=2 l=0.15
X906 VSS a_49302_13621# a_49260_14025# VSS sky130_fd_pr__nfet_01v8 ad=0.12095 pd=1.085 as=0.0696 ps=0.765 w=0.42 l=0.15
X907 a_49049_13647# _76_.D VDD VDD sky130_fd_pr__pfet_01v8_hvt ad=0.05775 pd=0.695 as=0.1092 ps=1.36 w=0.42 l=0.15
X908 VDD a_59937_12857# a_59967_12598# VDD sky130_fd_pr__pfet_01v8_hvt ad=0.0693 pd=0.75 as=0.0441 ps=0.63 w=0.42 l=0.15
X909 _83_.Q a_59571_14459# VDD VDD sky130_fd_pr__pfet_01v8_hvt ad=0.26 pd=2.52 as=0.135 ps=1.27 w=1 l=0.15
X910 a_57881_9295# _34_.Y VDD VDD sky130_fd_pr__pfet_01v8_hvt ad=0.05775 pd=0.695 as=0.1092 ps=1.36 w=0.42 l=0.15
X911 macro_core.phase_delay\[25\].delay_cell.A macro_core.phase_delay\[23\].delay_cell.Y VDD VDD sky130_fd_pr__pfet_01v8_hvt ad=0.26 pd=2.52 as=0.26 ps=2.52 w=1 l=0.15
X912 a_61215_55974# macro_core.array_and_peripherals.wl_driver_3.WL macro_core.array_and_peripherals.write_driver_3.BL VSS sky130_fd_pr__nfet_01v8 ad=0.174 pd=1.78 as=0.174 ps=1.78 w=0.6 l=0.15
X913 a_61215_40974# macro_core.array_and_peripherals.wl_driver_0.WL macro_core.array_and_peripherals.write_driver_3.BL VSS sky130_fd_pr__nfet_01v8 ad=0.174 pd=1.78 as=0.174 ps=1.78 w=0.6 l=0.15
X914 a_52905_3311# a_51915_3311# a_52779_3677# VSS sky130_fd_pr__special_nfet_01v8 ad=0.066 pd=0.745 as=0.0684 ps=0.74 w=0.36 l=0.15
X915 a_43167_55886# macro_core.array_and_peripherals.wl_driver_3.WL macro_core.array_and_peripherals.write_driver_0.BLB VSS sky130_fd_pr__nfet_01v8 ad=0.174 pd=1.78 as=0.174 ps=1.78 w=0.6 l=0.15
X916 a_43167_40886# macro_core.array_and_peripherals.wl_driver_0.WL macro_core.array_and_peripherals.write_driver_0.BLB VSS sky130_fd_pr__nfet_01v8 ad=0.174 pd=1.78 as=0.174 ps=1.78 w=0.6 l=0.15
X917 macro_core.phase_delay\[79\].delay_cell.Y macro_core.phase_delay\[78\].delay_cell.Y VSS VSS sky130_fd_pr__nfet_01v8 ad=0.169 pd=1.82 as=0.169 ps=1.82 w=0.65 l=0.15
X918 macro_core.phase_delay\[26\].delay_cell.A macro_core.phase_delay\[25\].delay_cell.A VSS VSS sky130_fd_pr__nfet_01v8 ad=0.169 pd=1.82 as=0.169 ps=1.82 w=0.65 l=0.15
X919 a_61167_55886# a_61215_55974# VDD VDD sky130_fd_pr__pfet_01v8 ad=0.1218 pd=1.42 as=0.1218 ps=1.42 w=0.42 l=0.15
X920 a_61167_40886# a_61215_40974# VDD VDD sky130_fd_pr__pfet_01v8 ad=0.1218 pd=1.42 as=0.1218 ps=1.42 w=0.42 l=0.15
X921 VSS macro_core.evaluation.X macro_core.array_and_peripherals.row_decoder_0.EVAL_GND VSS sky130_fd_pr__nfet_01v8 ad=0.435 pd=3.58 as=0.435 ps=3.58 w=1.5 l=0.15
X922 VDD a_43227_20916# a_45627_20496# VDD sky130_fd_pr__pfet_01v8 ad=1.4616 pd=10.66 as=1.4616 ps=10.66 w=5.04 l=0.15
X923 a_56027_20496# macro_core.data_complement\[2\].complement.Y macro_core.array_and_peripherals.write_driver_2.BL VDD sky130_fd_pr__pfet_01v8 ad=1.4616 pd=10.66 as=1.4616 ps=10.66 w=5.04 l=0.15
X924 VSS _62_.Y a_57803_12015# VSS sky130_fd_pr__nfet_01v8 ad=0.0567 pd=0.69 as=0.1092 ps=1.36 w=0.42 l=0.15
X925 a_80415_16496# macro_core.data_complement\[6\].complement.Y macro_core.array_and_peripherals.write_driver_6.BL VSS sky130_fd_pr__nfet_01v8 ad=1.4616 pd=10.66 as=1.4616 ps=10.66 w=5.04 l=0.15
X926 VDD macro_core.phase_delay\[0\].delay_cell.A _64_.Y VDD sky130_fd_pr__pfet_01v8_hvt ad=0.2352 pd=2.24 as=0.1134 ps=1.11 w=0.84 l=0.15
X927 VSS a_52947_3579# a_52905_3311# VSS sky130_fd_pr__nfet_01v8 ad=0.1092 pd=1.36 as=0.066 ps=0.745 w=0.42 l=0.15
X928 a_62389_12015# _48_.X VDD VDD sky130_fd_pr__pfet_01v8_hvt ad=0.05775 pd=0.695 as=0.1092 ps=1.36 w=0.42 l=0.15
X929 macro_core.phase_delay\[44\].delay_cell.Y macro_core.phase_delay\[44\].delay_cell.A VDD VDD sky130_fd_pr__pfet_01v8_hvt ad=0.26 pd=2.52 as=0.26 ps=2.52 w=1 l=0.15
X930 a_56202_14303# a_56034_14557# VDD VDD sky130_fd_pr__pfet_01v8_hvt ad=0.1095 pd=1.075 as=0.17887 ps=1.26 w=0.75 l=0.15
X931 VDD _63_.Y a_66819_13653# VDD sky130_fd_pr__pfet_01v8_hvt ad=0.0864 pd=0.91 as=0.1664 ps=1.8 w=0.64 l=0.15
X932 VDD _86_.CLK _62_.Y VDD sky130_fd_pr__pfet_01v8_hvt ad=0.2352 pd=2.24 as=0.1134 ps=1.11 w=0.84 l=0.15
X933 DATA[4] a_66543_12015# a_67047_12015# VSS sky130_fd_pr__nfet_01v8 ad=0.286 pd=2.18 as=0.06825 ps=0.86 w=0.65 l=0.15
X934 a_43215_45974# a_43167_45886# VDD VDD sky130_fd_pr__pfet_01v8 ad=0.1218 pd=1.42 as=0.1218 ps=1.42 w=0.42 l=0.15
X935 a_74951_14557# a_74087_14191# a_74694_14303# VDD sky130_fd_pr__pfet_01v8_hvt ad=0.0567 pd=0.69 as=0.1095 ps=1.075 w=0.42 l=0.15
X936 a_52511_9839# a_52173_10161# VSS VSS sky130_fd_pr__nfet_01v8 ad=0.06825 pd=0.86 as=0.2275 ps=2 w=0.65 l=0.15
X937 VSS macro_core.write_drive.X a_55227_20916# VSS sky130_fd_pr__nfet_01v8 ad=0.2436 pd=2.26 as=0.2436 ps=2.26 w=0.84 l=0.15
X938 VDD a_52700_13255# _46_.X VDD sky130_fd_pr__pfet_01v8_hvt ad=0.15835 pd=1.395 as=0.26 ps=2.52 w=1 l=0.15
X939 _86_.CLK a_58539_10383# VDD VDD sky130_fd_pr__pfet_01v8_hvt ad=0.135 pd=1.27 as=0.1625 ps=1.325 w=1 l=0.15
X940 a_49215_50974# macro_core.array_and_peripherals.wl_driver_2.WL macro_core.array_and_peripherals.write_driver_1.BL VSS sky130_fd_pr__nfet_01v8 ad=0.174 pd=1.78 as=0.174 ps=1.78 w=0.6 l=0.15
X941 VDD macro_core.precharge_drive.X macro_core.array_and_peripherals.write_driver_4.BL VDD sky130_fd_pr__pfet_01v8 ad=0.7308 pd=5.62 as=0.7308 ps=5.62 w=2.52 l=0.15
X942 VDD macro_core.precharge_drive.X macro_core.array_and_peripherals.write_driver_2.BLB VDD sky130_fd_pr__pfet_01v8 ad=0.7308 pd=5.62 as=0.7308 ps=5.62 w=2.52 l=0.15
X943 a_61842_14191# _86_.CLK a_61733_14191# VSS sky130_fd_pr__nfet_01v8 ad=0.06825 pd=0.86 as=0.12837 ps=1.045 w=0.65 l=0.15
X944 a_49762_12127# a_49594_12381# VDD VDD sky130_fd_pr__pfet_01v8_hvt ad=0.1095 pd=1.075 as=0.17887 ps=1.26 w=0.75 l=0.15
X945 macro_core.phase_delay\[63\].delay_cell.A macro_core.phase_delay\[62\].delay_cell.A VSS VSS sky130_fd_pr__nfet_01v8 ad=0.169 pd=1.82 as=0.169 ps=1.82 w=0.65 l=0.15
X946 macro_core.phase_delay\[11\].delay_cell.Y macro_core.phase_delay\[10\].delay_cell.Y VSS VSS sky130_fd_pr__nfet_01v8 ad=0.169 pd=1.82 as=0.169 ps=1.82 w=0.65 l=0.15
X947 VSS macro_core.sense_drive.X a_79615_26902# VSS sky130_fd_pr__nfet_01v8 ad=0.2842 pd=2.54 as=0.2842 ps=2.54 w=0.98 l=0.15
X948 macro_core.phase_delay\[16\].delay_cell.Y macro_core.phase_delay\[15\].delay_cell.Y VDD VDD sky130_fd_pr__pfet_01v8_hvt ad=0.26 pd=2.52 as=0.26 ps=2.52 w=1 l=0.15
X949 VDD a_61227_20916# a_62027_20496# VDD sky130_fd_pr__pfet_01v8 ad=1.4616 pd=10.66 as=1.4616 ps=10.66 w=5.04 l=0.15
X950 a_52848_14191# a_52449_14191# a_52722_14557# VSS sky130_fd_pr__special_nfet_01v8 ad=0.0696 pd=0.765 as=0.0621 ps=0.705 w=0.36 l=0.15
X951 a_74694_14303# a_74526_14557# VSS VSS sky130_fd_pr__nfet_01v8 ad=0.0989 pd=0.995 as=0.12095 ps=1.085 w=0.64 l=0.15
X952 macro_core.phase_delay\[42\].delay_cell.A macro_core.phase_delay\[41\].delay_cell.A VSS VSS sky130_fd_pr__nfet_01v8 ad=0.169 pd=1.82 as=0.169 ps=1.82 w=0.65 l=0.15
X953 a_79167_40886# a_79215_40974# VDD VDD sky130_fd_pr__pfet_01v8 ad=0.1218 pd=1.42 as=0.1218 ps=1.42 w=0.42 l=0.15
X954 VSS a_67696_14343# _79_.D VSS sky130_fd_pr__nfet_01v8 ad=0.11285 pd=1.045 as=0.169 ps=1.82 w=0.65 l=0.15
X955 macro_core.phase_delay\[1\].delay_cell.A macro_core.phase_delay\[0\].delay_cell.A VDD VDD sky130_fd_pr__pfet_01v8_hvt ad=0.26 pd=2.52 as=0.26 ps=2.52 w=1 l=0.15
X956 a_79167_55886# a_79215_55974# VDD VDD sky130_fd_pr__pfet_01v8 ad=0.1218 pd=1.42 as=0.1218 ps=1.42 w=0.42 l=0.15
X957 VSS a_69339_12381# a_69507_12283# VSS sky130_fd_pr__nfet_01v8 ad=0.08775 pd=0.92 as=0.169 ps=1.82 w=0.65 l=0.15
X958 VSS macro_core.write_drive.X a_86415_16496# VSS sky130_fd_pr__nfet_01v8 ad=1.4616 pd=10.66 as=1.4616 ps=10.66 w=5.04 l=0.15
X959 a_49107_11837# _75_.Q a_48744_11703# VSS sky130_fd_pr__nfet_01v8 ad=0.0693 pd=0.75 as=0.09975 ps=0.895 w=0.42 l=0.15
X960 macro_core.phase_delay\[23\].delay_cell.Y macro_core.phase_delay\[23\].delay_cell.A VSS VSS sky130_fd_pr__nfet_01v8 ad=0.169 pd=1.82 as=0.169 ps=1.82 w=0.65 l=0.15
X961 VDD macro_core.array_and_peripherals.row_decoder_0.N0 macro_core.qualify_row\[0\].qualify.A VDD sky130_fd_pr__pfet_01v8 ad=0.87 pd=6.58 as=0.87 ps=6.58 w=3 l=0.15
X962 a_85215_45974# a_85167_45886# VSS VSS sky130_fd_pr__nfet_01v8 ad=0.3654 pd=3.1 as=0.3654 ps=3.1 w=1.26 l=0.15
X963 macro_core.array_and_peripherals.write_driver_6.BLB macro_core.precharge_drive.X macro_core.array_and_peripherals.write_driver_6.BL VDD sky130_fd_pr__pfet_01v8 ad=0.7308 pd=5.62 as=0.7308 ps=5.62 w=2.52 l=0.15
X964 a_58893_14191# _44_.Y VDD VDD sky130_fd_pr__pfet_01v8_hvt ad=0.05775 pd=0.695 as=0.1092 ps=1.36 w=0.42 l=0.15
X965 VDD a_56627_14459# a_56543_14557# VDD sky130_fd_pr__pfet_01v8_hvt ad=0.1113 pd=1.37 as=0.0882 ps=0.84 w=0.42 l=0.15
X966 VDD a_55000_12791# _77_.D VDD sky130_fd_pr__pfet_01v8_hvt ad=0.15835 pd=1.395 as=0.26 ps=2.52 w=1 l=0.15
X967 VSS macro_core.phase_delay\[23\].delay_cell.Y a_65189_12043# VSS sky130_fd_pr__nfet_01v8 ad=0.1118 pd=1.04 as=0.0567 ps=0.69 w=0.42 l=0.15
X968 a_67215_50974# macro_core.array_and_peripherals.wl_driver_2.WL macro_core.array_and_peripherals.write_driver_4.BL VSS sky130_fd_pr__nfet_01v8 ad=0.174 pd=1.78 as=0.174 ps=1.78 w=0.6 l=0.15
X969 a_67167_45886# a_67215_45974# VSS VSS sky130_fd_pr__nfet_01v8 ad=0.3654 pd=3.1 as=0.3654 ps=3.1 w=1.26 l=0.15
X970 VSS a_75119_14459# a_75077_14191# VSS sky130_fd_pr__nfet_01v8 ad=0.1092 pd=1.36 as=0.066 ps=0.745 w=0.42 l=0.15
X971 a_52081_12337# _58_.Y VDD VDD sky130_fd_pr__pfet_01v8_hvt ad=0.1664 pd=1.8 as=0.0864 ps=0.91 w=0.64 l=0.15
X972 a_69465_12015# a_68475_12015# a_69339_12381# VSS sky130_fd_pr__special_nfet_01v8 ad=0.066 pd=0.745 as=0.0684 ps=0.74 w=0.36 l=0.15
X973 macro_core.phase_delay\[35\].delay_cell.Y macro_core.phase_delay\[34\].delay_cell.Y VDD VDD sky130_fd_pr__pfet_01v8_hvt ad=0.26 pd=2.52 as=0.26 ps=2.52 w=1 l=0.15
X974 a_77477_9839# _52_.X VDD VDD sky130_fd_pr__pfet_01v8_hvt ad=0.05775 pd=0.695 as=0.1092 ps=1.36 w=0.42 l=0.15
X975 a_75792_14343# _93_.A a_75934_14518# VDD sky130_fd_pr__pfet_01v8_hvt ad=0.1932 pd=1.34 as=0.07665 ps=0.785 w=0.42 l=0.15
X976 a_75357_12337# _53_.Y VDD VDD sky130_fd_pr__pfet_01v8_hvt ad=0.1664 pd=1.8 as=0.0864 ps=0.91 w=0.64 l=0.15
X977 macro_core.phase_delay\[34\].delay_cell.A macro_core.phase_delay\[32\].delay_cell.Y VSS VSS sky130_fd_pr__nfet_01v8 ad=0.169 pd=1.82 as=0.169 ps=1.82 w=0.65 l=0.15
X978 macro_core.phase_delay\[64\].delay_cell.A macro_core.phase_delay\[63\].delay_cell.A VSS VSS sky130_fd_pr__nfet_01v8 ad=0.169 pd=1.82 as=0.169 ps=1.82 w=0.65 l=0.15
X979 a_67167_50886# a_67215_50974# VDD VDD sky130_fd_pr__pfet_01v8 ad=0.1218 pd=1.42 as=0.1218 ps=1.42 w=0.42 l=0.15
X980 _43_.A1 macro_core.sense_drive.X macro_core.array_and_peripherals.write_driver_0.BL VDD sky130_fd_pr__pfet_01v8 ad=0.58 pd=4.58 as=0.58 ps=4.58 w=2 l=0.15
X981 a_43615_26902# _43_.A1 macro_core.array_and_peripherals.sense_amp_0.SA_OUTB VSS sky130_fd_pr__nfet_01v8 ad=0.2842 pd=2.54 as=0.2842 ps=2.54 w=0.98 l=0.15
X982 a_78797_11989# _84_.Q VDD VDD sky130_fd_pr__pfet_01v8_hvt ad=0.1176 pd=1.4 as=0.0693 ps=0.75 w=0.42 l=0.15
X983 a_50082_14518# _84_.Q VDD VDD sky130_fd_pr__pfet_01v8_hvt ad=0.07665 pd=0.785 as=0.15835 ps=1.395 w=0.42 l=0.15
X984 a_58368_12015# a_57969_12015# a_58242_12381# VSS sky130_fd_pr__special_nfet_01v8 ad=0.0696 pd=0.765 as=0.0621 ps=0.705 w=0.36 l=0.15
X985 a_49215_55974# a_49167_55886# VDD VDD sky130_fd_pr__pfet_01v8 ad=0.1218 pd=1.42 as=0.1218 ps=1.42 w=0.42 l=0.15
X986 a_49215_40974# a_49167_40886# VDD VDD sky130_fd_pr__pfet_01v8 ad=0.1218 pd=1.42 as=0.1218 ps=1.42 w=0.42 l=0.15
X987 a_61733_14191# _83_.Q a_61642_14191# VSS sky130_fd_pr__nfet_01v8 ad=0.12837 pd=1.045 as=0.19825 ps=1.91 w=0.65 l=0.15
X988 a_77837_12015# a_76847_12015# a_77711_12381# VSS sky130_fd_pr__special_nfet_01v8 ad=0.066 pd=0.745 as=0.0684 ps=0.74 w=0.36 l=0.15
X989 a_78797_11989# _84_.Q VSS VSS sky130_fd_pr__nfet_01v8 ad=0.1092 pd=1.36 as=0.1449 ps=1.11 w=0.42 l=0.15
X990 macro_core.phase_delay\[12\].delay_cell.Y macro_core.phase_delay\[11\].delay_cell.Y VDD VDD sky130_fd_pr__pfet_01v8_hvt ad=0.26 pd=2.52 as=0.26 ps=2.52 w=1 l=0.15
X991 a_68861_11769# _44_.Y VSS VSS sky130_fd_pr__nfet_01v8 ad=0.1092 pd=1.36 as=0.1449 ps=1.11 w=0.42 l=0.15
X992 a_73215_40974# a_73167_40886# VSS VSS sky130_fd_pr__nfet_01v8 ad=0.3654 pd=3.1 as=0.3654 ps=3.1 w=1.26 l=0.15
X993 a_55761_14191# a_55595_14191# VDD VDD sky130_fd_pr__pfet_01v8_hvt ad=0.1664 pd=1.8 as=0.0864 ps=0.91 w=0.64 l=0.15
X994 VDD a_49302_13621# a_49229_13647# VDD sky130_fd_pr__pfet_01v8_hvt ad=0.17887 pd=1.26 as=0.07665 ps=0.785 w=0.42 l=0.15
X995 VDD a_76865_9593# a_76895_9334# VDD sky130_fd_pr__pfet_01v8_hvt ad=0.0693 pd=0.75 as=0.0441 ps=0.63 w=0.42 l=0.15
X996 _57_.Y _84_.Q a_55497_10703# VSS sky130_fd_pr__nfet_01v8 ad=0.169 pd=1.82 as=0.08775 ps=0.92 w=0.65 l=0.15
X997 a_73215_55974# a_73167_55886# VSS VSS sky130_fd_pr__nfet_01v8 ad=0.3654 pd=3.1 as=0.3654 ps=3.1 w=1.26 l=0.15
X998 a_79367_14557# a_78669_14191# a_79110_14303# VSS sky130_fd_pr__special_nfet_01v8 ad=0.0684 pd=0.74 as=0.0989 ps=0.995 w=0.36 l=0.15
X999 a_70846_13647# a_70407_13653# a_70761_13647# VSS sky130_fd_pr__special_nfet_01v8 ad=0.0621 pd=0.705 as=0.0813 ps=0.83 w=0.36 l=0.15
X1000 macro_core.phase_delay\[23\].delay_cell.A macro_core.phase_delay\[21\].delay_cell.Y VSS VSS sky130_fd_pr__nfet_01v8 ad=0.169 pd=1.82 as=0.169 ps=1.82 w=0.65 l=0.15
X1001 a_55167_55886# a_55215_55974# VSS VSS sky130_fd_pr__nfet_01v8 ad=0.3654 pd=3.1 as=0.3654 ps=3.1 w=1.26 l=0.15
X1002 a_55167_40886# a_55215_40974# VSS VSS sky130_fd_pr__nfet_01v8 ad=0.3654 pd=3.1 as=0.3654 ps=3.1 w=1.26 l=0.15
X1003 macro_core.phase_delay\[64\].delay_cell.Y macro_core.phase_delay\[64\].delay_cell.A VSS VSS sky130_fd_pr__nfet_01v8 ad=0.169 pd=1.82 as=0.169 ps=1.82 w=0.65 l=0.15
X1004 a_52449_14191# a_52283_14191# VSS VSS sky130_fd_pr__nfet_01v8 ad=0.1092 pd=1.36 as=0.0567 ps=0.69 w=0.42 l=0.15
X1005 _62_.Y _86_.CLK VDD VDD sky130_fd_pr__pfet_01v8_hvt ad=0.1134 pd=1.11 as=0.2184 ps=2.2 w=0.84 l=0.15
X1006 VSS a_62642_12127# a_62600_12015# VSS sky130_fd_pr__nfet_01v8 ad=0.12095 pd=1.085 as=0.0696 ps=0.765 w=0.42 l=0.15
X1007 a_77412_12015# a_77013_12015# a_77286_12381# VSS sky130_fd_pr__special_nfet_01v8 ad=0.0696 pd=0.765 as=0.0621 ps=0.705 w=0.36 l=0.15
X1008 VDD a_62863_9295# clkbuf_0_CLK.X VDD sky130_fd_pr__pfet_01v8_hvt ad=0.26 pd=2.52 as=0.135 ps=1.27 w=1 l=0.15
X1009 a_49940_14343# _88_.A a_50082_14518# VDD sky130_fd_pr__pfet_01v8_hvt ad=0.1932 pd=1.34 as=0.07665 ps=0.785 w=0.42 l=0.15
X1010 a_69339_12381# a_68475_12015# a_69082_12127# VDD sky130_fd_pr__pfet_01v8_hvt ad=0.0567 pd=0.69 as=0.1095 ps=1.075 w=0.42 l=0.15
X1011 a_71978_14518# _84_.Q VDD VDD sky130_fd_pr__pfet_01v8_hvt ad=0.07665 pd=0.785 as=0.15835 ps=1.395 w=0.42 l=0.15
X1012 a_81627_20496# _51_.A0 macro_core.array_and_peripherals.write_driver_6.BLB VDD sky130_fd_pr__pfet_01v8 ad=1.4616 pd=10.66 as=1.4616 ps=10.66 w=5.04 l=0.15
X1013 a_52354_3677# a_52081_3311# a_52269_3311# VDD sky130_fd_pr__pfet_01v8_hvt ad=0.06825 pd=0.745 as=0.05775 ps=0.695 w=0.42 l=0.15
X1014 _47_.A0 a_56627_14459# VSS VSS sky130_fd_pr__nfet_01v8 ad=0.169 pd=1.82 as=0.08775 ps=0.92 w=0.65 l=0.15
X1015 macro_core.phase_delay\[57\].delay_cell.Y macro_core.phase_delay\[56\].delay_cell.Y VSS VSS sky130_fd_pr__nfet_01v8 ad=0.169 pd=1.82 as=0.169 ps=1.82 w=0.65 l=0.15
X1016 a_53911_2375# OEb VDD VDD sky130_fd_pr__pfet_01v8_hvt ad=0.1092 pd=1.36 as=0.14575 ps=1.335 w=0.42 l=0.15
X1017 macro_core.phase_delay\[73\].delay_cell.Y macro_core.phase_delay\[72\].delay_cell.Y VSS VSS sky130_fd_pr__nfet_01v8 ad=0.169 pd=1.82 as=0.169 ps=1.82 w=0.65 l=0.15
X1018 VDD a_62642_12127# a_62569_12381# VDD sky130_fd_pr__pfet_01v8_hvt ad=0.17887 pd=1.26 as=0.07665 ps=0.785 w=0.42 l=0.15
X1019 a_73613_12015# _50_.X VDD VDD sky130_fd_pr__pfet_01v8_hvt ad=0.05775 pd=0.695 as=0.1092 ps=1.36 w=0.42 l=0.15
X1020 VSS a_53911_2999# _34_.Y VSS sky130_fd_pr__nfet_01v8 ad=0.08775 pd=0.92 as=0.221 ps=1.98 w=0.65 l=0.15
X1021 a_57966_9295# a_57693_9301# a_57881_9295# VDD sky130_fd_pr__pfet_01v8_hvt ad=0.06825 pd=0.745 as=0.05775 ps=0.695 w=0.42 l=0.15
X1022 VSS a_61642_14191# macro_core.write_drive.X VSS sky130_fd_pr__nfet_01v8 ad=0.18525 pd=1.87 as=0.091 ps=0.93 w=0.65 l=0.15
X1023 a_70761_13647# _80_.D VDD VDD sky130_fd_pr__pfet_01v8_hvt ad=0.05775 pd=0.695 as=0.1092 ps=1.36 w=0.42 l=0.15
X1024 a_66353_11791# _34_.Y VSS VSS sky130_fd_pr__nfet_01v8 ad=0.08775 pd=0.92 as=0.169 ps=1.82 w=0.65 l=0.15
X1025 a_61215_50974# a_61167_50886# VSS VSS sky130_fd_pr__nfet_01v8 ad=0.3654 pd=3.1 as=0.3654 ps=3.1 w=1.26 l=0.15
X1026 a_72449_11989# _44_.Y VDD VDD sky130_fd_pr__pfet_01v8_hvt ad=0.1176 pd=1.4 as=0.0693 ps=0.75 w=0.42 l=0.15
X1027 a_73866_12127# a_73698_12381# VSS VSS sky130_fd_pr__nfet_01v8 ad=0.0989 pd=0.995 as=0.12095 ps=1.085 w=0.64 l=0.15
X1028 VSS OEb _34_.Y VSS sky130_fd_pr__nfet_01v8 ad=0.10025 pd=0.985 as=0.08775 ps=0.92 w=0.65 l=0.15
X1029 a_72449_11989# _44_.Y VSS VSS sky130_fd_pr__nfet_01v8 ad=0.1092 pd=1.36 as=0.1449 ps=1.11 w=0.42 l=0.15
X1030 macro_core.phase_delay\[13\].delay_cell.Y macro_core.phase_delay\[12\].delay_cell.Y VSS VSS sky130_fd_pr__nfet_01v8 ad=0.169 pd=1.82 as=0.169 ps=1.82 w=0.65 l=0.15
X1031 VSS a_49670_9951# a_49628_9839# VSS sky130_fd_pr__nfet_01v8 ad=0.12095 pd=1.085 as=0.0696 ps=0.765 w=0.42 l=0.15
X1032 _87_.TE_B _84_.Q a_52921_10703# VSS sky130_fd_pr__nfet_01v8 ad=0.169 pd=1.82 as=0.08775 ps=0.92 w=0.65 l=0.15
X1033 a_68861_11769# _44_.Y VDD VDD sky130_fd_pr__pfet_01v8_hvt ad=0.1176 pd=1.4 as=0.0693 ps=0.75 w=0.42 l=0.15
X1034 a_43167_50886# a_43215_50974# VSS VSS sky130_fd_pr__nfet_01v8 ad=0.3654 pd=3.1 as=0.3654 ps=3.1 w=1.26 l=0.15
X1035 a_49502_10205# a_49063_9839# a_49417_9839# VSS sky130_fd_pr__special_nfet_01v8 ad=0.0621 pd=0.705 as=0.0813 ps=0.83 w=0.36 l=0.15
X1036 a_79167_50886# macro_core.array_and_peripherals.wl_driver_2.WL macro_core.array_and_peripherals.write_driver_6.BLB VSS sky130_fd_pr__nfet_01v8 ad=0.174 pd=1.78 as=0.174 ps=1.78 w=0.6 l=0.15
X1037 VSS _86_.CLK _60_.Y VSS sky130_fd_pr__nfet_01v8 ad=0.1197 pd=1.41 as=0.1092 ps=1.36 w=0.42 l=0.15
X1038 VSS a_58835_12283# a_58793_12015# VSS sky130_fd_pr__nfet_01v8 ad=0.1092 pd=1.36 as=0.066 ps=0.745 w=0.42 l=0.15
X1039 VDD macro_core.phase_delay\[0\].delay_cell.A a_73259_12015# VDD sky130_fd_pr__pfet_01v8_hvt ad=0.0864 pd=0.91 as=0.1664 ps=1.8 w=0.64 l=0.15
X1040 a_77286_12381# a_77013_12015# a_77201_12015# VDD sky130_fd_pr__pfet_01v8_hvt ad=0.06825 pd=0.745 as=0.05775 ps=0.695 w=0.42 l=0.15
X1041 macro_core.phase_delay\[51\].delay_cell.A macro_core.phase_delay\[50\].delay_cell.A VSS VSS sky130_fd_pr__nfet_01v8 ad=0.169 pd=1.82 as=0.169 ps=1.82 w=0.65 l=0.15
X1042 a_58391_9295# a_57693_9301# a_58134_9269# VSS sky130_fd_pr__special_nfet_01v8 ad=0.0684 pd=0.74 as=0.0989 ps=0.995 w=0.36 l=0.15
X1043 a_77987_10205# a_77289_9839# a_77730_9951# VSS sky130_fd_pr__special_nfet_01v8 ad=0.0684 pd=0.74 as=0.0989 ps=0.995 w=0.36 l=0.15
X1044 a_72295_14518# _38_.A1 a_71836_14343# VDD sky130_fd_pr__pfet_01v8_hvt ad=0.0441 pd=0.63 as=0.1932 ps=1.34 w=0.42 l=0.15
X1045 a_65189_12043# macro_core.phase_delay\[0\].delay_cell.A a_65103_12043# VSS sky130_fd_pr__nfet_01v8 ad=0.0567 pd=0.69 as=0.1176 ps=1.4 w=0.42 l=0.15
X1046 macro_core.phase_delay\[46\].delay_cell.A macro_core.phase_delay\[44\].delay_cell.Y VDD VDD sky130_fd_pr__pfet_01v8_hvt ad=0.26 pd=2.52 as=0.26 ps=2.52 w=1 l=0.15
X1047 VDD macro_core.write_drive.X a_85227_20916# VDD sky130_fd_pr__pfet_01v8 ad=0.2436 pd=2.26 as=0.2436 ps=2.26 w=0.84 l=0.15
X1048 a_78669_14191# a_78503_14191# VDD VDD sky130_fd_pr__pfet_01v8_hvt ad=0.1664 pd=1.8 as=0.0864 ps=0.91 w=0.64 l=0.15
X1049 macro_core.phase_delay\[78\].delay_cell.Y macro_core.phase_delay\[77\].delay_cell.Y VSS VSS sky130_fd_pr__nfet_01v8 ad=0.169 pd=1.82 as=0.169 ps=1.82 w=0.65 l=0.15
X1050 VDD a_52522_3423# a_52449_3677# VDD sky130_fd_pr__pfet_01v8_hvt ad=0.17887 pd=1.26 as=0.07665 ps=0.785 w=0.42 l=0.15
X1051 a_49628_9839# a_49229_9839# a_49502_10205# VSS sky130_fd_pr__special_nfet_01v8 ad=0.0696 pd=0.765 as=0.0621 ps=0.705 w=0.36 l=0.15
X1052 macro_core.phase_delay\[44\].delay_cell.A macro_core.phase_delay\[43\].delay_cell.A VSS VSS sky130_fd_pr__nfet_01v8 ad=0.169 pd=1.82 as=0.169 ps=1.82 w=0.65 l=0.15
X1053 a_54065_2767# CSb a_53981_2767# VDD sky130_fd_pr__pfet_01v8_hvt ad=0.135 pd=1.27 as=0.135 ps=1.27 w=1 l=0.15
X1054 a_75035_14557# a_74253_14191# a_74951_14557# VDD sky130_fd_pr__pfet_01v8_hvt ad=0.0882 pd=0.84 as=0.0567 ps=0.69 w=0.42 l=0.15
X1055 VSS a_68432_11703# _49_.X VSS sky130_fd_pr__nfet_01v8 ad=0.11285 pd=1.045 as=0.169 ps=1.82 w=0.65 l=0.15
X1056 a_59937_12857# _84_.Q VDD VDD sky130_fd_pr__pfet_01v8_hvt ad=0.1176 pd=1.4 as=0.0693 ps=0.75 w=0.42 l=0.15
X1057 a_79215_50974# a_79167_50886# VSS VSS sky130_fd_pr__nfet_01v8 ad=0.3654 pd=3.1 as=0.3654 ps=3.1 w=1.26 l=0.15
X1058 a_44415_16496# macro_core.data_complement\[0\].complement.Y macro_core.array_and_peripherals.write_driver_0.BL VSS sky130_fd_pr__nfet_01v8 ad=1.4616 pd=10.66 as=1.4616 ps=10.66 w=5.04 l=0.15
X1059 macro_core.phase_delay\[15\].delay_cell.Y macro_core.phase_delay\[14\].delay_cell.Y VDD VDD sky130_fd_pr__pfet_01v8_hvt ad=0.26 pd=2.52 as=0.26 ps=2.52 w=1 l=0.15
X1060 VDD _42_.A1 macro_core.array_and_peripherals.sense_amp_1.SA_OUTB VDD sky130_fd_pr__pfet_01v8 ad=0.5481 pd=4.36 as=0.5481 ps=4.36 w=1.89 l=0.15
X1061 VDD macro_core.array_and_peripherals.sense_amp_3.SA_OUTB _40_.A1 VDD sky130_fd_pr__pfet_01v8 ad=0.5481 pd=4.36 as=0.5481 ps=4.36 w=1.89 l=0.15
X1062 DATA[5] a_71235_12015# a_71739_12015# VSS sky130_fd_pr__nfet_01v8 ad=0.286 pd=2.18 as=0.06825 ps=0.86 w=0.65 l=0.15
X1063 macro_core.phase_delay\[50\].delay_cell.A macro_core.phase_delay\[49\].delay_cell.A VSS VSS sky130_fd_pr__nfet_01v8 ad=0.169 pd=1.82 as=0.169 ps=1.82 w=0.65 l=0.15
X1064 VDD CLK a_62863_9295# VDD sky130_fd_pr__pfet_01v8_hvt ad=0.1625 pd=1.325 as=0.265 ps=2.53 w=1 l=0.15
X1065 macro_core.phase_delay\[14\].delay_cell.Y macro_core.phase_delay\[13\].delay_cell.Y VSS VSS sky130_fd_pr__nfet_01v8 ad=0.169 pd=1.82 as=0.169 ps=1.82 w=0.65 l=0.15
X1066 VDD a_77730_9951# a_77657_10205# VDD sky130_fd_pr__pfet_01v8_hvt ad=0.17887 pd=1.26 as=0.07665 ps=0.785 w=0.42 l=0.15
X1067 a_49417_9839# _75_.D VSS VSS sky130_fd_pr__nfet_01v8 ad=0.0813 pd=0.83 as=0.1092 ps=1.36 w=0.42 l=0.15
X1068 _48_.A0 a_63067_12283# VSS VSS sky130_fd_pr__nfet_01v8 ad=0.169 pd=1.82 as=0.08775 ps=0.92 w=0.65 l=0.15
X1069 a_68829_12015# _49_.X VSS VSS sky130_fd_pr__nfet_01v8 ad=0.0813 pd=0.83 as=0.1092 ps=1.36 w=0.42 l=0.15
X1070 VDD _86_.CLK a_55595_14191# VDD sky130_fd_pr__pfet_01v8_hvt ad=0.0864 pd=0.91 as=0.1664 ps=1.8 w=0.64 l=0.15
X1071 macro_core.phase_delay\[75\].delay_cell.Y macro_core.phase_delay\[74\].delay_cell.Y VDD VDD sky130_fd_pr__pfet_01v8_hvt ad=0.26 pd=2.52 as=0.26 ps=2.52 w=1 l=0.15
X1072 VDD a_71836_14343# _80_.D VDD sky130_fd_pr__pfet_01v8_hvt ad=0.15835 pd=1.395 as=0.26 ps=2.52 w=1 l=0.15
X1073 a_48886_11837# _84_.Q VSS VSS sky130_fd_pr__nfet_01v8 ad=0.0693 pd=0.75 as=0.11285 ps=1.045 w=0.42 l=0.15
X1074 DATA[3] a_59827_10383# a_60183_10383# VDD sky130_fd_pr__pfet_01v8_hvt ad=0.315 pd=2.63 as=0.475 ps=1.95 w=1 l=0.15
X1075 a_55497_10703# _34_.Y VSS VSS sky130_fd_pr__nfet_01v8 ad=0.08775 pd=0.92 as=0.169 ps=1.82 w=0.65 l=0.15
X1076 macro_core.array_and_peripherals.write_driver_6.BLB macro_core.sense_drive.X macro_core.array_and_peripherals.sense_amp_6.SA_OUTB VDD sky130_fd_pr__pfet_01v8 ad=0.58 pd=4.58 as=0.58 ps=4.58 w=2 l=0.15
X1077 macro_core.phase_delay\[53\].delay_cell.Y macro_core.phase_delay\[53\].delay_cell.A VDD VDD sky130_fd_pr__pfet_01v8_hvt ad=0.26 pd=2.52 as=0.26 ps=2.52 w=1 l=0.15
X1078 a_49167_45886# macro_core.array_and_peripherals.wl_driver_1.WL macro_core.array_and_peripherals.write_driver_1.BLB VSS sky130_fd_pr__nfet_01v8 ad=0.174 pd=1.78 as=0.174 ps=1.78 w=0.6 l=0.15
X1079 macro_core.sense_drive.X a_64611_14191# VSS VSS sky130_fd_pr__nfet_01v8 ad=0.091 pd=0.93 as=0.091 ps=0.93 w=0.65 l=0.15
X1080 VDD a_51872_11703# _45_.X VDD sky130_fd_pr__pfet_01v8_hvt ad=0.15835 pd=1.395 as=0.26 ps=2.52 w=1 l=0.15
X1081 VSS macro_core.sense_drive.X a_43615_26902# VSS sky130_fd_pr__nfet_01v8 ad=0.2842 pd=2.54 as=0.2842 ps=2.54 w=0.98 l=0.15
X1082 a_74652_14191# a_74253_14191# a_74526_14557# VSS sky130_fd_pr__special_nfet_01v8 ad=0.0696 pd=0.765 as=0.0621 ps=0.705 w=0.36 l=0.15
X1083 VSS a_56459_14557# a_56627_14459# VSS sky130_fd_pr__nfet_01v8 ad=0.08775 pd=0.92 as=0.169 ps=1.82 w=0.65 l=0.15
X1084 a_54753_11471# _77_.D VSS VSS sky130_fd_pr__nfet_01v8 ad=0.0813 pd=0.83 as=0.1092 ps=1.36 w=0.42 l=0.15
X1085 VDD macro_core.qualify_row\[2\].qualify.X a_36227_51432# VDD sky130_fd_pr__pfet_01v8 ad=0.4872 pd=3.94 as=0.4872 ps=3.94 w=1.68 l=0.15
X1086 macro_core.qualify_row\[1\].qualify.X a_12663_36833# VSS VSS sky130_fd_pr__nfet_01v8 ad=0.182 pd=1.86 as=0.1118 ps=1.04 w=0.65 l=0.15
X1087 a_14313_36833# macro_core.qualify_row\[2\].qualify.A a_14227_36833# VSS sky130_fd_pr__nfet_01v8 ad=0.0567 pd=0.69 as=0.1176 ps=1.4 w=0.42 l=0.15
X1088 VSS a_61642_14191# macro_core.write_drive.X VSS sky130_fd_pr__nfet_01v8 ad=0.091 pd=0.93 as=0.091 ps=0.93 w=0.65 l=0.15
X1089 VSS macro_core.phase_delay\[0\].delay_cell.A a_73259_12015# VSS sky130_fd_pr__nfet_01v8 ad=0.0567 pd=0.69 as=0.1092 ps=1.36 w=0.42 l=0.15
X1090 VDD macro_core.array_and_peripherals.sense_amp_6.SA_OUTB _37_.A1 VDD sky130_fd_pr__pfet_01v8 ad=0.5481 pd=4.36 as=0.5481 ps=4.36 w=1.89 l=0.15
X1091 a_46949_14455# _86_.CLK VDD VDD sky130_fd_pr__pfet_01v8_hvt ad=0.07438 pd=0.815 as=0.0567 ps=0.69 w=0.42 l=0.15
X1092 VDD macro_core.phase_delay\[0\].delay_cell.A _65_.Y VDD sky130_fd_pr__pfet_01v8_hvt ad=0.2352 pd=2.24 as=0.1134 ps=1.11 w=0.84 l=0.15
X1093 VSS a_73866_12127# a_73824_12015# VSS sky130_fd_pr__nfet_01v8 ad=0.12095 pd=1.085 as=0.0696 ps=0.765 w=0.42 l=0.15
X1094 macro_core.phase_delay\[10\].delay_cell.Y macro_core.phase_delay\[10\].delay_cell.A VSS VSS sky130_fd_pr__nfet_01v8 ad=0.169 pd=1.82 as=0.169 ps=1.82 w=0.65 l=0.15
X1095 VDD _39_.A1 macro_core.array_and_peripherals.sense_amp_4.SA_OUTB VDD sky130_fd_pr__pfet_01v8 ad=0.5481 pd=4.36 as=0.5481 ps=4.36 w=1.89 l=0.15
X1096 a_50369_14165# _84_.Q VSS VSS sky130_fd_pr__nfet_01v8 ad=0.1092 pd=1.36 as=0.1449 ps=1.11 w=0.42 l=0.15
X1097 VSS a_56288_13879# _47_.X VSS sky130_fd_pr__nfet_01v8 ad=0.11285 pd=1.045 as=0.169 ps=1.82 w=0.65 l=0.15
X1098 VSS a_36227_51432# macro_core.array_and_peripherals.wl_driver_2.WL VSS sky130_fd_pr__nfet_01v8 ad=1.4616 pd=10.66 as=1.4616 ps=10.66 w=5.04 l=0.15
X1099 VDD a_72265_14165# a_72295_14518# VDD sky130_fd_pr__pfet_01v8_hvt ad=0.0693 pd=0.75 as=0.0441 ps=0.63 w=0.42 l=0.15
X1100 DATA[0] a_52007_9839# a_52363_10089# VDD sky130_fd_pr__pfet_01v8_hvt ad=0.315 pd=2.63 as=0.475 ps=1.95 w=1 l=0.15
X1101 _54_.Y _84_.Q a_71413_11791# VSS sky130_fd_pr__nfet_01v8 ad=0.169 pd=1.82 as=0.08775 ps=0.92 w=0.65 l=0.15
X1102 macro_core.array_and_peripherals.write_driver_0.BLB macro_core.precharge_drive.X macro_core.array_and_peripherals.write_driver_0.BL VDD sky130_fd_pr__pfet_01v8 ad=0.7308 pd=5.62 as=0.7308 ps=5.62 w=2.52 l=0.15
X1103 a_59937_12857# _84_.Q VSS VSS sky130_fd_pr__nfet_01v8 ad=0.1092 pd=1.36 as=0.1449 ps=1.11 w=0.42 l=0.15
X1104 VDD _61_.Y a_54399_11477# VDD sky130_fd_pr__pfet_01v8_hvt ad=0.0864 pd=0.91 as=0.1664 ps=1.8 w=0.64 l=0.15
X1105 macro_core.phase_delay\[44\].delay_cell.Y macro_core.phase_delay\[44\].delay_cell.A VSS VSS sky130_fd_pr__nfet_01v8 ad=0.169 pd=1.82 as=0.169 ps=1.82 w=0.65 l=0.15
X1106 VSS a_58539_10383# _86_.CLK VSS sky130_fd_pr__nfet_01v8 ad=0.1092 pd=1.36 as=0.0567 ps=0.69 w=0.42 l=0.15
X1107 a_49215_45974# a_49167_45886# VSS VSS sky130_fd_pr__nfet_01v8 ad=0.3654 pd=3.1 as=0.3654 ps=3.1 w=1.26 l=0.15
X1108 a_56585_14191# a_55595_14191# a_56459_14557# VSS sky130_fd_pr__special_nfet_01v8 ad=0.066 pd=0.745 as=0.0684 ps=0.74 w=0.36 l=0.15
X1109 a_48886_11510# _84_.Q VDD VDD sky130_fd_pr__pfet_01v8_hvt ad=0.07665 pd=0.785 as=0.15835 ps=1.395 w=0.42 l=0.15
X1110 VSS a_55263_11471# a_55431_11445# VSS sky130_fd_pr__nfet_01v8 ad=0.08775 pd=0.92 as=0.169 ps=1.82 w=0.65 l=0.15
X1111 VDD a_55263_11471# a_55431_11445# VDD sky130_fd_pr__pfet_01v8_hvt ad=0.135 pd=1.27 as=0.27 ps=2.54 w=1 l=0.15
X1112 a_85215_50974# a_85167_50886# VDD VDD sky130_fd_pr__pfet_01v8 ad=0.1218 pd=1.42 as=0.1218 ps=1.42 w=0.42 l=0.15
X1113 a_85215_45974# macro_core.array_and_peripherals.wl_driver_1.WL macro_core.array_and_peripherals.write_driver_7.BL VSS sky130_fd_pr__nfet_01v8 ad=0.174 pd=1.78 as=0.174 ps=1.78 w=0.6 l=0.15
X1114 VDD a_67851_13621# a_67767_13647# VDD sky130_fd_pr__pfet_01v8_hvt ad=0.1113 pd=1.37 as=0.0882 ps=0.84 w=0.42 l=0.15
X1115 VSS a_49173_11769# a_49107_11837# VSS sky130_fd_pr__nfet_01v8 ad=0.1449 pd=1.11 as=0.0693 ps=0.75 w=0.42 l=0.15
X1116 a_50027_20496# macro_core.data_complement\[1\].complement.Y macro_core.array_and_peripherals.write_driver_1.BL VDD sky130_fd_pr__pfet_01v8 ad=1.4616 pd=10.66 as=1.4616 ps=10.66 w=5.04 l=0.15
X1117 _47_.A0 a_56627_14459# VDD VDD sky130_fd_pr__pfet_01v8_hvt ad=0.26 pd=2.52 as=0.135 ps=1.27 w=1 l=0.15
X1118 VDD macro_core.phase_delay\[79\].delay_cell.Y a_64611_14191# VDD sky130_fd_pr__pfet_01v8_hvt ad=0.1775 pd=1.355 as=0.14 ps=1.28 w=1 l=0.15
X1119 a_57693_9301# a_57527_9301# VSS VSS sky130_fd_pr__nfet_01v8 ad=0.1092 pd=1.36 as=0.0567 ps=0.69 w=0.42 l=0.15
X1120 a_75363_10089# _35_.Y VDD VDD sky130_fd_pr__pfet_01v8_hvt ad=0.475 pd=1.95 as=0.27 ps=2.54 w=1 l=0.15
X1121 _75_.Q a_50095_10107# VSS VSS sky130_fd_pr__nfet_01v8 ad=0.169 pd=1.82 as=0.08775 ps=0.92 w=0.65 l=0.15
X1122 a_67167_45886# macro_core.array_and_peripherals.wl_driver_1.WL macro_core.array_and_peripherals.write_driver_4.BLB VSS sky130_fd_pr__nfet_01v8 ad=0.174 pd=1.78 as=0.174 ps=1.78 w=0.6 l=0.15
X1123 a_55615_26902# macro_core.array_and_peripherals.sense_amp_2.SA_OUTB _41_.A1 VSS sky130_fd_pr__nfet_01v8 ad=0.2842 pd=2.54 as=0.2842 ps=2.54 w=0.98 l=0.15
X1124 a_85167_45886# a_85215_45974# VDD VDD sky130_fd_pr__pfet_01v8 ad=0.1218 pd=1.42 as=0.1218 ps=1.42 w=0.42 l=0.15
X1125 a_55263_11471# a_54399_11477# a_55006_11445# VDD sky130_fd_pr__pfet_01v8_hvt ad=0.0567 pd=0.69 as=0.1095 ps=1.075 w=0.42 l=0.15
X1126 VSS macro_core.write_drive.X a_64015_16496# VSS sky130_fd_pr__nfet_01v8 ad=1.4616 pd=10.66 as=1.4616 ps=10.66 w=5.04 l=0.15
X1127 a_76015_16496# _50_.A0 macro_core.array_and_peripherals.write_driver_5.BLB VSS sky130_fd_pr__nfet_01v8 ad=1.4616 pd=10.66 as=1.4616 ps=10.66 w=5.04 l=0.15
X1128 a_58893_14191# _44_.Y VSS VSS sky130_fd_pr__nfet_01v8 ad=0.0813 pd=0.83 as=0.1092 ps=1.36 w=0.42 l=0.15
X1129 a_75934_14518# _84_.Q VDD VDD sky130_fd_pr__pfet_01v8_hvt ad=0.07665 pd=0.785 as=0.15835 ps=1.395 w=0.42 l=0.15
X1130 DATA[1] a_51915_12015# a_52271_12265# VDD sky130_fd_pr__pfet_01v8_hvt ad=0.315 pd=2.63 as=0.475 ps=1.95 w=1 l=0.15
X1131 DATA[6] a_75191_12015# a_75547_12265# VDD sky130_fd_pr__pfet_01v8_hvt ad=0.315 pd=2.63 as=0.475 ps=1.95 w=1 l=0.15
X1132 a_48744_11703# _75_.Q a_48886_11510# VDD sky130_fd_pr__pfet_01v8_hvt ad=0.1932 pd=1.34 as=0.07665 ps=0.785 w=0.42 l=0.15
X1133 VSS a_77730_9951# a_77688_9839# VSS sky130_fd_pr__nfet_01v8 ad=0.12095 pd=1.085 as=0.0696 ps=0.765 w=0.42 l=0.15
X1134 macro_core.phase_delay\[66\].delay_cell.Y macro_core.phase_delay\[65\].delay_cell.Y VSS VSS sky130_fd_pr__nfet_01v8 ad=0.169 pd=1.82 as=0.169 ps=1.82 w=0.65 l=0.15
X1135 a_77562_10205# a_77123_9839# a_77477_9839# VSS sky130_fd_pr__special_nfet_01v8 ad=0.0621 pd=0.705 as=0.0813 ps=0.83 w=0.36 l=0.15
X1136 macro_core.phase_delay\[54\].delay_cell.Y macro_core.phase_delay\[53\].delay_cell.Y VDD VDD sky130_fd_pr__pfet_01v8_hvt ad=0.26 pd=2.52 as=0.26 ps=2.52 w=1 l=0.15
X1137 macro_core.phase_delay\[38\].delay_cell.Y macro_core.phase_delay\[37\].delay_cell.Y VDD VDD sky130_fd_pr__pfet_01v8_hvt ad=0.26 pd=2.52 as=0.26 ps=2.52 w=1 l=0.15
X1138 VDD macro_core.precharge_drive.X macro_core.array_and_peripherals.write_driver_3.BL VDD sky130_fd_pr__pfet_01v8 ad=0.7308 pd=5.62 as=0.7308 ps=5.62 w=2.52 l=0.15
X1139 a_67683_13647# a_66985_13653# a_67426_13621# VSS sky130_fd_pr__special_nfet_01v8 ad=0.0684 pd=0.74 as=0.0989 ps=0.995 w=0.36 l=0.15
X1140 VDD macro_core.precharge_drive.X macro_core.array_and_peripherals.write_driver_1.BLB VDD sky130_fd_pr__pfet_01v8 ad=0.7308 pd=5.62 as=0.7308 ps=5.62 w=2.52 l=0.15
X1141 macro_core.phase_delay\[10\].delay_cell.A macro_core.phase_delay\[8\].delay_cell.Y VSS VSS sky130_fd_pr__nfet_01v8 ad=0.169 pd=1.82 as=0.169 ps=1.82 w=0.65 l=0.15
X1142 VSS a_52779_3677# a_52947_3579# VSS sky130_fd_pr__nfet_01v8 ad=0.08775 pd=0.92 as=0.169 ps=1.82 w=0.65 l=0.15
X1143 a_58475_9295# a_57693_9301# a_58391_9295# VDD sky130_fd_pr__pfet_01v8_hvt ad=0.0882 pd=0.84 as=0.0567 ps=0.69 w=0.42 l=0.15
X1144 VDD _84_.Q _35_.Y VDD sky130_fd_pr__pfet_01v8_hvt ad=0.26 pd=2.52 as=0.135 ps=1.27 w=1 l=0.15
X1145 a_49502_10205# a_49229_9839# a_49417_9839# VDD sky130_fd_pr__pfet_01v8_hvt ad=0.06825 pd=0.745 as=0.05775 ps=0.695 w=0.42 l=0.15
X1146 a_73215_55974# macro_core.array_and_peripherals.wl_driver_3.WL macro_core.array_and_peripherals.write_driver_5.BL VSS sky130_fd_pr__nfet_01v8 ad=0.174 pd=1.78 as=0.174 ps=1.78 w=0.6 l=0.15
X1147 a_73215_40974# macro_core.array_and_peripherals.wl_driver_0.WL macro_core.array_and_peripherals.write_driver_5.BL VSS sky130_fd_pr__nfet_01v8 ad=0.174 pd=1.78 as=0.174 ps=1.78 w=0.6 l=0.15
X1148 VDD a_55006_11445# a_54933_11471# VDD sky130_fd_pr__pfet_01v8_hvt ad=0.17887 pd=1.26 as=0.07665 ps=0.785 w=0.42 l=0.15
X1149 DATA[0] a_52007_9839# a_52511_9839# VSS sky130_fd_pr__nfet_01v8 ad=0.286 pd=2.18 as=0.06825 ps=0.86 w=0.65 l=0.15
X1150 a_77289_9839# a_77123_9839# VDD VDD sky130_fd_pr__pfet_01v8_hvt ad=0.1664 pd=1.8 as=0.0864 ps=0.91 w=0.64 l=0.15
X1151 a_56191_10703# a_55853_10383# VSS VSS sky130_fd_pr__nfet_01v8 ad=0.06825 pd=0.86 as=0.2275 ps=2 w=0.65 l=0.15
X1152 a_55167_40886# macro_core.array_and_peripherals.wl_driver_0.WL macro_core.array_and_peripherals.write_driver_2.BLB VSS sky130_fd_pr__nfet_01v8 ad=0.174 pd=1.78 as=0.174 ps=1.78 w=0.6 l=0.15
X1153 a_74253_14191# a_74087_14191# VSS VSS sky130_fd_pr__nfet_01v8 ad=0.1092 pd=1.36 as=0.0567 ps=0.69 w=0.42 l=0.15
X1154 VDD a_77879_12283# a_77795_12381# VDD sky130_fd_pr__pfet_01v8_hvt ad=0.1113 pd=1.37 as=0.0882 ps=0.84 w=0.42 l=0.15
X1155 macro_core.phase_delay\[28\].delay_cell.A macro_core.phase_delay\[26\].delay_cell.Y VDD VDD sky130_fd_pr__pfet_01v8_hvt ad=0.26 pd=2.52 as=0.26 ps=2.52 w=1 l=0.15
X1156 a_55167_55886# macro_core.array_and_peripherals.wl_driver_3.WL macro_core.array_and_peripherals.write_driver_2.BLB VSS sky130_fd_pr__nfet_01v8 ad=0.174 pd=1.78 as=0.174 ps=1.78 w=0.6 l=0.15
X1157 a_62642_12127# a_62474_12381# VDD VDD sky130_fd_pr__pfet_01v8_hvt ad=0.1095 pd=1.075 as=0.17887 ps=1.26 w=0.75 l=0.15
X1158 VSS a_62899_12381# a_63067_12283# VSS sky130_fd_pr__nfet_01v8 ad=0.08775 pd=0.92 as=0.169 ps=1.82 w=0.65 l=0.15
X1159 a_73167_40886# a_73215_40974# VDD VDD sky130_fd_pr__pfet_01v8 ad=0.1218 pd=1.42 as=0.1218 ps=1.42 w=0.42 l=0.15
X1160 a_68027_20496# macro_core.data_complement\[4\].complement.Y macro_core.array_and_peripherals.write_driver_4.BL VDD sky130_fd_pr__pfet_01v8 ad=1.4616 pd=10.66 as=1.4616 ps=10.66 w=5.04 l=0.15
X1161 a_49203_11510# _43_.A1 a_48744_11703# VDD sky130_fd_pr__pfet_01v8_hvt ad=0.0441 pd=0.63 as=0.1932 ps=1.34 w=0.42 l=0.15
X1162 a_58092_9673# a_57693_9301# a_57966_9295# VSS sky130_fd_pr__special_nfet_01v8 ad=0.0696 pd=0.765 as=0.0621 ps=0.705 w=0.36 l=0.15
X1163 a_77688_9839# a_77289_9839# a_77562_10205# VSS sky130_fd_pr__special_nfet_01v8 ad=0.0696 pd=0.765 as=0.0621 ps=0.705 w=0.36 l=0.15
X1164 a_73167_55886# a_73215_55974# VDD VDD sky130_fd_pr__pfet_01v8 ad=0.1218 pd=1.42 as=0.1218 ps=1.42 w=0.42 l=0.15
X1165 VDD macro_core.evaluation.X macro_core.array_and_peripherals.row_decoder_0.N1 VDD sky130_fd_pr__pfet_01v8 ad=0.3625 pd=3.08 as=0.3625 ps=3.08 w=1.25 l=0.15
X1166 a_45627_20496# _45_.A0 macro_core.array_and_peripherals.write_driver_0.BLB VDD sky130_fd_pr__pfet_01v8 ad=1.4616 pd=10.66 as=1.4616 ps=10.66 w=5.04 l=0.15
X1167 VDD a_55227_20916# a_57627_20496# VDD sky130_fd_pr__pfet_01v8 ad=1.4616 pd=10.66 as=1.4616 ps=10.66 w=5.04 l=0.15
X1168 a_68125_14165# _84_.Q VSS VSS sky130_fd_pr__nfet_01v8 ad=0.1092 pd=1.36 as=0.1449 ps=1.11 w=0.42 l=0.15
X1169 macro_core.phase_delay\[7\].delay_cell.Y macro_core.phase_delay\[6\].delay_cell.Y VSS VSS sky130_fd_pr__nfet_01v8 ad=0.169 pd=1.82 as=0.169 ps=1.82 w=0.65 l=0.15
X1170 VSS macro_core.write_drive.X a_80415_16496# VSS sky130_fd_pr__nfet_01v8 ad=1.4616 pd=10.66 as=1.4616 ps=10.66 w=5.04 l=0.15
X1171 a_57969_12015# a_57803_12015# VDD VDD sky130_fd_pr__pfet_01v8_hvt ad=0.1664 pd=1.8 as=0.0864 ps=0.91 w=0.64 l=0.15
X1172 a_50019_12381# a_49155_12015# a_49762_12127# VDD sky130_fd_pr__pfet_01v8_hvt ad=0.0567 pd=0.69 as=0.1095 ps=1.075 w=0.42 l=0.15
X1173 macro_core.phase_delay\[74\].delay_cell.Y macro_core.phase_delay\[73\].delay_cell.Y VSS VSS sky130_fd_pr__nfet_01v8 ad=0.169 pd=1.82 as=0.169 ps=1.82 w=0.65 l=0.15
X1174 a_55215_45974# a_55167_45886# VDD VDD sky130_fd_pr__pfet_01v8 ad=0.1218 pd=1.42 as=0.1218 ps=1.42 w=0.42 l=0.15
X1175 VDD a_79110_14303# a_79037_14557# VDD sky130_fd_pr__pfet_01v8_hvt ad=0.17887 pd=1.26 as=0.07665 ps=0.785 w=0.42 l=0.15
X1176 a_49689_12381# a_49155_12015# a_49594_12381# VDD sky130_fd_pr__pfet_01v8_hvt ad=0.07665 pd=0.785 as=0.06825 ps=0.745 w=0.42 l=0.15
X1177 VSS macro_core.write_drive.X a_67227_20916# VSS sky130_fd_pr__nfet_01v8 ad=0.2436 pd=2.26 as=0.2436 ps=2.26 w=0.84 l=0.15
X1178 a_76251_14518# _37_.A1 a_75792_14343# VDD sky130_fd_pr__pfet_01v8_hvt ad=0.0441 pd=0.63 as=0.1932 ps=1.34 w=0.42 l=0.15
X1179 VSS macro_core.array_and_peripherals.row_decoder_0.N3 macro_core.qualify_row\[3\].qualify.A VSS sky130_fd_pr__nfet_01v8 ad=0.58 pd=4.58 as=0.58 ps=4.58 w=2 l=0.15
X1180 VSS a_50187_12283# a_50145_12015# VSS sky130_fd_pr__nfet_01v8 ad=0.1092 pd=1.36 as=0.066 ps=0.745 w=0.42 l=0.15
X1181 a_51872_11703# _45_.A0 a_52014_11510# VDD sky130_fd_pr__pfet_01v8_hvt ad=0.1932 pd=1.34 as=0.07665 ps=0.785 w=0.42 l=0.15
X1182 _61_.Y _86_.CLK VDD VDD sky130_fd_pr__pfet_01v8_hvt ad=0.1134 pd=1.11 as=0.2184 ps=2.2 w=0.84 l=0.15
X1183 VSS _86_.CLK a_49707_3311# VSS sky130_fd_pr__nfet_01v8 ad=0.0567 pd=0.69 as=0.1092 ps=1.36 w=0.42 l=0.15
X1184 a_77477_9839# _52_.X VSS VSS sky130_fd_pr__nfet_01v8 ad=0.0813 pd=0.83 as=0.1092 ps=1.36 w=0.42 l=0.15
X1185 macro_core.phase_delay\[64\].delay_cell.Y macro_core.phase_delay\[64\].delay_cell.A VDD VDD sky130_fd_pr__pfet_01v8_hvt ad=0.26 pd=2.52 as=0.26 ps=2.52 w=1 l=0.15
X1186 a_59993_10383# _56_.Y VSS VSS sky130_fd_pr__nfet_01v8 ad=0.2583 pd=2.07 as=0.09813 ps=1.005 w=0.42 l=0.15
X1187 a_61215_50974# macro_core.array_and_peripherals.wl_driver_2.WL macro_core.array_and_peripherals.write_driver_3.BL VSS sky130_fd_pr__nfet_01v8 ad=0.174 pd=1.78 as=0.174 ps=1.78 w=0.6 l=0.15
X1188 a_61167_45886# a_61215_45974# VSS VSS sky130_fd_pr__nfet_01v8 ad=0.3654 pd=3.1 as=0.3654 ps=3.1 w=1.26 l=0.15
X1189 _51_.A0 a_79535_14459# VDD VDD sky130_fd_pr__pfet_01v8_hvt ad=0.26 pd=2.52 as=0.135 ps=1.27 w=1 l=0.15
X1190 a_77013_12015# a_76847_12015# VDD VDD sky130_fd_pr__pfet_01v8_hvt ad=0.1664 pd=1.8 as=0.0864 ps=0.91 w=0.64 l=0.15
X1191 a_76865_9593# _44_.Y VDD VDD sky130_fd_pr__pfet_01v8_hvt ad=0.1176 pd=1.4 as=0.0693 ps=0.75 w=0.42 l=0.15
X1192 VDD _86_.CLK a_57527_9301# VDD sky130_fd_pr__pfet_01v8_hvt ad=0.0864 pd=0.91 as=0.1664 ps=1.8 w=0.64 l=0.15
X1193 VDD macro_core.precharge_drive.X macro_core.array_and_peripherals.write_driver_4.BLB VDD sky130_fd_pr__pfet_01v8 ad=0.7308 pd=5.62 as=0.7308 ps=5.62 w=2.52 l=0.15
X1194 VDD macro_core.precharge_drive.X macro_core.array_and_peripherals.write_driver_6.BL VDD sky130_fd_pr__pfet_01v8 ad=0.7308 pd=5.62 as=0.7308 ps=5.62 w=2.52 l=0.15
X1195 a_58157_12015# _78_.D VDD VDD sky130_fd_pr__pfet_01v8_hvt ad=0.05775 pd=0.695 as=0.1092 ps=1.36 w=0.42 l=0.15
X1196 a_69339_12381# a_68641_12015# a_69082_12127# VSS sky130_fd_pr__special_nfet_01v8 ad=0.0684 pd=0.74 as=0.0989 ps=0.995 w=0.36 l=0.15
X1197 a_78071_10205# a_77289_9839# a_77987_10205# VDD sky130_fd_pr__pfet_01v8_hvt ad=0.0882 pd=0.84 as=0.0567 ps=0.69 w=0.42 l=0.15
X1198 a_43167_50886# macro_core.array_and_peripherals.wl_driver_2.WL macro_core.array_and_peripherals.write_driver_0.BLB VSS sky130_fd_pr__nfet_01v8 ad=0.174 pd=1.78 as=0.174 ps=1.78 w=0.6 l=0.15
X1199 macro_core.qualify_row\[3\].qualify.X a_15147_35745# VSS VSS sky130_fd_pr__nfet_01v8 ad=0.182 pd=1.86 as=0.1118 ps=1.04 w=0.65 l=0.15
X1200 VDD macro_core.array_and_peripherals.row_decoder_0.A1B macro_core.array_and_peripherals.row_decoder_0.A1T VDD sky130_fd_pr__pfet_01v8 ad=0.58 pd=4.58 as=0.58 ps=4.58 w=2 l=0.15
X1201 _65_.Y macro_core.phase_delay\[0\].delay_cell.A VDD VDD sky130_fd_pr__pfet_01v8_hvt ad=0.1134 pd=1.11 as=0.2184 ps=2.2 w=0.84 l=0.15
X1202 macro_core.phase_delay\[36\].delay_cell.Y macro_core.phase_delay\[35\].delay_cell.Y VSS VSS sky130_fd_pr__nfet_01v8 ad=0.169 pd=1.82 as=0.169 ps=1.82 w=0.65 l=0.15
X1203 a_61167_50886# a_61215_50974# VDD VDD sky130_fd_pr__pfet_01v8 ad=0.1218 pd=1.42 as=0.1218 ps=1.42 w=0.42 l=0.15
X1204 macro_core.phase_delay\[51\].delay_cell.Y macro_core.phase_delay\[51\].delay_cell.A VDD VDD sky130_fd_pr__pfet_01v8_hvt ad=0.26 pd=2.52 as=0.26 ps=2.52 w=1 l=0.15
X1205 VDD a_73227_20916# a_74027_20496# VDD sky130_fd_pr__pfet_01v8 ad=1.4616 pd=10.66 as=1.4616 ps=10.66 w=5.04 l=0.15
X1206 a_63682_14191# macro_core.evaluation.A a_63599_14191# VSS sky130_fd_pr__nfet_01v8 ad=0.06825 pd=0.86 as=0.17225 ps=1.83 w=0.65 l=0.15
X1207 a_47104_14197# _86_.CLK a_47032_14197# VSS sky130_fd_pr__nfet_01v8 ad=0.05355 pd=0.675 as=0.0441 ps=0.63 w=0.42 l=0.15
X1208 VDD a_64611_14191# macro_core.sense_drive.X VDD sky130_fd_pr__pfet_01v8_hvt ad=0.285 pd=2.57 as=0.14 ps=1.28 w=1 l=0.15
X1209 a_68914_12381# a_68641_12015# a_68829_12015# VDD sky130_fd_pr__pfet_01v8_hvt ad=0.06825 pd=0.745 as=0.05775 ps=0.695 w=0.42 l=0.15
X1210 _86_.CLK a_58539_10383# VSS VSS sky130_fd_pr__nfet_01v8 ad=0.0567 pd=0.69 as=0.06825 ps=0.745 w=0.42 l=0.15
X1211 a_77201_12015# _82_.D VDD VDD sky130_fd_pr__pfet_01v8_hvt ad=0.05775 pd=0.695 as=0.1092 ps=1.36 w=0.42 l=0.15
X1212 VSS a_76865_9593# a_76799_9661# VSS sky130_fd_pr__nfet_01v8 ad=0.1449 pd=1.11 as=0.0693 ps=0.75 w=0.42 l=0.15
X1213 a_43215_55974# a_43167_55886# VDD VDD sky130_fd_pr__pfet_01v8 ad=0.1218 pd=1.42 as=0.1218 ps=1.42 w=0.42 l=0.15
X1214 a_43215_40974# a_43167_40886# VDD VDD sky130_fd_pr__pfet_01v8 ad=0.1218 pd=1.42 as=0.1218 ps=1.42 w=0.42 l=0.15
X1215 a_53063_13103# _46_.A0 a_52700_13255# VSS sky130_fd_pr__nfet_01v8 ad=0.0693 pd=0.75 as=0.09975 ps=0.895 w=0.42 l=0.15
X1216 VDD macro_core.write_drive.X a_49227_20916# VDD sky130_fd_pr__pfet_01v8 ad=0.2436 pd=2.26 as=0.2436 ps=2.26 w=0.84 l=0.15
X1217 a_52890_14303# a_52722_14557# VDD VDD sky130_fd_pr__pfet_01v8_hvt ad=0.1095 pd=1.075 as=0.17887 ps=1.26 w=0.75 l=0.15
X1218 VDD a_56459_14557# a_56627_14459# VDD sky130_fd_pr__pfet_01v8_hvt ad=0.135 pd=1.27 as=0.27 ps=2.54 w=1 l=0.15
X1219 VSS _63_.Y a_66819_13653# VSS sky130_fd_pr__nfet_01v8 ad=0.0567 pd=0.69 as=0.1092 ps=1.36 w=0.42 l=0.15
X1220 macro_core.phase_delay\[26\].delay_cell.Y macro_core.phase_delay\[26\].delay_cell.A VDD VDD sky130_fd_pr__pfet_01v8_hvt ad=0.26 pd=2.52 as=0.26 ps=2.52 w=1 l=0.15
X1221 DATA[2] a_55687_10383# a_56191_10703# VSS sky130_fd_pr__nfet_01v8 ad=0.286 pd=2.18 as=0.06825 ps=0.86 w=0.65 l=0.15
X1222 a_79167_45886# a_79215_45974# VSS VSS sky130_fd_pr__nfet_01v8 ad=0.3654 pd=3.1 as=0.3654 ps=3.1 w=1.26 l=0.15
X1223 VSS _33_.Y a_49063_9839# VSS sky130_fd_pr__nfet_01v8 ad=0.0567 pd=0.69 as=0.1092 ps=1.36 w=0.42 l=0.15
X1224 VDD a_49173_11769# a_49203_11510# VDD sky130_fd_pr__pfet_01v8_hvt ad=0.0693 pd=0.75 as=0.0441 ps=0.63 w=0.42 l=0.15
X1225 a_52081_3311# a_51915_3311# VDD VDD sky130_fd_pr__pfet_01v8_hvt ad=0.1664 pd=1.8 as=0.0864 ps=0.91 w=0.64 l=0.15
X1226 _86_.Q a_50739_3579# VSS VSS sky130_fd_pr__nfet_01v8 ad=0.169 pd=1.82 as=0.08775 ps=0.92 w=0.65 l=0.15
X1227 a_57969_12015# a_57803_12015# VSS VSS sky130_fd_pr__nfet_01v8 ad=0.1092 pd=1.36 as=0.0567 ps=0.69 w=0.42 l=0.15
X1228 VSS a_74291_12283# a_74249_12015# VSS sky130_fd_pr__nfet_01v8 ad=0.1092 pd=1.36 as=0.066 ps=0.745 w=0.42 l=0.15
X1229 a_79167_50886# a_79215_50974# VDD VDD sky130_fd_pr__pfet_01v8 ad=0.1218 pd=1.42 as=0.1218 ps=1.42 w=0.42 l=0.15
X1230 VSS a_52890_14303# a_52848_14191# VSS sky130_fd_pr__nfet_01v8 ad=0.12095 pd=1.085 as=0.0696 ps=0.765 w=0.42 l=0.15
X1231 a_66985_13653# a_66819_13653# VDD VDD sky130_fd_pr__pfet_01v8_hvt ad=0.1664 pd=1.8 as=0.0864 ps=0.91 w=0.64 l=0.15
X1232 VDD _88_.A a_51915_12015# VDD sky130_fd_pr__pfet_01v8_hvt ad=0.0864 pd=0.91 as=0.1664 ps=1.8 w=0.64 l=0.15
X1233 VSS _88_.A a_51915_12015# VSS sky130_fd_pr__nfet_01v8 ad=0.09813 pd=1.005 as=0.1092 ps=1.36 w=0.42 l=0.15
X1234 _35_.Y _34_.Y VDD VDD sky130_fd_pr__pfet_01v8_hvt ad=0.135 pd=1.27 as=0.26 ps=2.52 w=1 l=0.15
X1235 macro_core.array_and_peripherals.write_driver_0.BLB macro_core.sense_drive.X macro_core.array_and_peripherals.sense_amp_0.SA_OUTB VDD sky130_fd_pr__pfet_01v8 ad=0.58 pd=4.58 as=0.58 ps=4.58 w=2 l=0.15
X1236 _41_.A1 macro_core.sense_drive.X macro_core.array_and_peripherals.write_driver_2.BL VDD sky130_fd_pr__pfet_01v8 ad=0.58 pd=4.58 as=0.58 ps=4.58 w=2 l=0.15
X1237 a_55615_26902# _41_.A1 macro_core.array_and_peripherals.sense_amp_2.SA_OUTB VSS sky130_fd_pr__nfet_01v8 ad=0.2842 pd=2.54 as=0.2842 ps=2.54 w=0.98 l=0.15
X1238 VSS _65_.Y a_74087_14191# VSS sky130_fd_pr__nfet_01v8 ad=0.0567 pd=0.69 as=0.1092 ps=1.36 w=0.42 l=0.15
X1239 VDD a_63599_14191# macro_core.precharge_drive.X VDD sky130_fd_pr__pfet_01v8_hvt ad=0.14 pd=1.28 as=0.14 ps=1.28 w=1 l=0.15
X1240 a_77013_12015# a_76847_12015# VSS VSS sky130_fd_pr__nfet_01v8 ad=0.1092 pd=1.36 as=0.0567 ps=0.69 w=0.42 l=0.15
X1241 a_85215_55974# a_85167_55886# VSS VSS sky130_fd_pr__nfet_01v8 ad=0.3654 pd=3.1 as=0.3654 ps=3.1 w=1.26 l=0.15
X1242 a_85215_40974# a_85167_40886# VSS VSS sky130_fd_pr__nfet_01v8 ad=0.3654 pd=3.1 as=0.3654 ps=3.1 w=1.26 l=0.15
X1243 VDD macro_core.array_and_peripherals.row_decoder_0.N3 macro_core.qualify_row\[3\].qualify.A VDD sky130_fd_pr__pfet_01v8 ad=0.87 pd=6.58 as=0.87 ps=6.58 w=3 l=0.15
X1244 macro_core.data_complement\[4\].complement.Y _49_.A0 VSS VSS sky130_fd_pr__nfet_01v8 ad=0.169 pd=1.82 as=0.169 ps=1.82 w=0.65 l=0.15
X1245 a_48744_11703# _43_.A1 a_48886_11837# VSS sky130_fd_pr__nfet_01v8 ad=0.09975 pd=0.895 as=0.0693 ps=0.75 w=0.42 l=0.15
X1246 a_67167_55886# a_67215_55974# VSS VSS sky130_fd_pr__nfet_01v8 ad=0.3654 pd=3.1 as=0.3654 ps=3.1 w=1.26 l=0.15
X1247 a_67167_40886# a_67215_40974# VSS VSS sky130_fd_pr__nfet_01v8 ad=0.3654 pd=3.1 as=0.3654 ps=3.1 w=1.26 l=0.15
X1248 macro_core.array_and_peripherals.row_decoder_0.EVAL_GND macro_core.array_and_peripherals.row_decoder_0.A0B macro_core.array_and_peripherals.row_decoder_0.net1 VSS sky130_fd_pr__nfet_01v8 ad=0.58 pd=4.58 as=0.58 ps=4.58 w=2 l=0.15
X1249 VDD a_53315_14459# a_53231_14557# VDD sky130_fd_pr__pfet_01v8_hvt ad=0.1113 pd=1.37 as=0.0882 ps=0.84 w=0.42 l=0.15
X1250 a_78857_14191# _51_.X VDD VDD sky130_fd_pr__pfet_01v8_hvt ad=0.05775 pd=0.695 as=0.1092 ps=1.36 w=0.42 l=0.15
X1251 a_52779_3677# a_51915_3311# a_52522_3423# VDD sky130_fd_pr__pfet_01v8_hvt ad=0.0567 pd=0.69 as=0.1095 ps=1.075 w=0.42 l=0.15
X1252 macro_core.phase_delay\[30\].delay_cell.Y macro_core.phase_delay\[30\].delay_cell.A VDD VDD sky130_fd_pr__pfet_01v8_hvt ad=0.26 pd=2.52 as=0.26 ps=2.52 w=1 l=0.15
X1253 a_63341_11769# _44_.Y VSS VSS sky130_fd_pr__nfet_01v8 ad=0.1092 pd=1.36 as=0.1449 ps=1.11 w=0.42 l=0.15
X1254 a_59403_14557# a_58539_14191# a_59146_14303# VDD sky130_fd_pr__pfet_01v8_hvt ad=0.0567 pd=0.69 as=0.1095 ps=1.075 w=0.42 l=0.15
X1255 VSS macro_core.precharge_phase.X a_63682_14191# VSS sky130_fd_pr__nfet_01v8 ad=0.13813 pd=1.075 as=0.06825 ps=0.86 w=0.65 l=0.15
X1256 a_55263_11471# a_54565_11477# a_55006_11445# VSS sky130_fd_pr__special_nfet_01v8 ad=0.0684 pd=0.74 as=0.0989 ps=0.995 w=0.36 l=0.15
X1257 a_59073_14557# a_58539_14191# a_58978_14557# VDD sky130_fd_pr__pfet_01v8_hvt ad=0.07665 pd=0.785 as=0.06825 ps=0.745 w=0.42 l=0.15
X1258 macro_core.phase_delay\[68\].delay_cell.Y macro_core.phase_delay\[67\].delay_cell.Y VDD VDD sky130_fd_pr__pfet_01v8_hvt ad=0.26 pd=2.52 as=0.26 ps=2.52 w=1 l=0.15
X1259 VSS a_50095_10107# a_50053_9839# VSS sky130_fd_pr__nfet_01v8 ad=0.1092 pd=1.36 as=0.066 ps=0.745 w=0.42 l=0.15
X1260 a_76221_14165# _84_.Q VDD VDD sky130_fd_pr__pfet_01v8_hvt ad=0.1176 pd=1.4 as=0.0693 ps=0.75 w=0.42 l=0.15
X1261 VDD _66_.Y a_76847_12015# VDD sky130_fd_pr__pfet_01v8_hvt ad=0.0864 pd=0.91 as=0.1664 ps=1.8 w=0.64 l=0.15
X1262 VDD a_50369_14165# a_50399_14518# VDD sky130_fd_pr__pfet_01v8_hvt ad=0.0693 pd=0.75 as=0.0441 ps=0.63 w=0.42 l=0.15
X1263 a_50571_3677# a_49873_3311# a_50314_3423# VSS sky130_fd_pr__special_nfet_01v8 ad=0.0684 pd=0.74 as=0.0989 ps=0.995 w=0.36 l=0.15
X1264 a_49215_50974# a_49167_50886# VDD VDD sky130_fd_pr__pfet_01v8 ad=0.1218 pd=1.42 as=0.1218 ps=1.42 w=0.42 l=0.15
X1265 VSS a_58410_12127# a_58368_12015# VSS sky130_fd_pr__nfet_01v8 ad=0.12095 pd=1.085 as=0.0696 ps=0.765 w=0.42 l=0.15
X1266 macro_core.phase_delay\[70\].delay_cell.Y macro_core.phase_delay\[70\].delay_cell.A VSS VSS sky130_fd_pr__nfet_01v8 ad=0.169 pd=1.82 as=0.169 ps=1.82 w=0.65 l=0.15
X1267 a_73215_50974# a_73167_50886# VSS VSS sky130_fd_pr__nfet_01v8 ad=0.3654 pd=3.1 as=0.3654 ps=3.1 w=1.26 l=0.15
X1268 macro_core.phase_delay\[32\].delay_cell.A macro_core.phase_delay\[30\].delay_cell.Y VDD VDD sky130_fd_pr__pfet_01v8_hvt ad=0.26 pd=2.52 as=0.26 ps=2.52 w=1 l=0.15
X1269 macro_core.phase_delay\[67\].delay_cell.Y macro_core.phase_delay\[66\].delay_cell.Y VDD VDD sky130_fd_pr__pfet_01v8_hvt ad=0.26 pd=2.52 as=0.26 ps=2.52 w=1 l=0.15
X1270 a_49670_9951# a_49502_10205# VDD VDD sky130_fd_pr__pfet_01v8_hvt ad=0.1095 pd=1.075 as=0.17887 ps=1.26 w=0.75 l=0.15
X1271 macro_core.phase_delay\[25\].delay_cell.A macro_core.phase_delay\[23\].delay_cell.Y VSS VSS sky130_fd_pr__nfet_01v8 ad=0.169 pd=1.82 as=0.169 ps=1.82 w=0.65 l=0.15
X1272 a_55167_50886# a_55215_50974# VSS VSS sky130_fd_pr__nfet_01v8 ad=0.3654 pd=3.1 as=0.3654 ps=3.1 w=1.26 l=0.15
X1273 VDD a_59146_14303# a_59073_14557# VDD sky130_fd_pr__pfet_01v8_hvt ad=0.17887 pd=1.26 as=0.07665 ps=0.785 w=0.42 l=0.15
X1274 a_59146_14303# a_58978_14557# VSS VSS sky130_fd_pr__nfet_01v8 ad=0.0989 pd=0.995 as=0.12095 ps=1.085 w=0.64 l=0.15
X1275 a_72265_14165# _84_.Q VDD VDD sky130_fd_pr__pfet_01v8_hvt ad=0.1176 pd=1.4 as=0.0693 ps=0.75 w=0.42 l=0.15
X1276 macro_core.phase_delay\[28\].delay_cell.Y macro_core.phase_delay\[28\].delay_cell.A VSS VSS sky130_fd_pr__nfet_01v8 ad=0.169 pd=1.82 as=0.169 ps=1.82 w=0.65 l=0.15
X1277 a_49167_45886# a_49215_45974# VDD VDD sky130_fd_pr__pfet_01v8 ad=0.1218 pd=1.42 as=0.1218 ps=1.42 w=0.42 l=0.15
X1278 a_58978_14557# a_58539_14191# a_58893_14191# VSS sky130_fd_pr__special_nfet_01v8 ad=0.0621 pd=0.705 as=0.0813 ps=0.83 w=0.36 l=0.15
X1279 VSS a_63599_14191# macro_core.precharge_drive.X VSS sky130_fd_pr__nfet_01v8 ad=0.18525 pd=1.87 as=0.091 ps=0.93 w=0.65 l=0.15
X1280 a_49643_13647# a_48861_13653# a_49559_13647# VDD sky130_fd_pr__pfet_01v8_hvt ad=0.0882 pd=0.84 as=0.0567 ps=0.69 w=0.42 l=0.15
X1281 VDD a_58410_12127# a_58337_12381# VDD sky130_fd_pr__pfet_01v8_hvt ad=0.17887 pd=1.26 as=0.07665 ps=0.785 w=0.42 l=0.15
X1282 VSS a_77454_12127# a_77412_12015# VSS sky130_fd_pr__nfet_01v8 ad=0.12095 pd=1.085 as=0.0696 ps=0.765 w=0.42 l=0.15
X1283 _84_.Q a_58559_9269# VSS VSS sky130_fd_pr__nfet_01v8 ad=0.169 pd=1.82 as=0.08775 ps=0.92 w=0.65 l=0.15
X1284 a_49670_9951# a_49502_10205# VSS VSS sky130_fd_pr__nfet_01v8 ad=0.0989 pd=0.995 as=0.12095 ps=1.085 w=0.64 l=0.15
X1285 VSS macro_core.array_and_peripherals.row_decoder_0.A0B macro_core.array_and_peripherals.row_decoder_0.A0T VSS sky130_fd_pr__nfet_01v8 ad=0.58 pd=4.58 as=0.58 ps=4.58 w=2 l=0.15
X1286 a_51872_11703# DATA[0] a_52014_11837# VSS sky130_fd_pr__nfet_01v8 ad=0.09975 pd=0.895 as=0.0693 ps=0.75 w=0.42 l=0.15
X1287 VDD a_52947_3579# a_52863_3677# VDD sky130_fd_pr__pfet_01v8_hvt ad=0.1113 pd=1.37 as=0.0882 ps=0.84 w=0.42 l=0.15
X1288 a_63341_11769# _44_.Y VDD VDD sky130_fd_pr__pfet_01v8_hvt ad=0.1176 pd=1.4 as=0.0693 ps=0.75 w=0.42 l=0.15
X1289 a_77406_13686# _44_.Y VDD VDD sky130_fd_pr__pfet_01v8_hvt ad=0.07665 pd=0.785 as=0.15835 ps=1.395 w=0.42 l=0.15
X1290 a_52522_3423# a_52354_3677# VDD VDD sky130_fd_pr__pfet_01v8_hvt ad=0.1095 pd=1.075 as=0.17887 ps=1.26 w=0.75 l=0.15
X1291 macro_core.phase_delay\[30\].delay_cell.A macro_core.phase_delay\[28\].delay_cell.Y VDD VDD sky130_fd_pr__pfet_01v8_hvt ad=0.26 pd=2.52 as=0.26 ps=2.52 w=1 l=0.15
X1292 a_59650_12598# _84_.Q VDD VDD sky130_fd_pr__pfet_01v8_hvt ad=0.07665 pd=0.785 as=0.15835 ps=1.395 w=0.42 l=0.15
X1293 a_66709_12337# _55_.Y VSS VSS sky130_fd_pr__nfet_01v8 ad=0.2583 pd=2.07 as=0.09813 ps=1.005 w=0.42 l=0.15
X1294 macro_core.data_complement\[2\].complement.Y _47_.A0 VSS VSS sky130_fd_pr__nfet_01v8 ad=0.169 pd=1.82 as=0.169 ps=1.82 w=0.65 l=0.15
X1295 a_52014_11837# _44_.Y VSS VSS sky130_fd_pr__nfet_01v8 ad=0.0693 pd=0.75 as=0.11285 ps=1.045 w=0.42 l=0.15
X1296 VSS _86_.CLK _61_.Y VSS sky130_fd_pr__nfet_01v8 ad=0.1197 pd=1.41 as=0.1092 ps=1.36 w=0.42 l=0.15
X1297 macro_core.phase_delay\[1\].delay_cell.Y macro_core.phase_delay\[1\].delay_cell.A VDD VDD sky130_fd_pr__pfet_01v8_hvt ad=0.26 pd=2.52 as=0.26 ps=2.52 w=1 l=0.15
X1298 _46_.A0 a_53315_14459# VSS VSS sky130_fd_pr__nfet_01v8 ad=0.169 pd=1.82 as=0.08775 ps=0.92 w=0.65 l=0.15
X1299 a_68059_14191# _91_.A a_67696_14343# VSS sky130_fd_pr__nfet_01v8 ad=0.0693 pd=0.75 as=0.09975 ps=0.895 w=0.42 l=0.15
X1300 _53_.Y _84_.Q a_74817_11791# VSS sky130_fd_pr__nfet_01v8 ad=0.169 pd=1.82 as=0.08775 ps=0.92 w=0.65 l=0.15
X1301 VDD macro_core.precharge_phase.X a_63599_14191# VDD sky130_fd_pr__pfet_01v8_hvt ad=0.1775 pd=1.355 as=0.14 ps=1.28 w=1 l=0.15
X1302 VSS a_71271_13647# a_71439_13621# VSS sky130_fd_pr__nfet_01v8 ad=0.08775 pd=0.92 as=0.169 ps=1.82 w=0.65 l=0.15
X1303 a_62983_12381# a_62201_12015# a_62899_12381# VDD sky130_fd_pr__pfet_01v8_hvt ad=0.0882 pd=0.84 as=0.0567 ps=0.69 w=0.42 l=0.15
X1304 a_77264_13879# _51_.A0 a_77406_13686# VDD sky130_fd_pr__pfet_01v8_hvt ad=0.1932 pd=1.34 as=0.07665 ps=0.785 w=0.42 l=0.15
X1305 a_54933_11471# a_54399_11477# a_54838_11471# VDD sky130_fd_pr__pfet_01v8_hvt ad=0.07665 pd=0.785 as=0.06825 ps=0.745 w=0.42 l=0.15
X1306 a_56415_16496# macro_core.data_complement\[2\].complement.Y macro_core.array_and_peripherals.write_driver_2.BL VSS sky130_fd_pr__nfet_01v8 ad=1.4616 pd=10.66 as=1.4616 ps=10.66 w=5.04 l=0.15
X1307 a_59508_12791# _90_.A a_59650_12598# VDD sky130_fd_pr__pfet_01v8_hvt ad=0.1932 pd=1.34 as=0.07665 ps=0.785 w=0.42 l=0.15
X1308 VDD _40_.A1 macro_core.array_and_peripherals.sense_amp_3.SA_OUTB VDD sky130_fd_pr__pfet_01v8 ad=0.5481 pd=4.36 as=0.5481 ps=4.36 w=1.89 l=0.15
X1309 VDD macro_core.array_and_peripherals.sense_amp_5.SA_OUTB _38_.A1 VDD sky130_fd_pr__pfet_01v8 ad=0.5481 pd=4.36 as=0.5481 ps=4.36 w=1.89 l=0.15
X1310 VSS macro_core.write_drive.X a_44415_16496# VSS sky130_fd_pr__nfet_01v8 ad=1.4616 pd=10.66 as=1.4616 ps=10.66 w=5.04 l=0.15
X1311 a_74123_12381# a_73259_12015# a_73866_12127# VDD sky130_fd_pr__pfet_01v8_hvt ad=0.0567 pd=0.69 as=0.1095 ps=1.075 w=0.42 l=0.15
X1312 macro_core.phase_delay\[5\].delay_cell.Y macro_core.phase_delay\[4\].delay_cell.Y VSS VSS sky130_fd_pr__nfet_01v8 ad=0.169 pd=1.82 as=0.169 ps=1.82 w=0.65 l=0.15
X1313 a_71271_13647# a_70407_13653# a_71014_13621# VDD sky130_fd_pr__pfet_01v8_hvt ad=0.0567 pd=0.69 as=0.1095 ps=1.075 w=0.42 l=0.15
X1314 VDD a_78368_12167# _82_.D VDD sky130_fd_pr__pfet_01v8_hvt ad=0.15835 pd=1.395 as=0.26 ps=2.52 w=1 l=0.15
X1315 VSS _61_.Y a_54399_11477# VSS sky130_fd_pr__nfet_01v8 ad=0.0567 pd=0.69 as=0.1092 ps=1.36 w=0.42 l=0.15
X1316 VSS a_62912_11703# _48_.X VSS sky130_fd_pr__nfet_01v8 ad=0.11285 pd=1.045 as=0.169 ps=1.82 w=0.65 l=0.15
X1317 macro_core.phase_delay\[49\].delay_cell.A macro_core.phase_delay\[48\].delay_cell.A VSS VSS sky130_fd_pr__nfet_01v8 ad=0.169 pd=1.82 as=0.169 ps=1.82 w=0.65 l=0.15
X1318 a_67809_14025# a_66819_13653# a_67683_13647# VSS sky130_fd_pr__special_nfet_01v8 ad=0.066 pd=0.745 as=0.0684 ps=0.74 w=0.36 l=0.15
X1319 a_52842_13430# _44_.Y VDD VDD sky130_fd_pr__pfet_01v8_hvt ad=0.07665 pd=0.785 as=0.15835 ps=1.395 w=0.42 l=0.15
X1320 VSS _66_.Y a_76847_12015# VSS sky130_fd_pr__nfet_01v8 ad=0.0567 pd=0.69 as=0.1092 ps=1.36 w=0.42 l=0.15
X1321 a_50655_3677# a_49873_3311# a_50571_3677# VDD sky130_fd_pr__pfet_01v8_hvt ad=0.0882 pd=0.84 as=0.0567 ps=0.69 w=0.42 l=0.15
X1322 macro_core.phase_delay\[65\].delay_cell.Y macro_core.phase_delay\[64\].delay_cell.Y VSS VSS sky130_fd_pr__nfet_01v8 ad=0.169 pd=1.82 as=0.169 ps=1.82 w=0.65 l=0.15
X1323 VDD _86_.CLK _60_.Y VDD sky130_fd_pr__pfet_01v8_hvt ad=0.2352 pd=2.24 as=0.1134 ps=1.11 w=0.84 l=0.15
X1324 a_56430_13686# _44_.Y VDD VDD sky130_fd_pr__pfet_01v8_hvt ad=0.07665 pd=0.785 as=0.15835 ps=1.395 w=0.42 l=0.15
X1325 a_70972_14025# a_70573_13653# a_70846_13647# VSS sky130_fd_pr__special_nfet_01v8 ad=0.0696 pd=0.765 as=0.0621 ps=0.705 w=0.36 l=0.15
X1326 a_43215_45974# a_43167_45886# VSS VSS sky130_fd_pr__nfet_01v8 ad=0.3654 pd=3.1 as=0.3654 ps=3.1 w=1.26 l=0.15
X1327 VDD macro_core.evaluation.A a_46949_14455# VDD sky130_fd_pr__pfet_01v8_hvt ad=0.0567 pd=0.69 as=0.1092 ps=1.36 w=0.42 l=0.15
X1328 a_74526_14557# a_74253_14191# a_74441_14191# VDD sky130_fd_pr__pfet_01v8_hvt ad=0.06825 pd=0.745 as=0.05775 ps=0.695 w=0.42 l=0.15
X1329 VSS a_67851_13621# a_67809_14025# VSS sky130_fd_pr__nfet_01v8 ad=0.1092 pd=1.36 as=0.066 ps=0.745 w=0.42 l=0.15
X1330 a_52842_13103# _44_.Y VSS VSS sky130_fd_pr__nfet_01v8 ad=0.0693 pd=0.75 as=0.11285 ps=1.045 w=0.42 l=0.15
X1331 macro_core.phase_delay\[58\].delay_cell.Y macro_core.phase_delay\[57\].delay_cell.Y VDD VDD sky130_fd_pr__pfet_01v8_hvt ad=0.26 pd=2.52 as=0.26 ps=2.52 w=1 l=0.15
X1332 a_79215_45974# macro_core.array_and_peripherals.wl_driver_1.WL macro_core.array_and_peripherals.write_driver_6.BL VSS sky130_fd_pr__nfet_01v8 ad=0.174 pd=1.78 as=0.174 ps=1.78 w=0.6 l=0.15
X1333 a_14227_36833# macro_core.qualify_row\[2\].qualify.A VDD VDD sky130_fd_pr__pfet_01v8_hvt ad=0.0567 pd=0.69 as=0.1176 ps=1.4 w=0.42 l=0.15
X1334 a_56034_14557# a_55595_14191# a_55949_14191# VSS sky130_fd_pr__special_nfet_01v8 ad=0.0621 pd=0.705 as=0.0813 ps=0.83 w=0.36 l=0.15
X1335 a_56459_14557# a_55761_14191# a_56202_14303# VSS sky130_fd_pr__special_nfet_01v8 ad=0.0684 pd=0.74 as=0.0989 ps=0.995 w=0.36 l=0.15
X1336 VDD _86_.CLK a_51915_3311# VDD sky130_fd_pr__pfet_01v8_hvt ad=0.0864 pd=0.91 as=0.1664 ps=1.8 w=0.64 l=0.15
X1337 a_61167_45886# macro_core.array_and_peripherals.wl_driver_1.WL macro_core.array_and_peripherals.write_driver_3.BLB VSS sky130_fd_pr__nfet_01v8 ad=0.174 pd=1.78 as=0.174 ps=1.78 w=0.6 l=0.15
X1338 a_52014_11510# _44_.Y VDD VDD sky130_fd_pr__pfet_01v8_hvt ad=0.07665 pd=0.785 as=0.15835 ps=1.395 w=0.42 l=0.15
X1339 _55_.Y _84_.Q a_66353_11791# VSS sky130_fd_pr__nfet_01v8 ad=0.169 pd=1.82 as=0.08775 ps=0.92 w=0.65 l=0.15
X1340 macro_core.phase_delay\[40\].delay_cell.A macro_core.phase_delay\[38\].delay_cell.Y VSS VSS sky130_fd_pr__nfet_01v8 ad=0.169 pd=1.82 as=0.169 ps=1.82 w=0.65 l=0.15
X1341 macro_core.phase_delay\[3\].delay_cell.Y macro_core.phase_delay\[2\].delay_cell.Y VSS VSS sky130_fd_pr__nfet_01v8 ad=0.169 pd=1.82 as=0.169 ps=1.82 w=0.65 l=0.15
X1342 VSS macro_core.sense_drive.X a_55615_26902# VSS sky130_fd_pr__nfet_01v8 ad=0.2842 pd=2.54 as=0.2842 ps=2.54 w=0.98 l=0.15
X1343 VDD a_71014_13621# a_70941_13647# VDD sky130_fd_pr__pfet_01v8_hvt ad=0.17887 pd=1.26 as=0.07665 ps=0.785 w=0.42 l=0.15
X1344 a_52700_13255# _46_.A0 a_52842_13430# VDD sky130_fd_pr__pfet_01v8_hvt ad=0.1932 pd=1.34 as=0.07665 ps=0.785 w=0.42 l=0.15
X1345 macro_core.data_complement\[5\].complement.Y _50_.A0 VDD VDD sky130_fd_pr__pfet_01v8_hvt ad=0.26 pd=2.52 as=0.26 ps=2.52 w=1 l=0.15
X1346 macro_core.sense_drive.X a_64611_14191# VSS VSS sky130_fd_pr__nfet_01v8 ad=0.091 pd=0.93 as=0.13813 ps=1.075 w=0.65 l=0.15
X1347 a_56288_13879# _47_.A0 a_56430_13686# VDD sky130_fd_pr__pfet_01v8_hvt ad=0.1932 pd=1.34 as=0.07665 ps=0.785 w=0.42 l=0.15
X1348 _90_.A a_58835_12283# VSS VSS sky130_fd_pr__nfet_01v8 ad=0.169 pd=1.82 as=0.08775 ps=0.92 w=0.65 l=0.15
X1349 VSS macro_core.phase_delay\[59\].delay_cell.Y a_47104_14197# VSS sky130_fd_pr__nfet_01v8 ad=0.1304 pd=1.105 as=0.05355 ps=0.675 w=0.42 l=0.15
X1350 a_49594_12381# a_49155_12015# a_49509_12015# VSS sky130_fd_pr__special_nfet_01v8 ad=0.0621 pd=0.705 as=0.0813 ps=0.83 w=0.36 l=0.15
X1351 macro_core.data_complement\[0\].complement.Y _45_.A0 VDD VDD sky130_fd_pr__pfet_01v8_hvt ad=0.26 pd=2.52 as=0.26 ps=2.52 w=1 l=0.15
X1352 a_59650_12925# _84_.Q VSS VSS sky130_fd_pr__nfet_01v8 ad=0.0693 pd=0.75 as=0.11285 ps=1.045 w=0.42 l=0.15
X1353 a_49173_11769# _84_.Q VSS VSS sky130_fd_pr__nfet_01v8 ad=0.1092 pd=1.36 as=0.1449 ps=1.11 w=0.42 l=0.15
X1354 a_56129_14557# a_55595_14191# a_56034_14557# VDD sky130_fd_pr__pfet_01v8_hvt ad=0.07665 pd=0.785 as=0.06825 ps=0.745 w=0.42 l=0.15
X1355 VDD a_49559_13647# a_49727_13621# VDD sky130_fd_pr__pfet_01v8_hvt ad=0.135 pd=1.27 as=0.27 ps=2.54 w=1 l=0.15
X1356 a_63025_12015# a_62035_12015# a_62899_12381# VSS sky130_fd_pr__special_nfet_01v8 ad=0.066 pd=0.745 as=0.0684 ps=0.74 w=0.36 l=0.15
X1357 _49_.A0 a_69507_12283# VDD VDD sky130_fd_pr__pfet_01v8_hvt ad=0.26 pd=2.52 as=0.135 ps=1.27 w=1 l=0.15
X1358 macro_core.phase_delay\[34\].delay_cell.Y macro_core.phase_delay\[34\].delay_cell.A VSS VSS sky130_fd_pr__nfet_01v8 ad=0.169 pd=1.82 as=0.169 ps=1.82 w=0.65 l=0.15
X1359 VDD _86_.Q macro_core.array_and_peripherals.row_decoder_0.A1B VDD sky130_fd_pr__pfet_01v8 ad=0.2436 pd=2.26 as=0.2436 ps=2.26 w=0.84 l=0.15
X1360 VSS _86_.CLK a_58539_14191# VSS sky130_fd_pr__nfet_01v8 ad=0.0567 pd=0.69 as=0.1092 ps=1.36 w=0.42 l=0.15
X1361 VSS a_49559_13647# a_49727_13621# VSS sky130_fd_pr__nfet_01v8 ad=0.08775 pd=0.92 as=0.169 ps=1.82 w=0.65 l=0.15
X1362 _58_.Y _34_.Y VDD VDD sky130_fd_pr__pfet_01v8_hvt ad=0.135 pd=1.27 as=0.26 ps=2.52 w=1 l=0.15
X1363 VSS a_50314_3423# a_50272_3311# VSS sky130_fd_pr__nfet_01v8 ad=0.12095 pd=1.085 as=0.0696 ps=0.765 w=0.42 l=0.15
X1364 VDD a_72020_12167# _50_.X VDD sky130_fd_pr__pfet_01v8_hvt ad=0.15835 pd=1.395 as=0.26 ps=2.52 w=1 l=0.15
X1365 a_74357_9839# _34_.Y VSS VSS sky130_fd_pr__nfet_01v8 ad=0.08775 pd=0.92 as=0.169 ps=1.82 w=0.65 l=0.15
X1366 macro_core.array_and_peripherals.write_driver_2.BLB macro_core.precharge_drive.X macro_core.array_and_peripherals.write_driver_2.BL VDD sky130_fd_pr__pfet_01v8 ad=0.7308 pd=5.62 as=0.7308 ps=5.62 w=2.52 l=0.15
X1367 VDD _86_.CLK a_52283_14191# VDD sky130_fd_pr__pfet_01v8_hvt ad=0.0864 pd=0.91 as=0.1664 ps=1.8 w=0.64 l=0.15
X1368 a_68914_12381# a_68475_12015# a_68829_12015# VSS sky130_fd_pr__special_nfet_01v8 ad=0.0621 pd=0.705 as=0.0813 ps=0.83 w=0.36 l=0.15
X1369 a_50146_3677# a_49707_3311# a_50061_3311# VSS sky130_fd_pr__special_nfet_01v8 ad=0.0621 pd=0.705 as=0.0813 ps=0.83 w=0.36 l=0.15
X1370 a_49167_40886# macro_core.array_and_peripherals.wl_driver_0.WL macro_core.array_and_peripherals.write_driver_1.BLB VSS sky130_fd_pr__nfet_01v8 ad=0.174 pd=1.78 as=0.174 ps=1.78 w=0.6 l=0.15
X1371 a_49559_13647# a_48695_13653# a_49302_13621# VDD sky130_fd_pr__pfet_01v8_hvt ad=0.0567 pd=0.69 as=0.1095 ps=1.075 w=0.42 l=0.15
X1372 a_49167_55886# macro_core.array_and_peripherals.wl_driver_3.WL macro_core.array_and_peripherals.write_driver_1.BLB VSS sky130_fd_pr__nfet_01v8 ad=0.174 pd=1.78 as=0.174 ps=1.78 w=0.6 l=0.15
X1373 VDD a_49227_20916# a_51627_20496# VDD sky130_fd_pr__pfet_01v8 ad=1.4616 pd=10.66 as=1.4616 ps=10.66 w=5.04 l=0.15
X1374 a_62027_20496# macro_core.data_complement\[3\].complement.Y macro_core.array_and_peripherals.write_driver_3.BL VDD sky130_fd_pr__pfet_01v8 ad=1.4616 pd=10.66 as=1.4616 ps=10.66 w=5.04 l=0.15
X1375 VSS a_49927_10205# a_50095_10107# VSS sky130_fd_pr__nfet_01v8 ad=0.08775 pd=0.92 as=0.169 ps=1.82 w=0.65 l=0.15
X1376 a_67615_26902# macro_core.array_and_peripherals.sense_amp_4.SA_OUTB _39_.A1 VSS sky130_fd_pr__nfet_01v8 ad=0.2842 pd=2.54 as=0.2842 ps=2.54 w=0.98 l=0.15
X1377 VSS macro_core.write_drive.X a_76015_16496# VSS sky130_fd_pr__nfet_01v8 ad=1.4616 pd=10.66 as=1.4616 ps=10.66 w=5.04 l=0.15
X1378 a_88015_16496# _52_.A0 macro_core.array_and_peripherals.write_driver_7.BLB VSS sky130_fd_pr__nfet_01v8 ad=1.4616 pd=10.66 as=1.4616 ps=10.66 w=5.04 l=0.15
X1379 VSS a_74694_14303# a_74652_14191# VSS sky130_fd_pr__nfet_01v8 ad=0.12095 pd=1.085 as=0.0696 ps=0.765 w=0.42 l=0.15
X1380 a_50272_3311# a_49873_3311# a_50146_3677# VSS sky130_fd_pr__special_nfet_01v8 ad=0.0696 pd=0.765 as=0.0621 ps=0.705 w=0.36 l=0.15
X1381 VSS a_53147_14557# a_53315_14459# VSS sky130_fd_pr__nfet_01v8 ad=0.08775 pd=0.92 as=0.169 ps=1.82 w=0.65 l=0.15
X1382 VSS a_52700_13255# _46_.X VSS sky130_fd_pr__nfet_01v8 ad=0.11285 pd=1.045 as=0.169 ps=1.82 w=0.65 l=0.15
X1383 a_77454_12127# a_77286_12381# VSS VSS sky130_fd_pr__nfet_01v8 ad=0.0989 pd=0.995 as=0.12095 ps=1.085 w=0.64 l=0.15
X1384 a_74817_11791# _34_.Y VSS VSS sky130_fd_pr__nfet_01v8 ad=0.08775 pd=0.92 as=0.169 ps=1.82 w=0.65 l=0.15
X1385 VSS macro_core.write_drive.X a_61227_20916# VSS sky130_fd_pr__nfet_01v8 ad=0.2436 pd=2.26 as=0.2436 ps=2.26 w=0.84 l=0.15
X1386 a_49173_11769# _84_.Q VDD VDD sky130_fd_pr__pfet_01v8_hvt ad=0.1176 pd=1.4 as=0.0693 ps=0.75 w=0.42 l=0.15
X1387 VSS a_36227_46432# macro_core.array_and_peripherals.wl_driver_1.WL VSS sky130_fd_pr__nfet_01v8 ad=1.4616 pd=10.66 as=1.4616 ps=10.66 w=5.04 l=0.15
X1388 a_62899_12381# a_62035_12015# a_62642_12127# VDD sky130_fd_pr__pfet_01v8_hvt ad=0.0567 pd=0.69 as=0.1095 ps=1.075 w=0.42 l=0.15
X1389 a_67047_12015# a_66709_12337# VSS VSS sky130_fd_pr__nfet_01v8 ad=0.06825 pd=0.86 as=0.2275 ps=2 w=0.65 l=0.15
X1390 a_62569_12381# a_62035_12015# a_62474_12381# VDD sky130_fd_pr__pfet_01v8_hvt ad=0.07665 pd=0.785 as=0.06825 ps=0.745 w=0.42 l=0.15
X1391 a_49215_55974# a_49167_55886# VSS VSS sky130_fd_pr__nfet_01v8 ad=0.3654 pd=3.1 as=0.3654 ps=3.1 w=1.26 l=0.15
X1392 a_49215_40974# a_49167_40886# VSS VSS sky130_fd_pr__nfet_01v8 ad=0.3654 pd=3.1 as=0.3654 ps=3.1 w=1.26 l=0.15
X1393 VDD macro_core.precharge_drive.X macro_core.array_and_peripherals.write_driver_3.BLB VDD sky130_fd_pr__pfet_01v8 ad=0.7308 pd=5.62 as=0.7308 ps=5.62 w=2.52 l=0.15
X1394 VDD macro_core.precharge_drive.X macro_core.array_and_peripherals.write_driver_5.BL VDD sky130_fd_pr__pfet_01v8 ad=0.7308 pd=5.62 as=0.7308 ps=5.62 w=2.52 l=0.15
X1395 a_53911_2375# OEb VSS VSS sky130_fd_pr__nfet_01v8 ad=0.1092 pd=1.36 as=0.10025 ps=0.985 w=0.42 l=0.15
X1396 a_58517_9673# a_57527_9301# a_58391_9295# VSS sky130_fd_pr__special_nfet_01v8 ad=0.066 pd=0.745 as=0.0684 ps=0.74 w=0.36 l=0.15
X1397 VDD a_66819_10383# macro_core.phase_delay\[0\].delay_cell.A VDD sky130_fd_pr__pfet_01v8_hvt ad=0.26 pd=2.52 as=0.135 ps=1.27 w=1 l=0.15
X1398 a_85215_40974# macro_core.array_and_peripherals.wl_driver_0.WL macro_core.array_and_peripherals.write_driver_7.BL VSS sky130_fd_pr__nfet_01v8 ad=0.174 pd=1.78 as=0.174 ps=1.78 w=0.6 l=0.15
X1399 VSS a_49940_14343# _76_.D VSS sky130_fd_pr__nfet_01v8 ad=0.11285 pd=1.045 as=0.169 ps=1.82 w=0.65 l=0.15
X1400 a_59871_12925# _90_.A a_59508_12791# VSS sky130_fd_pr__nfet_01v8 ad=0.0693 pd=0.75 as=0.09975 ps=0.895 w=0.42 l=0.15
X1401 a_85215_55974# macro_core.array_and_peripherals.wl_driver_3.WL macro_core.array_and_peripherals.write_driver_7.BL VSS sky130_fd_pr__nfet_01v8 ad=0.174 pd=1.78 as=0.174 ps=1.78 w=0.6 l=0.15
X1402 VDD a_36227_46432# macro_core.array_and_peripherals.wl_driver_1.WL VDD sky130_fd_pr__pfet_01v8 ad=1.4616 pd=10.66 as=1.4616 ps=10.66 w=5.04 l=0.15
X1403 VSS a_46949_14455# macro_core.evaluation.X VSS sky130_fd_pr__nfet_01v8 ad=0.17875 pd=1.85 as=0.08775 ps=0.92 w=0.65 l=0.15
X1404 a_53273_14191# a_52283_14191# a_53147_14557# VSS sky130_fd_pr__special_nfet_01v8 ad=0.066 pd=0.745 as=0.0684 ps=0.74 w=0.36 l=0.15
X1405 a_67426_13621# a_67258_13647# VDD VDD sky130_fd_pr__pfet_01v8_hvt ad=0.1095 pd=1.075 as=0.17887 ps=1.26 w=0.75 l=0.15
X1406 a_50061_3311# ADDR[1] VSS VSS sky130_fd_pr__nfet_01v8 ad=0.0813 pd=0.83 as=0.1092 ps=1.36 w=0.42 l=0.15
X1407 a_67167_55886# macro_core.array_and_peripherals.wl_driver_3.WL macro_core.array_and_peripherals.write_driver_4.BLB VSS sky130_fd_pr__nfet_01v8 ad=0.174 pd=1.78 as=0.174 ps=1.78 w=0.6 l=0.15
X1408 a_67167_40886# macro_core.array_and_peripherals.wl_driver_0.WL macro_core.array_and_peripherals.write_driver_4.BLB VSS sky130_fd_pr__nfet_01v8 ad=0.174 pd=1.78 as=0.174 ps=1.78 w=0.6 l=0.15
X1409 a_67258_13647# a_66985_13653# a_67173_13647# VDD sky130_fd_pr__pfet_01v8_hvt ad=0.06825 pd=0.745 as=0.05775 ps=0.695 w=0.42 l=0.15
X1410 macro_core.data_complement\[1\].complement.Y _46_.A0 VDD VDD sky130_fd_pr__pfet_01v8_hvt ad=0.26 pd=2.52 as=0.26 ps=2.52 w=1 l=0.15
X1411 a_64694_14191# _84_.Q a_64611_14191# VSS sky130_fd_pr__nfet_01v8 ad=0.06825 pd=0.86 as=0.17225 ps=1.83 w=0.65 l=0.15
X1412 VDD macro_core.phase_delay\[23\].delay_cell.Y a_65103_12043# VDD sky130_fd_pr__pfet_01v8_hvt ad=0.16655 pd=1.39 as=0.0567 ps=0.69 w=0.42 l=0.15
X1413 _52_.A0 a_78155_10107# VSS VSS sky130_fd_pr__nfet_01v8 ad=0.169 pd=1.82 as=0.08775 ps=0.92 w=0.65 l=0.15
X1414 a_85167_55886# a_85215_55974# VDD VDD sky130_fd_pr__pfet_01v8 ad=0.1218 pd=1.42 as=0.1218 ps=1.42 w=0.42 l=0.15
X1415 a_85167_40886# a_85215_40974# VDD VDD sky130_fd_pr__pfet_01v8 ad=0.1218 pd=1.42 as=0.1218 ps=1.42 w=0.42 l=0.15
X1416 a_57627_20496# _47_.A0 macro_core.array_and_peripherals.write_driver_2.BLB VDD sky130_fd_pr__pfet_01v8 ad=1.4616 pd=10.66 as=1.4616 ps=10.66 w=5.04 l=0.15
X1417 VDD a_67227_20916# a_69627_20496# VDD sky130_fd_pr__pfet_01v8 ad=1.4616 pd=10.66 as=1.4616 ps=10.66 w=5.04 l=0.15
X1418 macro_core.phase_delay\[8\].delay_cell.Y macro_core.phase_delay\[7\].delay_cell.Y VDD VDD sky130_fd_pr__pfet_01v8_hvt ad=0.26 pd=2.52 as=0.26 ps=2.52 w=1 l=0.15
X1419 VSS macro_core.evaluation.X a_14313_36833# VSS sky130_fd_pr__nfet_01v8 ad=0.1118 pd=1.04 as=0.0567 ps=0.69 w=0.42 l=0.15
X1420 VDD macro_core.write_drive.X a_43227_20916# VDD sky130_fd_pr__pfet_01v8 ad=0.2436 pd=2.26 as=0.2436 ps=2.26 w=0.84 l=0.15
X1421 a_55006_11445# a_54838_11471# VSS VSS sky130_fd_pr__nfet_01v8 ad=0.0989 pd=0.995 as=0.12095 ps=1.085 w=0.64 l=0.15
X1422 a_78857_14191# _51_.X VSS VSS sky130_fd_pr__nfet_01v8 ad=0.0813 pd=0.83 as=0.1092 ps=1.36 w=0.42 l=0.15
X1423 a_52173_10161# _87_.TE_B VDD VDD sky130_fd_pr__pfet_01v8_hvt ad=0.1664 pd=1.8 as=0.0864 ps=0.91 w=0.64 l=0.15
X1424 a_55853_10383# _57_.Y VSS VSS sky130_fd_pr__nfet_01v8 ad=0.2583 pd=2.07 as=0.09813 ps=1.005 w=0.42 l=0.15
X1425 a_67215_45974# a_67167_45886# VDD VDD sky130_fd_pr__pfet_01v8 ad=0.1218 pd=1.42 as=0.1218 ps=1.42 w=0.42 l=0.15
X1426 VSS macro_core.write_drive.X a_79227_20916# VSS sky130_fd_pr__nfet_01v8 ad=0.2436 pd=2.26 as=0.2436 ps=2.26 w=0.84 l=0.15
X1427 a_77406_14013# _44_.Y VSS VSS sky130_fd_pr__nfet_01v8 ad=0.0693 pd=0.75 as=0.11285 ps=1.045 w=0.42 l=0.15
X1428 a_58410_12127# a_58242_12381# VDD VDD sky130_fd_pr__pfet_01v8_hvt ad=0.1095 pd=1.075 as=0.17887 ps=1.26 w=0.75 l=0.15
X1429 a_54565_11477# a_54399_11477# VDD VDD sky130_fd_pr__pfet_01v8_hvt ad=0.1664 pd=1.8 as=0.0864 ps=0.91 w=0.64 l=0.15
X1430 macro_core.array_and_peripherals.row_decoder_0.net1 macro_core.array_and_peripherals.row_decoder_0.A1B macro_core.array_and_peripherals.row_decoder_0.N0 VSS sky130_fd_pr__nfet_01v8 ad=0.58 pd=4.58 as=0.58 ps=4.58 w=2 l=0.15
X1431 a_67838_14191# _84_.Q VSS VSS sky130_fd_pr__nfet_01v8 ad=0.0693 pd=0.75 as=0.11285 ps=1.045 w=0.42 l=0.15
X1432 VDD a_53129_13077# a_53159_13430# VDD sky130_fd_pr__pfet_01v8_hvt ad=0.0693 pd=0.75 as=0.0441 ps=0.63 w=0.42 l=0.15
X1433 VSS a_58667_12381# a_58835_12283# VSS sky130_fd_pr__nfet_01v8 ad=0.08775 pd=0.92 as=0.169 ps=1.82 w=0.65 l=0.15
X1434 _89_.A a_55431_11445# VDD VDD sky130_fd_pr__pfet_01v8_hvt ad=0.26 pd=2.52 as=0.135 ps=1.27 w=1 l=0.15
X1435 macro_core.phase_delay\[37\].delay_cell.Y macro_core.phase_delay\[36\].delay_cell.Y VSS VSS sky130_fd_pr__nfet_01v8 ad=0.169 pd=1.82 as=0.169 ps=1.82 w=0.65 l=0.15
X1436 a_73167_45886# a_73215_45974# VSS VSS sky130_fd_pr__nfet_01v8 ad=0.3654 pd=3.1 as=0.3654 ps=3.1 w=1.26 l=0.15
X1437 _89_.A a_55431_11445# VSS VSS sky130_fd_pr__nfet_01v8 ad=0.169 pd=1.82 as=0.08775 ps=0.92 w=0.65 l=0.15
X1438 macro_core.phase_delay\[46\].delay_cell.Y macro_core.phase_delay\[46\].delay_cell.A VDD VDD sky130_fd_pr__pfet_01v8_hvt ad=0.26 pd=2.52 as=0.26 ps=2.52 w=1 l=0.15
X1439 _54_.Y _34_.Y VDD VDD sky130_fd_pr__pfet_01v8_hvt ad=0.135 pd=1.27 as=0.26 ps=2.52 w=1 l=0.15
X1440 a_73215_50974# macro_core.array_and_peripherals.wl_driver_2.WL macro_core.array_and_peripherals.write_driver_5.BL VSS sky130_fd_pr__nfet_01v8 ad=0.174 pd=1.78 as=0.174 ps=1.78 w=0.6 l=0.15
X1441 a_59104_14191# a_58705_14191# a_58978_14557# VSS sky130_fd_pr__special_nfet_01v8 ad=0.0696 pd=0.765 as=0.0621 ps=0.705 w=0.36 l=0.15
X1442 macro_core.phase_delay\[70\].delay_cell.A macro_core.phase_delay\[68\].delay_cell.Y VSS VSS sky130_fd_pr__nfet_01v8 ad=0.169 pd=1.82 as=0.169 ps=1.82 w=0.65 l=0.15
X1443 macro_core.phase_delay\[54\].delay_cell.Y macro_core.phase_delay\[53\].delay_cell.Y VSS VSS sky130_fd_pr__nfet_01v8 ad=0.169 pd=1.82 as=0.169 ps=1.82 w=0.65 l=0.15
X1444 a_55167_50886# macro_core.array_and_peripherals.wl_driver_2.WL macro_core.array_and_peripherals.write_driver_2.BLB VSS sky130_fd_pr__nfet_01v8 ad=0.174 pd=1.78 as=0.174 ps=1.78 w=0.6 l=0.15
X1445 VDD a_69339_12381# a_69507_12283# VDD sky130_fd_pr__pfet_01v8_hvt ad=0.135 pd=1.27 as=0.27 ps=2.54 w=1 l=0.15
X1446 macro_core.phase_delay\[18\].delay_cell.Y macro_core.phase_delay\[17\].delay_cell.Y VDD VDD sky130_fd_pr__pfet_01v8_hvt ad=0.26 pd=2.52 as=0.26 ps=2.52 w=1 l=0.15
X1447 VDD a_52890_14303# a_52817_14557# VDD sky130_fd_pr__pfet_01v8_hvt ad=0.17887 pd=1.26 as=0.07665 ps=0.785 w=0.42 l=0.15
X1448 VDD a_52301_11769# a_52331_11510# VDD sky130_fd_pr__pfet_01v8_hvt ad=0.0693 pd=0.75 as=0.0441 ps=0.63 w=0.42 l=0.15
X1449 a_55389_11849# a_54399_11477# a_55263_11471# VSS sky130_fd_pr__special_nfet_01v8 ad=0.066 pd=0.745 as=0.0684 ps=0.74 w=0.36 l=0.15
X1450 a_73167_50886# a_73215_50974# VDD VDD sky130_fd_pr__pfet_01v8 ad=0.1218 pd=1.42 as=0.1218 ps=1.42 w=0.42 l=0.15
X1451 VDD a_85227_20916# a_86027_20496# VDD sky130_fd_pr__pfet_01v8 ad=1.4616 pd=10.66 as=1.4616 ps=10.66 w=5.04 l=0.15
X1452 VSS a_77711_12381# a_77879_12283# VSS sky130_fd_pr__nfet_01v8 ad=0.08775 pd=0.92 as=0.169 ps=1.82 w=0.65 l=0.15
X1453 a_55347_11471# a_54565_11477# a_55263_11471# VDD sky130_fd_pr__pfet_01v8_hvt ad=0.0882 pd=0.84 as=0.0567 ps=0.69 w=0.42 l=0.15
X1454 macro_core.phase_delay\[71\].delay_cell.Y macro_core.phase_delay\[70\].delay_cell.Y VSS VSS sky130_fd_pr__nfet_01v8 ad=0.169 pd=1.82 as=0.169 ps=1.82 w=0.65 l=0.15
X1455 _42_.A1 macro_core.sense_drive.X macro_core.array_and_peripherals.write_driver_1.BL VDD sky130_fd_pr__pfet_01v8 ad=0.58 pd=4.58 as=0.58 ps=4.58 w=2 l=0.15
X1456 a_49615_26902# _42_.A1 macro_core.array_and_peripherals.sense_amp_1.SA_OUTB VSS sky130_fd_pr__nfet_01v8 ad=0.2842 pd=2.54 as=0.2842 ps=2.54 w=0.98 l=0.15
X1457 VSS a_55431_11445# a_55389_11849# VSS sky130_fd_pr__nfet_01v8 ad=0.1092 pd=1.36 as=0.066 ps=0.745 w=0.42 l=0.15
X1458 macro_core.phase_delay\[48\].delay_cell.A macro_core.phase_delay\[46\].delay_cell.Y VDD VDD sky130_fd_pr__pfet_01v8_hvt ad=0.26 pd=2.52 as=0.26 ps=2.52 w=1 l=0.15
X1459 a_77987_10205# a_77123_9839# a_77730_9951# VDD sky130_fd_pr__pfet_01v8_hvt ad=0.0567 pd=0.69 as=0.1095 ps=1.075 w=0.42 l=0.15
X1460 a_77657_10205# a_77123_9839# a_77562_10205# VDD sky130_fd_pr__pfet_01v8_hvt ad=0.07665 pd=0.785 as=0.06825 ps=0.745 w=0.42 l=0.15
X1461 a_55215_55974# a_55167_55886# VDD VDD sky130_fd_pr__pfet_01v8 ad=0.1218 pd=1.42 as=0.1218 ps=1.42 w=0.42 l=0.15
X1462 a_55215_40974# a_55167_40886# VDD VDD sky130_fd_pr__pfet_01v8 ad=0.1218 pd=1.42 as=0.1218 ps=1.42 w=0.42 l=0.15
X1463 a_59821_9839# _34_.Y VSS VSS sky130_fd_pr__nfet_01v8 ad=0.08775 pd=0.92 as=0.169 ps=1.82 w=0.65 l=0.15
X1464 VDD a_64611_14191# macro_core.sense_drive.X VDD sky130_fd_pr__pfet_01v8_hvt ad=0.14 pd=1.28 as=0.14 ps=1.28 w=1 l=0.15
X1465 a_53129_13077# _44_.Y VDD VDD sky130_fd_pr__pfet_01v8_hvt ad=0.1176 pd=1.4 as=0.0693 ps=0.75 w=0.42 l=0.15
X1466 macro_core.qualify_row\[0\].qualify.X a_15147_37067# VDD VDD sky130_fd_pr__pfet_01v8_hvt ad=0.475 pd=2.95 as=0.16655 ps=1.39 w=1 l=0.15
X1467 a_56430_14013# _44_.Y VSS VSS sky130_fd_pr__nfet_01v8 ad=0.0693 pd=0.75 as=0.11285 ps=1.045 w=0.42 l=0.15
X1468 a_61167_55886# a_61215_55974# VSS VSS sky130_fd_pr__nfet_01v8 ad=0.3654 pd=3.1 as=0.3654 ps=3.1 w=1.26 l=0.15
X1469 a_61167_40886# a_61215_40974# VSS VSS sky130_fd_pr__nfet_01v8 ad=0.3654 pd=3.1 as=0.3654 ps=3.1 w=1.26 l=0.15
X1470 a_53129_13077# _44_.Y VSS VSS sky130_fd_pr__nfet_01v8 ad=0.1092 pd=1.36 as=0.1449 ps=1.11 w=0.42 l=0.15
X1471 VDD macro_core.evaluation.X a_15147_37067# VDD sky130_fd_pr__pfet_01v8_hvt ad=0.16655 pd=1.39 as=0.0567 ps=0.69 w=0.42 l=0.15
X1472 a_79451_14557# a_78669_14191# a_79367_14557# VDD sky130_fd_pr__pfet_01v8_hvt ad=0.0882 pd=0.84 as=0.0567 ps=0.69 w=0.42 l=0.15
X1473 a_54065_2473# CSb a_53981_2473# VDD sky130_fd_pr__pfet_01v8_hvt ad=0.135 pd=1.27 as=0.135 ps=1.27 w=1 l=0.15
X1474 VSS a_68125_14165# a_68059_14191# VSS sky130_fd_pr__nfet_01v8 ad=0.1449 pd=1.11 as=0.0693 ps=0.75 w=0.42 l=0.15
X1475 VDD a_56717_13945# a_56747_13686# VDD sky130_fd_pr__pfet_01v8_hvt ad=0.0693 pd=0.75 as=0.0441 ps=0.63 w=0.42 l=0.15
X1476 macro_core.write_drive.X a_61642_14191# VDD VDD sky130_fd_pr__pfet_01v8_hvt ad=0.14 pd=1.28 as=0.1775 ps=1.355 w=1 l=0.15
X1477 VSS macro_core.phase_delay\[79\].delay_cell.Y a_64694_14191# VSS sky130_fd_pr__nfet_01v8 ad=0.13813 pd=1.075 as=0.06825 ps=0.86 w=0.65 l=0.15
X1478 VDD clkbuf_0_CLK.X a_58539_10383# VDD sky130_fd_pr__pfet_01v8_hvt ad=0.1625 pd=1.325 as=0.265 ps=2.53 w=1 l=0.15
X1479 macro_core.phase_delay\[21\].delay_cell.Y macro_core.phase_delay\[21\].delay_cell.A VDD VDD sky130_fd_pr__pfet_01v8_hvt ad=0.26 pd=2.52 as=0.26 ps=2.52 w=1 l=0.15
X1480 a_77627_14013# _51_.A0 a_77264_13879# VSS sky130_fd_pr__nfet_01v8 ad=0.0693 pd=0.75 as=0.09975 ps=0.895 w=0.42 l=0.15
X1481 a_43215_50974# a_43167_50886# VDD VDD sky130_fd_pr__pfet_01v8 ad=0.1218 pd=1.42 as=0.1218 ps=1.42 w=0.42 l=0.15
X1482 _39_.A1 macro_core.sense_drive.X macro_core.array_and_peripherals.write_driver_4.BL VDD sky130_fd_pr__pfet_01v8 ad=0.58 pd=4.58 as=0.58 ps=4.58 w=2 l=0.15
X1483 a_67615_26902# _39_.A1 macro_core.array_and_peripherals.sense_amp_4.SA_OUTB VSS sky130_fd_pr__nfet_01v8 ad=0.2842 pd=2.54 as=0.2842 ps=2.54 w=0.98 l=0.15
X1484 VSS a_59571_14459# a_59529_14191# VSS sky130_fd_pr__nfet_01v8 ad=0.1092 pd=1.36 as=0.066 ps=0.745 w=0.42 l=0.15
X1485 macro_core.phase_delay\[21\].delay_cell.A macro_core.phase_delay\[19\].delay_cell.Y VSS VSS sky130_fd_pr__nfet_01v8 ad=0.169 pd=1.82 as=0.169 ps=1.82 w=0.65 l=0.15
X1486 macro_core.phase_delay\[26\].delay_cell.Y macro_core.phase_delay\[26\].delay_cell.A VSS VSS sky130_fd_pr__nfet_01v8 ad=0.169 pd=1.82 as=0.169 ps=1.82 w=0.65 l=0.15
X1487 a_43215_45974# macro_core.array_and_peripherals.wl_driver_1.WL macro_core.array_and_peripherals.write_driver_0.BL VSS sky130_fd_pr__nfet_01v8 ad=0.174 pd=1.78 as=0.174 ps=1.78 w=0.6 l=0.15
X1488 macro_core.array_and_peripherals.write_driver_2.BLB macro_core.sense_drive.X macro_core.array_and_peripherals.sense_amp_2.SA_OUTB VDD sky130_fd_pr__pfet_01v8 ad=0.58 pd=4.58 as=0.58 ps=4.58 w=2 l=0.15
X1489 macro_core.evaluation.X a_46949_14455# VSS VSS sky130_fd_pr__nfet_01v8 ad=0.08775 pd=0.92 as=0.1304 ps=1.105 w=0.65 l=0.15
X1490 a_56288_13879# DATA[2] a_56430_14013# VSS sky130_fd_pr__nfet_01v8 ad=0.09975 pd=0.895 as=0.0693 ps=0.75 w=0.42 l=0.15
X1491 VDD a_53147_14557# a_53315_14459# VDD sky130_fd_pr__pfet_01v8_hvt ad=0.135 pd=1.27 as=0.27 ps=2.54 w=1 l=0.15
X1492 a_65103_12043# macro_core.phase_delay\[0\].delay_cell.A VDD VDD sky130_fd_pr__pfet_01v8_hvt ad=0.0567 pd=0.69 as=0.1176 ps=1.4 w=0.42 l=0.15
.ends
