.model sky130_fd_pr__nfet_01v8 nmos
.model sky130_fd_pr__pfet_01v8 pmos
.model sky130_fd_pr__pfet_01v8_hvt pmos
.model sky130_fd_pr__special_nfet_01v8 nmos
.subckt sram_4x8_wrapper ADDR0 ADDR1 CLK CSb DATA0 DATA1 DATA2 DATA3 DATA4 DATA5 DATA6 DATA7 OEb VDD VSS WEb
M0 a_43167_45886# a_43215_45974# VDD VDD sky130_fd_pr__pfet_01v8 w=0.42u l=0.15u
M1 VDD macro_core.qualify_row\[0\].qualify.A macro_core.array_and_peripherals.row_decoder_0.N0 VDD sky130_fd_pr__pfet_01v8 w=0.84u l=0.15u
M2 macro_core.precharge_phase.X a_64836_13353# VDD VDD sky130_fd_pr__pfet_01v8_hvt w=1u l=0.15u
M3 a_79167_55886# a_79215_55974# VSS VSS sky130_fd_pr__nfet_01v8 w=1.26u l=0.15u
M4 a_79167_40886# a_79215_40974# VSS VSS sky130_fd_pr__nfet_01v8 w=1.26u l=0.15u
M5 a_73793_12381# a_73259_12015# a_73698_12381# VDD sky130_fd_pr__pfet_01v8_hvt w=0.42u l=0.15u
M6 VDD a_52779_3677# a_52947_3579# VDD sky130_fd_pr__pfet_01v8_hvt w=1u l=0.15u
M7 macro_core.phase_delay\[36\].delay_cell.Y macro_core.phase_delay\[35\].delay_cell.Y VDD VDD sky130_fd_pr__pfet_01v8_hvt w=1u l=0.15u
M8 a_70941_13647# a_70407_13653# a_70846_13647# VDD sky130_fd_pr__pfet_01v8_hvt w=0.42u l=0.15u
M9 VDD _75_.Q a_52007_9839# VDD sky130_fd_pr__pfet_01v8_hvt w=0.64u l=0.15u
M10 VSS a_75792_14343# _81_.D VSS sky130_fd_pr__nfet_01v8 w=0.65u l=0.15u
M11 VDD a_56202_14303# a_56129_14557# VDD sky130_fd_pr__pfet_01v8_hvt w=0.42u l=0.15u
M12 a_56651_14013# _47_.A0 a_56288_13879# VSS sky130_fd_pr__nfet_01v8 w=0.42u l=0.15u
M13 a_77723_13686# DATA6 a_77264_13879# VDD sky130_fd_pr__pfet_01v8_hvt w=0.42u l=0.15u
M14 macro_core.phase_delay\[76\].delay_cell.Y macro_core.phase_delay\[75\].delay_cell.Y VDD VDD sky130_fd_pr__pfet_01v8_hvt w=1u l=0.15u
M15 a_69040_12015# a_68641_12015# a_68914_12381# VSS sky130_fd_pr__special_nfet_01v8 w=0.36u l=0.15u
M16 a_75173_10161# _35_.Y VSS VSS sky130_fd_pr__nfet_01v8 w=0.42u l=0.15u
M17 a_66985_13653# a_66819_13653# VSS VSS sky130_fd_pr__nfet_01v8 w=0.42u l=0.15u
M18 VDD a_73866_12127# a_73793_12381# VDD sky130_fd_pr__pfet_01v8_hvt w=0.42u l=0.15u
M19 macro_core.phase_delay\[2\].delay_cell.Y macro_core.phase_delay\[1\].delay_cell.Y VDD VDD sky130_fd_pr__pfet_01v8_hvt w=1u l=0.15u
M20 macro_core.phase_delay\[17\].delay_cell.Y macro_core.phase_delay\[16\].delay_cell.Y VSS VSS sky130_fd_pr__nfet_01v8 w=0.65u l=0.15u
M21 a_85215_50974# a_85167_50886# VSS VSS sky130_fd_pr__nfet_01v8 w=1.26u l=0.15u
M22 a_50415_16496# macro_core.data_complement\[1\].complement.Y macro_core.array_and_peripherals.write_driver_1.BL VSS sky130_fd_pr__nfet_01v8 w=5.04u l=0.15u
M23 macro_core.precharge_drive.X a_63599_14191# VSS VSS sky130_fd_pr__nfet_01v8 w=0.65u l=0.15u
M24 _45_.A0 a_50187_12283# VSS VSS sky130_fd_pr__nfet_01v8 w=0.65u l=0.15u
M25 a_75695_12015# a_75357_12337# VSS VSS sky130_fd_pr__nfet_01v8 w=0.65u l=0.15u
M26 _84_.Q a_58559_9269# VDD VDD sky130_fd_pr__pfet_01v8_hvt w=1u l=0.15u
M27 a_67167_50886# a_67215_50974# VSS VSS sky130_fd_pr__nfet_01v8 w=1.26u l=0.15u
M28 macro_core.array_and_peripherals.row_decoder_0.EVAL_GND macro_core.array_and_peripherals.row_decoder_0.A0T macro_core.array_and_peripherals.row_decoder_0.net4 VSS sky130_fd_pr__nfet_01v8 w=2u l=0.15u
M29 VSS a_74951_14557# a_75119_14459# VSS sky130_fd_pr__nfet_01v8 w=0.65u l=0.15u
M30 macro_core.phase_delay\[79\].delay_cell.Y macro_core.phase_delay\[78\].delay_cell.Y VDD VDD sky130_fd_pr__pfet_01v8_hvt w=1u l=0.15u
M31 macro_core.phase_delay\[35\].delay_cell.Y macro_core.phase_delay\[34\].delay_cell.Y VSS VSS sky130_fd_pr__nfet_01v8 w=0.65u l=0.15u
M32 a_67258_13647# a_66819_13653# a_67173_13647# VSS sky130_fd_pr__special_nfet_01v8 w=0.36u l=0.15u
M33 macro_core.phase_delay\[4\].delay_cell.Y macro_core.phase_delay\[3\].delay_cell.Y VSS VSS sky130_fd_pr__nfet_01v8 w=0.65u l=0.15u
M34 _33_.Y _86_.CLK VDD VDD sky130_fd_pr__pfet_01v8_hvt w=0.84u l=0.15u
M35 VSS macro_core.qualify_row\[0\].qualify.X a_36227_41432# VSS sky130_fd_pr__nfet_01v8 w=1.68u l=0.15u
M36 a_59993_10383# _56_.Y VDD VDD sky130_fd_pr__pfet_01v8_hvt w=0.64u l=0.15u
M37 a_76799_9661# _52_.A0 a_76436_9527# VSS sky130_fd_pr__nfet_01v8 w=0.42u l=0.15u
M38 a_79367_14557# a_78503_14191# a_79110_14303# VDD sky130_fd_pr__pfet_01v8_hvt w=0.42u l=0.15u
M39 _60_.Y _86_.CLK VDD VDD sky130_fd_pr__pfet_01v8_hvt w=0.84u l=0.15u
M40 a_79037_14557# a_78503_14191# a_78942_14557# VDD sky130_fd_pr__pfet_01v8_hvt w=0.42u l=0.15u
M41 VSS macro_core.sense_drive.X a_49615_26902# VSS sky130_fd_pr__nfet_01v8 w=0.98u l=0.15u
M42 _48_.A0 a_63067_12283# VDD VDD sky130_fd_pr__pfet_01v8_hvt w=1u l=0.15u
M43 a_49167_55886# a_49215_55974# VDD VDD sky130_fd_pr__pfet_01v8 w=0.42u l=0.15u
M44 a_49167_40886# a_49215_40974# VDD VDD sky130_fd_pr__pfet_01v8 w=0.42u l=0.15u
M45 a_67173_13647# _79_.D VDD VDD sky130_fd_pr__pfet_01v8_hvt w=0.42u l=0.15u
M46 VSS a_69507_12283# a_69465_12015# VSS sky130_fd_pr__nfet_01v8 w=0.42u l=0.15u
M47 _56_.Y _34_.Y VDD VDD sky130_fd_pr__pfet_01v8_hvt w=1u l=0.15u
M48 VDD macro_core.array_and_peripherals.sense_amp_7.SA_OUTB _36_.A1 VDD sky130_fd_pr__pfet_01v8 w=1.89u l=0.15u
M49 VSS macro_core.write_drive.X a_56415_16496# VSS sky130_fd_pr__nfet_01v8 w=5.04u l=0.15u
M50 a_68415_16496# macro_core.data_complement\[4\].complement.Y macro_core.array_and_peripherals.write_driver_4.BL VSS sky130_fd_pr__nfet_01v8 w=5.04u l=0.15u
M51 a_79110_14303# a_78942_14557# VSS VSS sky130_fd_pr__nfet_01v8 w=0.64u l=0.15u
M52 VSS a_67426_13621# a_67384_14025# VSS sky130_fd_pr__nfet_01v8 w=0.42u l=0.15u
M53 macro_core.phase_delay\[63\].delay_cell.A macro_core.phase_delay\[62\].delay_cell.A VDD VDD sky130_fd_pr__pfet_01v8_hvt w=1u l=0.15u
M54 macro_core.phase_delay\[11\].delay_cell.Y macro_core.phase_delay\[10\].delay_cell.Y VDD VDD sky130_fd_pr__pfet_01v8_hvt w=1u l=0.15u
M55 VDD _38_.A1 macro_core.array_and_peripherals.sense_amp_5.SA_OUTB VDD sky130_fd_pr__pfet_01v8 w=1.89u l=0.15u
M56 a_78942_14557# a_78503_14191# a_78857_14191# VSS sky130_fd_pr__special_nfet_01v8 w=0.36u l=0.15u
M57 a_62474_12381# a_62035_12015# a_62389_12015# VSS sky130_fd_pr__special_nfet_01v8 w=0.36u l=0.15u
M58 a_62899_12381# a_62201_12015# a_62642_12127# VSS sky130_fd_pr__special_nfet_01v8 w=0.36u l=0.15u
M59 macro_core.phase_delay\[72\].delay_cell.Y macro_core.phase_delay\[71\].delay_cell.Y VSS VSS sky130_fd_pr__nfet_01v8 w=0.65u l=0.15u
M60 a_59487_14557# a_58705_14191# a_59403_14557# VDD sky130_fd_pr__pfet_01v8_hvt w=0.42u l=0.15u
M61 macro_core.phase_delay\[61\].delay_cell.A macro_core.phase_delay\[59\].delay_cell.Y VSS VSS sky130_fd_pr__nfet_01v8 w=0.65u l=0.15u
M62 _50_.A0 a_74291_12283# VSS VSS sky130_fd_pr__nfet_01v8 w=0.65u l=0.15u
M63 _86_.Q a_50739_3579# VDD VDD sky130_fd_pr__pfet_01v8_hvt w=1u l=0.15u
M64 a_53981_2767# a_53911_2999# _34_.Y VDD sky130_fd_pr__pfet_01v8_hvt w=1u l=0.15u
M65 macro_core.phase_delay\[19\].delay_cell.Y macro_core.phase_delay\[18\].delay_cell.Y VDD VDD sky130_fd_pr__pfet_01v8_hvt w=1u l=0.15u
M66 macro_core.array_and_peripherals.write_driver_1.BLB macro_core.precharge_drive.X macro_core.array_and_peripherals.write_driver_1.BL VDD sky130_fd_pr__pfet_01v8 w=2.52u l=0.15u
M67 macro_core.array_and_peripherals.row_decoder_0.net3 macro_core.array_and_peripherals.row_decoder_0.A1T macro_core.array_and_peripherals.row_decoder_0.N2 VSS sky130_fd_pr__nfet_01v8 w=2u l=0.15u
M68 VDD a_77693_13945# a_77723_13686# VDD sky130_fd_pr__pfet_01v8_hvt w=0.42u l=0.15u
M69 macro_core.phase_delay\[42\].delay_cell.A macro_core.phase_delay\[41\].delay_cell.A VDD VDD sky130_fd_pr__pfet_01v8_hvt w=1u l=0.15u
M70 a_55215_45974# a_55167_45886# VSS VSS sky130_fd_pr__nfet_01v8 w=1.26u l=0.15u
M71 a_58751_12381# a_57969_12015# a_58667_12381# VDD sky130_fd_pr__pfet_01v8_hvt w=0.42u l=0.15u
M72 VDD OEb a_54065_2767# VDD sky130_fd_pr__pfet_01v8_hvt w=1u l=0.15u
M73 VDD macro_core.release_phase.X a_64918_13353# VDD sky130_fd_pr__pfet_01v8_hvt w=0.42u l=0.15u
M74 a_55949_14191# _47_.X VDD VDD sky130_fd_pr__pfet_01v8_hvt w=0.42u l=0.15u
M75 a_50103_12381# a_49321_12015# a_50019_12381# VDD sky130_fd_pr__pfet_01v8_hvt w=0.42u l=0.15u
M76 a_49873_3311# a_49707_3311# VDD VDD sky130_fd_pr__pfet_01v8_hvt w=0.64u l=0.15u
M77 a_73167_45886# macro_core.array_and_peripherals.wl_driver_1.WL macro_core.array_and_peripherals.write_driver_5.BLB VSS sky130_fd_pr__nfet_01v8 w=0.6u l=0.15u
M78 a_61615_26902# macro_core.array_and_peripherals.sense_amp_3.SA_OUTB _40_.A1 VSS sky130_fd_pr__nfet_01v8 w=0.98u l=0.15u
M79 DATA1 a_51915_12015# a_52419_12015# VSS sky130_fd_pr__nfet_01v8 w=0.65u l=0.15u
M80 DATA6 a_75191_12015# a_75695_12015# VSS sky130_fd_pr__nfet_01v8 w=0.65u l=0.15u
M81 VSS a_77879_12283# a_77837_12015# VSS sky130_fd_pr__nfet_01v8 w=0.42u l=0.15u
M82 a_77730_9951# a_77562_10205# VDD VDD sky130_fd_pr__pfet_01v8_hvt w=0.75u l=0.15u
M83 VSS macro_core.sense_drive.X a_67615_26902# VSS sky130_fd_pr__nfet_01v8 w=0.98u l=0.15u
M84 a_77264_13879# DATA6 a_77406_14013# VSS sky130_fd_pr__nfet_01v8 w=0.42u l=0.15u
M85 VSS macro_core.write_drive.X a_70015_16496# VSS sky130_fd_pr__nfet_01v8 w=5.04u l=0.15u
M86 a_82015_16496# _51_.A0 macro_core.array_and_peripherals.write_driver_6.BLB VSS sky130_fd_pr__nfet_01v8 w=5.04u l=0.15u
M87 a_67696_14343# _39_.A1 a_67838_14191# VSS sky130_fd_pr__nfet_01v8 w=0.42u l=0.15u
M88 a_55142_12598# _84_.Q VDD VDD sky130_fd_pr__pfet_01v8_hvt w=0.42u l=0.15u
M89 a_49509_12015# _45_.X VSS VSS sky130_fd_pr__nfet_01v8 w=0.42u l=0.15u
M90 VDD a_58134_9269# a_58061_9295# VDD sky130_fd_pr__pfet_01v8_hvt w=0.42u l=0.15u
M91 a_50399_14518# _42_.A1 a_49940_14343# VDD sky130_fd_pr__pfet_01v8_hvt w=0.42u l=0.15u
M92 VSS macro_core.array_and_peripherals.row_decoder_0.A1B macro_core.array_and_peripherals.row_decoder_0.A1T VSS sky130_fd_pr__nfet_01v8 w=2u l=0.15u
M93 a_43215_55974# a_43167_55886# VSS VSS sky130_fd_pr__nfet_01v8 w=1.26u l=0.15u
M94 a_43215_40974# a_43167_40886# VSS VSS sky130_fd_pr__nfet_01v8 w=1.26u l=0.15u
M95 a_71014_13621# a_70846_13647# VSS VSS sky130_fd_pr__nfet_01v8 w=0.64u l=0.15u
M96 VSS a_77264_13879# _51_.X VSS sky130_fd_pr__nfet_01v8 w=0.65u l=0.15u
M97 VSS a_50019_12381# a_50187_12283# VSS sky130_fd_pr__nfet_01v8 w=0.65u l=0.15u
M98 _66_.Y macro_core.phase_delay\[0\].delay_cell.A VDD VDD sky130_fd_pr__pfet_01v8_hvt w=0.84u l=0.15u
M99 a_50061_3311# ADDR1 VDD VDD sky130_fd_pr__pfet_01v8_hvt w=0.42u l=0.15u
M100 a_79215_40974# macro_core.array_and_peripherals.wl_driver_0.WL macro_core.array_and_peripherals.write_driver_6.BL VSS sky130_fd_pr__nfet_01v8 w=0.6u l=0.15u
M101 macro_core.precharge_drive.X a_63599_14191# VDD VDD sky130_fd_pr__pfet_01v8_hvt w=1u l=0.15u
M102 VSS a_59508_12791# _78_.D VSS sky130_fd_pr__nfet_01v8 w=0.65u l=0.15u
M103 a_55000_12791# _89_.A a_55142_12598# VDD sky130_fd_pr__pfet_01v8_hvt w=0.42u l=0.15u
M104 a_58061_9295# a_57527_9301# a_57966_9295# VDD sky130_fd_pr__pfet_01v8_hvt w=0.42u l=0.15u
M105 a_76865_9593# _44_.Y VSS VSS sky130_fd_pr__nfet_01v8 w=0.42u l=0.15u
M106 a_79215_55974# macro_core.array_and_peripherals.wl_driver_3.WL macro_core.array_and_peripherals.write_driver_6.BL VSS sky130_fd_pr__nfet_01v8 w=0.6u l=0.15u
M107 macro_core.array_and_peripherals.write_driver_4.BLB macro_core.precharge_drive.X macro_core.array_and_peripherals.write_driver_4.BL VDD sky130_fd_pr__pfet_01v8 w=2.52u l=0.15u
M108 macro_core.phase_delay\[46\].delay_cell.A macro_core.phase_delay\[44\].delay_cell.Y VSS VSS sky130_fd_pr__nfet_01v8 w=0.65u l=0.15u
M109 a_61167_55886# macro_core.array_and_peripherals.wl_driver_3.WL macro_core.array_and_peripherals.write_driver_3.BLB VSS sky130_fd_pr__nfet_01v8 w=0.6u l=0.15u
M110 a_61167_40886# macro_core.array_and_peripherals.wl_driver_0.WL macro_core.array_and_peripherals.write_driver_3.BLB VSS sky130_fd_pr__nfet_01v8 w=0.6u l=0.15u
M111 a_53147_14557# a_52449_14191# a_52890_14303# VSS sky130_fd_pr__special_nfet_01v8 w=0.36u l=0.15u
M112 _92_.A a_71439_13621# VDD VDD sky130_fd_pr__pfet_01v8_hvt w=1u l=0.15u
M113 a_50697_3311# a_49707_3311# a_50571_3677# VSS sky130_fd_pr__special_nfet_01v8 w=0.36u l=0.15u
M114 a_74027_20496# macro_core.data_complement\[5\].complement.Y macro_core.array_and_peripherals.write_driver_5.BL VDD sky130_fd_pr__pfet_01v8 w=5.04u l=0.15u
M115 _92_.A a_71439_13621# VSS VSS sky130_fd_pr__nfet_01v8 w=0.65u l=0.15u
M116 a_58793_12015# a_57803_12015# a_58667_12381# VSS sky130_fd_pr__special_nfet_01v8 w=0.36u l=0.15u
M117 a_79615_26902# macro_core.array_and_peripherals.sense_amp_6.SA_OUTB _37_.A1 VSS sky130_fd_pr__nfet_01v8 w=0.98u l=0.15u
M118 a_51627_20496# _46_.A0 macro_core.array_and_peripherals.write_driver_1.BLB VDD sky130_fd_pr__pfet_01v8 w=5.04u l=0.15u
M119 VDD a_61227_20916# a_63627_20496# VDD sky130_fd_pr__pfet_01v8 w=5.04u l=0.15u
M120 VDD _90_.A a_59827_10383# VDD sky130_fd_pr__pfet_01v8_hvt w=0.64u l=0.15u
M121 a_74207_12381# a_73425_12015# a_74123_12381# VDD sky130_fd_pr__pfet_01v8_hvt w=0.42u l=0.15u
M122 VSS a_50739_3579# a_50697_3311# VSS sky130_fd_pr__nfet_01v8 w=0.42u l=0.15u
M123 a_61215_45974# a_61167_45886# VDD VDD sky130_fd_pr__pfet_01v8 w=0.42u l=0.15u
M124 VSS macro_core.write_drive.X a_88015_16496# VSS sky130_fd_pr__nfet_01v8 w=5.04u l=0.15u
M125 VSS _84_.Q a_61156_14441# VSS sky130_fd_pr__nfet_01v8 w=0.42u l=0.15u
M126 a_56717_13945# _44_.Y VDD VDD sky130_fd_pr__pfet_01v8_hvt w=0.42u l=0.15u
M127 a_71355_13647# a_70573_13653# a_71271_13647# VDD sky130_fd_pr__pfet_01v8_hvt w=0.42u l=0.15u
M128 a_54565_11477# a_54399_11477# VSS VSS sky130_fd_pr__nfet_01v8 w=0.42u l=0.15u
M129 a_57881_9295# _34_.Y VSS VSS sky130_fd_pr__nfet_01v8 w=0.42u l=0.15u
M130 VSS macro_core.write_drive.X a_73227_20916# VSS sky130_fd_pr__nfet_01v8 w=0.84u l=0.15u
M131 VDD macro_core.evaluation.X a_14227_36833# VDD sky130_fd_pr__pfet_01v8_hvt w=0.42u l=0.15u
M132 VSS macro_core.phase_delay\[0\].delay_cell.A a_78503_14191# VSS sky130_fd_pr__nfet_01v8 w=0.42u l=0.15u
M133 VSS a_77693_13945# a_77627_14013# VSS sky130_fd_pr__nfet_01v8 w=0.42u l=0.15u
M134 VDD a_62899_12381# a_63067_12283# VDD sky130_fd_pr__pfet_01v8_hvt w=1u l=0.15u
M135 macro_core.phase_delay\[75\].delay_cell.Y macro_core.phase_delay\[74\].delay_cell.Y VSS VSS sky130_fd_pr__nfet_01v8 w=0.65u l=0.15u
M136 VDD macro_core.precharge_drive.X macro_core.array_and_peripherals.write_driver_5.BLB VDD sky130_fd_pr__pfet_01v8 w=2.52u l=0.15u
M137 VDD macro_core.precharge_drive.X macro_core.array_and_peripherals.write_driver_7.BL VDD sky130_fd_pr__pfet_01v8 w=2.52u l=0.15u
M138 a_55142_12925# _84_.Q VSS VSS sky130_fd_pr__nfet_01v8 w=0.42u l=0.15u
M139 macro_core.phase_delay\[57\].delay_cell.Y macro_core.phase_delay\[56\].delay_cell.Y VDD VDD sky130_fd_pr__pfet_01v8_hvt w=1u l=0.15u
M140 DATA7 a_75007_9839# a_75363_10089# VDD sky130_fd_pr__pfet_01v8_hvt w=1u l=0.15u
M141 DATA3 a_59827_10383# a_60331_10703# VSS sky130_fd_pr__nfet_01v8 w=0.65u l=0.15u
M142 a_49167_50886# macro_core.array_and_peripherals.wl_driver_2.WL macro_core.array_and_peripherals.write_driver_1.BLB VSS sky130_fd_pr__nfet_01v8 w=0.6u l=0.15u
M143 a_76578_9334# _44_.Y VDD VDD sky130_fd_pr__pfet_01v8_hvt w=0.42u l=0.15u
M144 macro_core.phase_delay\[21\].delay_cell.Y macro_core.phase_delay\[21\].delay_cell.A VSS VSS sky130_fd_pr__nfet_01v8 w=0.65u l=0.15u
M145 macro_core.write_drive.X a_61642_14191# VSS VSS sky130_fd_pr__nfet_01v8 w=0.65u l=0.15u
M146 VDD a_79227_20916# a_80027_20496# VDD sky130_fd_pr__pfet_01v8 w=5.04u l=0.15u
M147 a_49302_13621# a_49134_13647# VSS VSS sky130_fd_pr__nfet_01v8 w=0.64u l=0.15u
M148 a_73866_12127# a_73698_12381# VDD VDD sky130_fd_pr__pfet_01v8_hvt w=0.75u l=0.15u
M149 VSS macro_core.phase_delay\[0\].delay_cell.A _66_.Y VSS sky130_fd_pr__nfet_01v8 w=0.42u l=0.15u
M150 _55_.Y _34_.Y VDD VDD sky130_fd_pr__pfet_01v8_hvt w=1u l=0.15u
M151 clkbuf_0_CLK.X a_62863_9295# VDD VDD sky130_fd_pr__pfet_01v8_hvt w=1u l=0.15u
M152 a_50053_9839# a_49063_9839# a_49927_10205# VSS sky130_fd_pr__special_nfet_01v8 w=0.36u l=0.15u
M153 macro_core.phase_delay\[0\].delay_cell.A a_66819_10383# VDD VDD sky130_fd_pr__pfet_01v8_hvt w=1u l=0.15u
M154 a_56160_14191# a_55761_14191# a_56034_14557# VSS sky130_fd_pr__special_nfet_01v8 w=0.36u l=0.15u
M155 a_58667_12381# a_57803_12015# a_58410_12127# VDD sky130_fd_pr__pfet_01v8_hvt w=0.42u l=0.15u
M156 a_71401_12337# _54_.Y VSS VSS sky130_fd_pr__nfet_01v8 w=0.42u l=0.15u
M157 VSS a_66819_10383# macro_core.phase_delay\[0\].delay_cell.A VSS sky130_fd_pr__nfet_01v8 w=0.42u l=0.15u
M158 VDD macro_core.phase_delay\[59\].delay_cell.Y a_46949_14455# VDD sky130_fd_pr__pfet_01v8_hvt w=0.42u l=0.15u
M159 a_61238_14441# _83_.Q a_61156_14441# VDD sky130_fd_pr__pfet_01v8_hvt w=0.42u l=0.15u
M160 a_58337_12381# a_57803_12015# a_58242_12381# VDD sky130_fd_pr__pfet_01v8_hvt w=0.42u l=0.15u
M161 VDD a_69507_12283# a_69423_12381# VDD sky130_fd_pr__pfet_01v8_hvt w=0.42u l=0.15u
M162 a_71591_12265# _54_.Y VDD VDD sky130_fd_pr__pfet_01v8_hvt w=1u l=0.15u
M163 VDD macro_core.write_drive.X a_55227_20916# VDD sky130_fd_pr__pfet_01v8 w=0.84u l=0.15u
M164 a_58705_14191# a_58539_14191# VSS VSS sky130_fd_pr__nfet_01v8 w=0.42u l=0.15u
M165 VSS _86_.CLK _33_.Y VSS sky130_fd_pr__nfet_01v8 w=0.42u l=0.15u
M166 VSS a_36227_56432# macro_core.array_and_peripherals.wl_driver_3.WL VSS sky130_fd_pr__nfet_01v8 w=5.04u l=0.15u
M167 a_79215_45974# a_79167_45886# VDD VDD sky130_fd_pr__pfet_01v8 w=0.42u l=0.15u
M168 a_47032_14197# macro_core.evaluation.A a_46949_14455# VSS sky130_fd_pr__nfet_01v8 w=0.42u l=0.15u
M169 a_52449_14191# a_52283_14191# VDD VDD sky130_fd_pr__pfet_01v8_hvt w=0.64u l=0.15u
M170 a_61642_14191# _86_.CLK VDD VDD sky130_fd_pr__pfet_01v8_hvt w=1u l=0.15u
M171 VDD a_69082_12127# a_69009_12381# VDD sky130_fd_pr__pfet_01v8_hvt w=0.42u l=0.15u
M172 a_49215_50974# a_49167_50886# VSS VSS sky130_fd_pr__nfet_01v8 w=1.26u l=0.15u
M173 a_49321_12015# a_49155_12015# VDD VDD sky130_fd_pr__pfet_01v8_hvt w=0.64u l=0.15u
M174 a_49720_12015# a_49321_12015# a_49594_12381# VSS sky130_fd_pr__special_nfet_01v8 w=0.36u l=0.15u
M175 a_77711_12381# a_76847_12015# a_77454_12127# VDD sky130_fd_pr__pfet_01v8_hvt w=0.42u l=0.15u
M176 a_85167_45886# a_85215_45974# VSS VSS sky130_fd_pr__nfet_01v8 w=1.26u l=0.15u
M177 a_77381_12381# a_76847_12015# a_77286_12381# VDD sky130_fd_pr__pfet_01v8_hvt w=0.42u l=0.15u
M178 VDD a_36227_56432# macro_core.array_and_peripherals.wl_driver_3.WL VDD sky130_fd_pr__pfet_01v8 w=5.04u l=0.15u
M179 a_85215_50974# macro_core.array_and_peripherals.wl_driver_2.WL macro_core.array_and_peripherals.write_driver_7.BL VSS sky130_fd_pr__nfet_01v8 w=0.6u l=0.15u
M180 VDD a_36227_41432# macro_core.array_and_peripherals.wl_driver_0.WL VDD sky130_fd_pr__pfet_01v8 w=5.04u l=0.15u
M181 macro_core.phase_delay\[62\].delay_cell.A macro_core.phase_delay\[61\].delay_cell.A VDD VDD sky130_fd_pr__pfet_01v8_hvt w=1u l=0.15u
M182 _58_.Y _84_.Q a_52737_11791# VSS sky130_fd_pr__nfet_01v8 w=0.65u l=0.15u
M183 VSS a_55006_11445# a_54964_11849# VSS sky130_fd_pr__nfet_01v8 w=0.42u l=0.15u
M184 VDD a_50571_3677# a_50739_3579# VDD sky130_fd_pr__pfet_01v8_hvt w=1u l=0.15u
M185 a_67167_50886# macro_core.array_and_peripherals.wl_driver_2.WL macro_core.array_and_peripherals.write_driver_4.BLB VSS sky130_fd_pr__nfet_01v8 w=0.6u l=0.15u
M186 a_15147_37067# macro_core.qualify_row\[0\].qualify.A VDD VDD sky130_fd_pr__pfet_01v8_hvt w=0.42u l=0.15u
M187 VDD a_67696_14343# _79_.D VDD sky130_fd_pr__pfet_01v8_hvt w=1u l=0.15u
M188 VDD a_68432_11703# _49_.X VDD sky130_fd_pr__pfet_01v8_hvt w=1u l=0.15u
M189 a_85167_50886# a_85215_50974# VDD VDD sky130_fd_pr__pfet_01v8 w=0.42u l=0.15u
M190 a_66899_12265# _55_.Y VDD VDD sky130_fd_pr__pfet_01v8_hvt w=1u l=0.15u
M191 a_68641_12015# a_68475_12015# VDD VDD sky130_fd_pr__pfet_01v8_hvt w=0.64u l=0.15u
M192 _40_.A1 macro_core.sense_drive.X macro_core.array_and_peripherals.write_driver_3.BL VDD sky130_fd_pr__pfet_01v8 w=2u l=0.15u
M193 a_61615_26902# _40_.A1 macro_core.array_and_peripherals.sense_amp_3.SA_OUTB VSS sky130_fd_pr__nfet_01v8 w=0.98u l=0.15u
M194 macro_core.array_and_peripherals.write_driver_1.BLB macro_core.sense_drive.X macro_core.array_and_peripherals.sense_amp_1.SA_OUTB VDD sky130_fd_pr__pfet_01v8 w=2u l=0.15u
M195 a_55363_12925# _89_.A a_55000_12791# VSS sky130_fd_pr__nfet_01v8 w=0.42u l=0.15u
M196 VDD a_77454_12127# a_77381_12381# VDD sky130_fd_pr__pfet_01v8_hvt w=0.42u l=0.15u
M197 a_56043_10383# _57_.Y VDD VDD sky130_fd_pr__pfet_01v8_hvt w=1u l=0.15u
M198 a_67215_55974# a_67167_55886# VDD VDD sky130_fd_pr__pfet_01v8 w=0.42u l=0.15u
M199 a_67215_40974# a_67167_40886# VDD VDD sky130_fd_pr__pfet_01v8 w=0.42u l=0.15u
M200 VDD a_71271_13647# a_71439_13621# VDD sky130_fd_pr__pfet_01v8_hvt w=1u l=0.15u
M201 a_49417_9839# _75_.D VDD VDD sky130_fd_pr__pfet_01v8_hvt w=0.42u l=0.15u
M202 a_49049_13647# _76_.D VSS VSS sky130_fd_pr__nfet_01v8 w=0.42u l=0.15u
M203 a_52235_11837# _45_.A0 a_51872_11703# VSS sky130_fd_pr__nfet_01v8 w=0.42u l=0.15u
M204 a_73167_55886# a_73215_55974# VSS VSS sky130_fd_pr__nfet_01v8 w=1.26u l=0.15u
M205 a_73167_40886# a_73215_40974# VSS VSS sky130_fd_pr__nfet_01v8 w=1.26u l=0.15u
M206 VSS a_56627_14459# a_56585_14191# VSS sky130_fd_pr__nfet_01v8 w=0.42u l=0.15u
M207 macro_core.phase_delay\[41\].delay_cell.A macro_core.phase_delay\[40\].delay_cell.A VDD VDD sky130_fd_pr__pfet_01v8_hvt w=1u l=0.15u
M208 VDD _85_.Q macro_core.array_and_peripherals.row_decoder_0.A0B VDD sky130_fd_pr__pfet_01v8 w=0.84u l=0.15u
M209 macro_core.array_and_peripherals.row_decoder_0.net4 macro_core.array_and_peripherals.row_decoder_0.A1T macro_core.array_and_peripherals.row_decoder_0.N3 VSS sky130_fd_pr__nfet_01v8 w=2u l=0.15u
M210 a_49594_12381# a_49321_12015# a_49509_12015# VDD sky130_fd_pr__pfet_01v8_hvt w=0.42u l=0.15u
M211 VSS a_59146_14303# a_59104_14191# VSS sky130_fd_pr__nfet_01v8 w=0.42u l=0.15u
M212 a_61156_14441# _83_.Q VSS VSS sky130_fd_pr__nfet_01v8 w=0.42u l=0.15u
M213 a_78510_12342# _84_.Q VDD VDD sky130_fd_pr__pfet_01v8_hvt w=0.42u l=0.15u
M214 VDD macro_core.array_and_peripherals.sense_amp_1.SA_OUTB _42_.A1 VDD sky130_fd_pr__pfet_01v8 w=1.89u l=0.15u
M215 VDD a_68125_14165# a_68155_14518# VDD sky130_fd_pr__pfet_01v8_hvt w=0.42u l=0.15u
M216 a_79068_14191# a_78669_14191# a_78942_14557# VSS sky130_fd_pr__special_nfet_01v8 w=0.36u l=0.15u
M217 a_52779_3677# a_52081_3311# a_52522_3423# VSS sky130_fd_pr__special_nfet_01v8 w=0.36u l=0.15u
M218 VSS macro_core.phase_delay\[0\].delay_cell.A a_77123_9839# VSS sky130_fd_pr__nfet_01v8 w=0.42u l=0.15u
M219 VSS _94_.A a_75007_9839# VSS sky130_fd_pr__nfet_01v8 w=0.42u l=0.15u
M220 macro_core.evaluation.A a_61156_14441# VSS VSS sky130_fd_pr__nfet_01v8 w=0.65u l=0.15u
M221 a_78510_12015# _84_.Q VSS VSS sky130_fd_pr__nfet_01v8 w=0.42u l=0.15u
M222 macro_core.qualify_row\[2\].qualify.X a_14227_36833# VDD VDD sky130_fd_pr__pfet_01v8_hvt w=1u l=0.15u
M223 _87_.TE_B _34_.Y VDD VDD sky130_fd_pr__pfet_01v8_hvt w=1u l=0.15u
M224 VDD _83_.Q a_61642_14191# VDD sky130_fd_pr__pfet_01v8_hvt w=1u l=0.15u
M225 a_50146_3677# a_49873_3311# a_50061_3311# VDD sky130_fd_pr__pfet_01v8_hvt w=0.42u l=0.15u
M226 a_55215_50974# a_55167_50886# VDD VDD sky130_fd_pr__pfet_01v8 w=0.42u l=0.15u
M227 a_49321_12015# a_49155_12015# VSS VSS sky130_fd_pr__nfet_01v8 w=0.42u l=0.15u
M228 a_55215_45974# macro_core.array_and_peripherals.wl_driver_1.WL macro_core.array_and_peripherals.write_driver_2.BL VSS sky130_fd_pr__nfet_01v8 w=0.6u l=0.15u
M229 macro_core.array_and_peripherals.write_driver_4.BLB macro_core.sense_drive.X macro_core.array_and_peripherals.sense_amp_4.SA_OUTB VDD sky130_fd_pr__pfet_01v8 w=2u l=0.15u
M230 a_72199_14191# _92_.A a_71836_14343# VSS sky130_fd_pr__nfet_01v8 w=0.42u l=0.15u
M231 a_78368_12167# _94_.A a_78510_12342# VDD sky130_fd_pr__pfet_01v8_hvt w=0.42u l=0.15u
M232 macro_core.phase_delay\[10\].delay_cell.Y macro_core.phase_delay\[10\].delay_cell.A VDD VDD sky130_fd_pr__pfet_01v8_hvt w=1u l=0.15u
M233 a_76436_9527# DATA7 a_76578_9661# VSS sky130_fd_pr__nfet_01v8 w=0.42u l=0.15u
M234 macro_core.phase_delay\[43\].delay_cell.A macro_core.phase_delay\[42\].delay_cell.A VDD VDD sky130_fd_pr__pfet_01v8_hvt w=1u l=0.15u
M235 a_48861_13653# a_48695_13653# VDD VDD sky130_fd_pr__pfet_01v8_hvt w=0.64u l=0.15u
M236 VDD a_56288_13879# _47_.X VDD sky130_fd_pr__pfet_01v8_hvt w=1u l=0.15u
M237 VSS a_62863_9295# clkbuf_0_CLK.X VSS sky130_fd_pr__nfet_01v8 w=0.42u l=0.15u
M238 VSS clkbuf_0_CLK.X a_58539_10383# VSS sky130_fd_pr__nfet_01v8 w=0.42u l=0.15u
M239 a_61167_50886# a_61215_50974# VSS VSS sky130_fd_pr__nfet_01v8 w=1.26u l=0.15u
M240 a_77693_13945# _44_.Y VDD VDD sky130_fd_pr__pfet_01v8_hvt w=0.42u l=0.15u
M241 VDD _91_.A a_66543_12015# VDD sky130_fd_pr__pfet_01v8_hvt w=0.64u l=0.15u
M242 VSS _91_.A a_66543_12015# VSS sky130_fd_pr__nfet_01v8 w=0.42u l=0.15u
M243 VSS a_50571_3677# a_50739_3579# VSS sky130_fd_pr__nfet_01v8 w=0.65u l=0.15u
M244 VDD _84_.Q _54_.Y VDD sky130_fd_pr__pfet_01v8_hvt w=1u l=0.15u
M245 a_55167_45886# a_55215_45974# VDD VDD sky130_fd_pr__pfet_01v8 w=0.42u l=0.15u
M246 a_46015_16496# _45_.A0 macro_core.array_and_peripherals.write_driver_0.BLB VSS sky130_fd_pr__nfet_01v8 w=5.04u l=0.15u
M247 macro_core.phase_delay\[77\].delay_cell.Y macro_core.phase_delay\[76\].delay_cell.Y VSS VSS sky130_fd_pr__nfet_01v8 w=0.65u l=0.15u
M248 a_68641_12015# a_68475_12015# VSS VSS sky130_fd_pr__nfet_01v8 w=0.42u l=0.15u
M249 a_52081_3311# a_51915_3311# VSS VSS sky130_fd_pr__nfet_01v8 w=0.42u l=0.15u
M250 a_68829_12015# _49_.X VDD VDD sky130_fd_pr__pfet_01v8_hvt w=0.42u l=0.15u
M251 a_69082_12127# a_68914_12381# VSS VSS sky130_fd_pr__nfet_01v8 w=0.64u l=0.15u
M252 _94_.A a_77879_12283# VSS VSS sky130_fd_pr__nfet_01v8 w=0.65u l=0.15u
M253 VDD a_50095_10107# a_50011_10205# VDD sky130_fd_pr__pfet_01v8_hvt w=0.42u l=0.15u
M254 a_55949_14191# _47_.X VSS VSS sky130_fd_pr__nfet_01v8 w=0.42u l=0.15u
M255 a_72162_12342# _44_.Y VDD VDD sky130_fd_pr__pfet_01v8_hvt w=0.42u l=0.15u
M256 a_53159_13430# DATA1 a_52700_13255# VDD sky130_fd_pr__pfet_01v8_hvt w=0.42u l=0.15u
M257 a_72162_12015# _44_.Y VSS VSS sky130_fd_pr__nfet_01v8 w=0.42u l=0.15u
M258 VDD a_61642_14191# macro_core.write_drive.X VDD sky130_fd_pr__pfet_01v8_hvt w=1u l=0.15u
M259 a_43215_55974# macro_core.array_and_peripherals.wl_driver_3.WL macro_core.array_and_peripherals.write_driver_0.BL VSS sky130_fd_pr__nfet_01v8 w=0.6u l=0.15u
M260 a_43215_40974# macro_core.array_and_peripherals.wl_driver_0.WL macro_core.array_and_peripherals.write_driver_0.BL VSS sky130_fd_pr__nfet_01v8 w=0.6u l=0.15u
M261 a_56717_13945# _44_.Y VSS VSS sky130_fd_pr__nfet_01v8 w=0.42u l=0.15u
M262 _88_.A a_49727_13621# VDD VDD sky130_fd_pr__pfet_01v8_hvt w=1u l=0.15u
M263 VSS a_53129_13077# a_53063_13103# VSS sky130_fd_pr__nfet_01v8 w=0.42u l=0.15u
M264 VSS _86_.CLK a_57527_9301# VSS sky130_fd_pr__nfet_01v8 w=0.42u l=0.15u
M265 VSS a_79535_14459# a_79493_14191# VSS sky130_fd_pr__nfet_01v8 w=0.42u l=0.15u
M266 _88_.A a_49727_13621# VSS VSS sky130_fd_pr__nfet_01v8 w=0.65u l=0.15u
M267 VSS a_63067_12283# a_63025_12015# VSS sky130_fd_pr__nfet_01v8 w=0.42u l=0.15u
M268 macro_core.phase_delay\[13\].delay_cell.Y macro_core.phase_delay\[12\].delay_cell.Y VDD VDD sky130_fd_pr__pfet_01v8_hvt w=1u l=0.15u
M269 a_67696_14343# _91_.A a_67838_14518# VDD sky130_fd_pr__pfet_01v8_hvt w=0.42u l=0.15u
M270 VSS macro_core.phase_delay\[0\].delay_cell.A _63_.Y VSS sky130_fd_pr__nfet_01v8 w=0.42u l=0.15u
M271 a_72020_12167# _50_.A0 a_72162_12342# VDD sky130_fd_pr__pfet_01v8_hvt w=0.42u l=0.15u
M272 VDD a_50314_3423# a_50241_3677# VDD sky130_fd_pr__pfet_01v8_hvt w=0.42u l=0.15u
M273 a_43167_55886# a_43215_55974# VDD VDD sky130_fd_pr__pfet_01v8 w=0.42u l=0.15u
M274 a_43167_40886# a_43215_40974# VDD VDD sky130_fd_pr__pfet_01v8 w=0.42u l=0.15u
M275 VSS _86_.Q macro_core.array_and_peripherals.row_decoder_0.A1B VSS sky130_fd_pr__nfet_01v8 w=0.84u l=0.15u
M276 VDD macro_core.phase_delay\[0\].delay_cell.A a_68475_12015# VDD sky130_fd_pr__pfet_01v8_hvt w=0.64u l=0.15u
M277 macro_core.phase_delay\[16\].delay_cell.Y macro_core.phase_delay\[15\].delay_cell.Y VSS VSS sky130_fd_pr__nfet_01v8 w=0.65u l=0.15u
M278 a_79167_50886# a_79215_50974# VSS VSS sky130_fd_pr__nfet_01v8 w=1.26u l=0.15u
M279 VSS macro_core.write_drive.X a_50415_16496# VSS sky130_fd_pr__nfet_01v8 w=5.04u l=0.15u
M280 a_62415_16496# macro_core.data_complement\[3\].complement.Y macro_core.array_and_peripherals.write_driver_3.BL VSS sky130_fd_pr__nfet_01v8 w=5.04u l=0.15u
M281 VSS a_78368_12167# _82_.D VSS sky130_fd_pr__nfet_01v8 w=0.65u l=0.15u
M282 macro_core.phase_delay\[10\].delay_cell.A macro_core.phase_delay\[8\].delay_cell.Y VDD VDD sky130_fd_pr__pfet_01v8_hvt w=1u l=0.15u
M283 VDD macro_core.qualify_row\[3\].qualify.A macro_core.array_and_peripherals.row_decoder_0.N3 VDD sky130_fd_pr__pfet_01v8 w=0.84u l=0.15u
M284 macro_core.phase_delay\[1\].delay_cell.A macro_core.phase_delay\[0\].delay_cell.A VSS VSS sky130_fd_pr__nfet_01v8 w=0.65u l=0.15u
M285 a_55853_10383# _57_.Y VDD VDD sky130_fd_pr__pfet_01v8_hvt w=0.64u l=0.15u
M286 VDD a_55431_11445# a_55347_11471# VDD sky130_fd_pr__pfet_01v8_hvt w=0.42u l=0.15u
M287 macro_core.phase_delay\[58\].delay_cell.Y macro_core.phase_delay\[57\].delay_cell.Y VSS VSS sky130_fd_pr__nfet_01v8 w=0.65u l=0.15u
M288 a_75357_12337# _53_.Y VSS VSS sky130_fd_pr__nfet_01v8 w=0.42u l=0.15u
M289 a_50241_3677# a_49707_3311# a_50146_3677# VDD sky130_fd_pr__pfet_01v8_hvt w=0.42u l=0.15u
M290 a_77730_9951# a_77562_10205# VSS VSS sky130_fd_pr__nfet_01v8 w=0.64u l=0.15u
M291 macro_core.data_complement\[6\].complement.Y _51_.A0 VSS VSS sky130_fd_pr__nfet_01v8 w=0.65u l=0.15u
M292 macro_core.phase_delay\[55\].delay_cell.Y macro_core.phase_delay\[54\].delay_cell.Y VDD VDD sky130_fd_pr__pfet_01v8_hvt w=1u l=0.15u
M293 VSS a_74123_12381# a_74291_12283# VSS sky130_fd_pr__nfet_01v8 w=0.65u l=0.15u
M294 macro_core.phase_delay\[7\].delay_cell.Y macro_core.phase_delay\[6\].delay_cell.Y VDD VDD sky130_fd_pr__pfet_01v8_hvt w=1u l=0.15u
M295 VDD macro_core.precharge_drive.X macro_core.array_and_peripherals.write_driver_1.BL VDD sky130_fd_pr__pfet_01v8 w=2.52u l=0.15u
M296 VDD a_75119_14459# a_75035_14557# VDD sky130_fd_pr__pfet_01v8_hvt w=0.42u l=0.15u
M297 VDD a_76436_9527# _52_.X VDD sky130_fd_pr__pfet_01v8_hvt w=1u l=0.15u
M298 VSS macro_core.evaluation.X a_12749_36833# VSS sky130_fd_pr__nfet_01v8 w=0.42u l=0.15u
M299 macro_core.data_complement\[4\].complement.Y _49_.A0 VDD VDD sky130_fd_pr__pfet_01v8_hvt w=1u l=0.15u
M300 a_56543_14557# a_55761_14191# a_56459_14557# VDD sky130_fd_pr__pfet_01v8_hvt w=0.42u l=0.15u
M301 VSS macro_core.sense_drive.X a_61615_26902# VSS sky130_fd_pr__nfet_01v8 w=0.98u l=0.15u
M302 _46_.A0 a_53315_14459# VDD VDD sky130_fd_pr__pfet_01v8_hvt w=1u l=0.15u
M303 VSS CLK a_62863_9295# VSS sky130_fd_pr__nfet_01v8 w=0.42u l=0.15u
M304 VDD a_49670_9951# a_49597_10205# VDD sky130_fd_pr__pfet_01v8_hvt w=0.42u l=0.15u
M305 VDD a_43227_20916# a_44027_20496# VDD sky130_fd_pr__pfet_01v8 w=5.04u l=0.15u
M306 macro_core.phase_delay\[59\].delay_cell.Y macro_core.phase_delay\[58\].delay_cell.Y VSS VSS sky130_fd_pr__nfet_01v8 w=0.65u l=0.15u
M307 a_53911_2999# WEb VDD VDD sky130_fd_pr__pfet_01v8_hvt w=0.42u l=0.15u
M308 macro_core.data_complement\[7\].complement.Y _52_.A0 VDD VDD sky130_fd_pr__pfet_01v8_hvt w=1u l=0.15u
M309 VSS a_52522_3423# a_52480_3311# VSS sky130_fd_pr__nfet_01v8 w=0.42u l=0.15u
M310 a_72383_12015# _50_.A0 a_72020_12167# VSS sky130_fd_pr__nfet_01v8 w=0.42u l=0.15u
M311 VSS a_48744_11703# _75_.D VSS sky130_fd_pr__nfet_01v8 w=0.65u l=0.15u
M312 macro_core.phase_delay\[14\].delay_cell.Y macro_core.phase_delay\[13\].delay_cell.Y VDD VDD sky130_fd_pr__pfet_01v8_hvt w=1u l=0.15u
M313 macro_core.phase_delay\[32\].delay_cell.Y macro_core.phase_delay\[32\].delay_cell.A VDD VDD sky130_fd_pr__pfet_01v8_hvt w=1u l=0.15u
M314 VSS macro_core.write_drive.X a_68415_16496# VSS sky130_fd_pr__nfet_01v8 w=5.04u l=0.15u
M315 a_52817_14557# a_52283_14191# a_52722_14557# VDD sky130_fd_pr__pfet_01v8_hvt w=0.42u l=0.15u
M316 a_62389_12015# _48_.X VSS VSS sky130_fd_pr__nfet_01v8 w=0.42u l=0.15u
M317 VSS a_72020_12167# _50_.X VSS sky130_fd_pr__nfet_01v8 w=0.65u l=0.15u
M318 macro_core.phase_delay\[30\].delay_cell.Y macro_core.phase_delay\[30\].delay_cell.A VSS VSS sky130_fd_pr__nfet_01v8 w=0.65u l=0.15u
M319 macro_core.qualify_row\[3\].qualify.X a_15147_35745# VDD VDD sky130_fd_pr__pfet_01v8_hvt w=1u l=0.15u
M320 VDD _36_.A1 macro_core.array_and_peripherals.sense_amp_7.SA_OUTB VDD sky130_fd_pr__pfet_01v8 w=1.89u l=0.15u
M321 VSS macro_core.qualify_row\[2\].qualify.X a_36227_51432# VSS sky130_fd_pr__nfet_01v8 w=1.68u l=0.15u
M322 macro_core.data_complement\[3\].complement.Y _48_.A0 VSS VSS sky130_fd_pr__nfet_01v8 w=0.65u l=0.15u
M323 VDD _60_.Y a_48695_13653# VDD sky130_fd_pr__pfet_01v8_hvt w=0.64u l=0.15u
M324 macro_core.phase_delay\[6\].delay_cell.Y macro_core.phase_delay\[5\].delay_cell.Y VSS VSS sky130_fd_pr__nfet_01v8 w=0.65u l=0.15u
M325 macro_core.array_and_peripherals.write_driver_3.BLB macro_core.precharge_drive.X macro_core.array_and_peripherals.write_driver_3.BL VDD sky130_fd_pr__pfet_01v8 w=2.52u l=0.15u
M326 macro_core.sense_drive.X a_64611_14191# VDD VDD sky130_fd_pr__pfet_01v8_hvt w=1u l=0.15u
M327 a_74253_14191# a_74087_14191# VDD VDD sky130_fd_pr__pfet_01v8_hvt w=0.64u l=0.15u
M328 a_67215_45974# a_67167_45886# VSS VSS sky130_fd_pr__nfet_01v8 w=1.26u l=0.15u
M329 macro_core.phase_delay\[68\].delay_cell.Y macro_core.phase_delay\[67\].delay_cell.Y VSS VSS sky130_fd_pr__nfet_01v8 w=0.65u l=0.15u
M330 a_49167_45886# a_49215_45974# VSS VSS sky130_fd_pr__nfet_01v8 w=1.26u l=0.15u
M331 a_50369_14165# _84_.Q VDD VDD sky130_fd_pr__pfet_01v8_hvt w=0.42u l=0.15u
M332 a_49685_14025# a_48695_13653# a_49559_13647# VSS sky130_fd_pr__special_nfet_01v8 w=0.36u l=0.15u
M333 VSS macro_core.phase_delay\[0\].delay_cell.A a_68475_12015# VSS sky130_fd_pr__nfet_01v8 w=0.42u l=0.15u
M334 VDD a_58559_9269# a_58475_9295# VDD sky130_fd_pr__pfet_01v8_hvt w=0.42u l=0.15u
M335 a_54838_11471# a_54399_11477# a_54753_11471# VSS sky130_fd_pr__special_nfet_01v8 w=0.36u l=0.15u
M336 a_85167_45886# macro_core.array_and_peripherals.wl_driver_1.WL macro_core.array_and_peripherals.write_driver_7.BLB VSS sky130_fd_pr__nfet_01v8 w=0.6u l=0.15u
M337 a_73615_26902# macro_core.array_and_peripherals.sense_amp_5.SA_OUTB _38_.A1 VSS sky130_fd_pr__nfet_01v8 w=0.98u l=0.15u
M338 VSS a_49727_13621# a_49685_14025# VSS sky130_fd_pr__nfet_01v8 w=0.42u l=0.15u
M339 a_70761_13647# _80_.D VSS VSS sky130_fd_pr__nfet_01v8 w=0.42u l=0.15u
M340 a_77454_12127# a_77286_12381# VDD VDD sky130_fd_pr__pfet_01v8_hvt w=0.75u l=0.15u
M341 a_50082_14191# _84_.Q VSS VSS sky130_fd_pr__nfet_01v8 w=0.42u l=0.15u
M342 a_58667_12381# a_57969_12015# a_58410_12127# VSS sky130_fd_pr__special_nfet_01v8 w=0.36u l=0.15u
M343 macro_core.phase_delay\[67\].delay_cell.Y macro_core.phase_delay\[66\].delay_cell.Y VSS VSS sky130_fd_pr__nfet_01v8 w=0.65u l=0.15u
M344 a_49167_50886# a_49215_50974# VDD VDD sky130_fd_pr__pfet_01v8 w=0.42u l=0.15u
M345 VDD a_61642_14191# macro_core.write_drive.X VDD sky130_fd_pr__pfet_01v8_hvt w=1u l=0.15u
M346 macro_core.phase_delay\[32\].delay_cell.A macro_core.phase_delay\[30\].delay_cell.Y VSS VSS sky130_fd_pr__nfet_01v8 w=0.65u l=0.15u
M347 VSS macro_core.write_drive.X a_82015_16496# VSS sky130_fd_pr__nfet_01v8 w=5.04u l=0.15u
M348 macro_core.data_complement\[2\].complement.Y _47_.A0 VDD VDD sky130_fd_pr__pfet_01v8_hvt w=1u l=0.15u
M349 a_71836_14343# _38_.A1 a_71978_14191# VSS sky130_fd_pr__nfet_01v8 w=0.42u l=0.15u
M350 _93_.A a_75119_14459# VSS VSS sky130_fd_pr__nfet_01v8 w=0.65u l=0.15u
M351 VSS a_67683_13647# a_67851_13621# VSS sky130_fd_pr__nfet_01v8 w=0.65u l=0.15u
M352 VDD a_67683_13647# a_67851_13621# VDD sky130_fd_pr__pfet_01v8_hvt w=1u l=0.15u
M353 VDD _86_.CLK _33_.Y VDD sky130_fd_pr__pfet_01v8_hvt w=0.84u l=0.15u
M354 a_52269_3311# ADDR0 VSS VSS sky130_fd_pr__nfet_01v8 w=0.42u l=0.15u
M355 a_53911_2999# WEb VSS VSS sky130_fd_pr__nfet_01v8 w=0.42u l=0.15u
M356 a_55215_55974# a_55167_55886# VSS VSS sky130_fd_pr__nfet_01v8 w=1.26u l=0.15u
M357 a_55215_40974# a_55167_40886# VSS VSS sky130_fd_pr__nfet_01v8 w=1.26u l=0.15u
M358 VSS _86_.CLK a_51915_3311# VSS sky130_fd_pr__nfet_01v8 w=0.42u l=0.15u
M359 macro_core.phase_delay\[30\].delay_cell.A macro_core.phase_delay\[28\].delay_cell.Y VSS VSS sky130_fd_pr__nfet_01v8 w=0.65u l=0.15u
M360 a_71978_14191# _84_.Q VSS VSS sky130_fd_pr__nfet_01v8 w=0.42u l=0.15u
M361 a_76155_14191# _93_.A a_75792_14343# VSS sky130_fd_pr__nfet_01v8 w=0.42u l=0.15u
M362 macro_core.phase_delay\[53\].delay_cell.A macro_core.phase_delay\[51\].delay_cell.Y VDD VDD sky130_fd_pr__pfet_01v8_hvt w=1u l=0.15u
M363 macro_core.phase_delay\[51\].delay_cell.A macro_core.phase_delay\[50\].delay_cell.A VDD VDD sky130_fd_pr__pfet_01v8_hvt w=1u l=0.15u
M364 VDD _89_.A a_55687_10383# VDD sky130_fd_pr__pfet_01v8_hvt w=0.64u l=0.15u
M365 a_73167_55886# macro_core.array_and_peripherals.wl_driver_3.WL macro_core.array_and_peripherals.write_driver_5.BLB VSS sky130_fd_pr__nfet_01v8 w=0.6u l=0.15u
M366 a_73167_40886# macro_core.array_and_peripherals.wl_driver_0.WL macro_core.array_and_peripherals.write_driver_5.BLB VSS sky130_fd_pr__nfet_01v8 w=0.6u l=0.15u
M367 a_67384_14025# a_66985_13653# a_67258_13647# VSS sky130_fd_pr__special_nfet_01v8 w=0.36u l=0.15u
M368 a_86027_20496# macro_core.data_complement\[7\].complement.Y macro_core.array_and_peripherals.write_driver_7.BL VDD sky130_fd_pr__pfet_01v8 w=5.04u l=0.15u
M369 a_52637_14191# _46_.X VDD VDD sky130_fd_pr__pfet_01v8_hvt w=0.42u l=0.15u
M370 VDD a_63067_12283# a_62983_12381# VDD sky130_fd_pr__pfet_01v8_hvt w=0.42u l=0.15u
M371 macro_core.release_phase.X a_65103_12043# VDD VDD sky130_fd_pr__pfet_01v8_hvt w=1u l=0.15u
M372 a_63627_20496# _48_.A0 macro_core.array_and_peripherals.write_driver_3.BLB VDD sky130_fd_pr__pfet_01v8 w=5.04u l=0.15u
M373 VDD a_73227_20916# a_75627_20496# VDD sky130_fd_pr__pfet_01v8 w=5.04u l=0.15u
M374 a_77693_13945# _44_.Y VSS VSS sky130_fd_pr__nfet_01v8 w=0.42u l=0.15u
M375 VDD a_55429_12857# a_55459_12598# VDD sky130_fd_pr__pfet_01v8_hvt w=0.42u l=0.15u
M376 VSS a_52301_11769# a_52235_11837# VSS sky130_fd_pr__nfet_01v8 w=0.42u l=0.15u
M377 VDD _84_.Q _56_.Y VDD sky130_fd_pr__pfet_01v8_hvt w=1u l=0.15u
M378 VDD macro_core.evaluation.X macro_core.array_and_peripherals.row_decoder_0.N0 VDD sky130_fd_pr__pfet_01v8 w=1.25u l=0.15u
M379 a_73215_45974# a_73167_45886# VDD VDD sky130_fd_pr__pfet_01v8 w=0.42u l=0.15u
M380 a_12749_36833# macro_core.qualify_row\[1\].qualify.A a_12663_36833# VSS sky130_fd_pr__nfet_01v8 w=0.42u l=0.15u
M381 a_56459_14557# a_55595_14191# a_56202_14303# VDD sky130_fd_pr__pfet_01v8_hvt w=0.42u l=0.15u
M382 a_49229_9839# a_49063_9839# VDD VDD sky130_fd_pr__pfet_01v8_hvt w=0.64u l=0.15u
M383 VSS macro_core.evaluation.X a_15233_35745# VSS sky130_fd_pr__nfet_01v8 w=0.42u l=0.15u
M384 VSS macro_core.write_drive.X a_85227_20916# VSS sky130_fd_pr__nfet_01v8 w=0.84u l=0.15u
M385 a_68125_14165# _84_.Q VDD VDD sky130_fd_pr__pfet_01v8_hvt w=0.42u l=0.15u
M386 macro_core.phase_delay\[50\].delay_cell.A macro_core.phase_delay\[49\].delay_cell.A VDD VDD sky130_fd_pr__pfet_01v8_hvt w=1u l=0.15u
M387 a_43215_50974# a_43167_50886# VSS VSS sky130_fd_pr__nfet_01v8 w=1.26u l=0.15u
M388 VSS _90_.A a_59827_10383# VSS sky130_fd_pr__nfet_01v8 w=0.42u l=0.15u
M389 macro_core.phase_delay\[76\].delay_cell.Y macro_core.phase_delay\[75\].delay_cell.Y VSS VSS sky130_fd_pr__nfet_01v8 w=0.65u l=0.15u
M390 VSS macro_core.array_and_peripherals.row_decoder_0.N2 macro_core.qualify_row\[2\].qualify.A VSS sky130_fd_pr__nfet_01v8 w=2u l=0.15u
M391 a_50303_14191# _88_.A a_49940_14343# VSS sky130_fd_pr__nfet_01v8 w=0.42u l=0.15u
M392 a_52700_13255# DATA1 a_52842_13103# VSS sky130_fd_pr__nfet_01v8 w=0.42u l=0.15u
M393 a_79215_50974# macro_core.array_and_peripherals.wl_driver_2.WL macro_core.array_and_peripherals.write_driver_6.BL VSS sky130_fd_pr__nfet_01v8 w=0.6u l=0.15u
M394 VDD macro_core.precharge_drive.X macro_core.array_and_peripherals.write_driver_7.BLB VDD sky130_fd_pr__pfet_01v8 w=2.52u l=0.15u
M395 a_61167_50886# macro_core.array_and_peripherals.wl_driver_2.WL macro_core.array_and_peripherals.write_driver_3.BLB VSS sky130_fd_pr__nfet_01v8 w=0.6u l=0.15u
M396 a_55761_14191# a_55595_14191# VSS VSS sky130_fd_pr__nfet_01v8 w=0.42u l=0.15u
M397 a_62201_12015# a_62035_12015# VDD VDD sky130_fd_pr__pfet_01v8_hvt w=0.64u l=0.15u
M398 a_62600_12015# a_62201_12015# a_62474_12381# VSS sky130_fd_pr__special_nfet_01v8 w=0.36u l=0.15u
M399 VSS a_72265_14165# a_72199_14191# VSS sky130_fd_pr__nfet_01v8 w=0.42u l=0.15u
M400 macro_core.phase_delay\[15\].delay_cell.Y macro_core.phase_delay\[14\].delay_cell.Y VSS VSS sky130_fd_pr__nfet_01v8 w=0.65u l=0.15u
M401 a_68574_11837# _44_.Y VSS VSS sky130_fd_pr__nfet_01v8 w=0.42u l=0.15u
M402 a_56202_14303# a_56034_14557# VSS VSS sky130_fd_pr__nfet_01v8 w=0.64u l=0.15u
M403 a_55429_12857# _84_.Q VDD VDD sky130_fd_pr__pfet_01v8_hvt w=0.42u l=0.15u
M404 VDD _65_.Y a_74087_14191# VDD sky130_fd_pr__pfet_01v8_hvt w=0.64u l=0.15u
M405 a_49134_13647# a_48861_13653# a_49049_13647# VDD sky130_fd_pr__pfet_01v8_hvt w=0.42u l=0.15u
M406 a_49302_13621# a_49134_13647# VDD VDD sky130_fd_pr__pfet_01v8_hvt w=0.75u l=0.15u
M407 VSS a_55000_12791# _77_.D VSS sky130_fd_pr__nfet_01v8 w=0.65u l=0.15u
M408 a_59508_12791# _40_.A1 a_59650_12925# VSS sky130_fd_pr__nfet_01v8 w=0.42u l=0.15u
M409 a_59967_12598# _40_.A1 a_59508_12791# VDD sky130_fd_pr__pfet_01v8_hvt w=0.42u l=0.15u
M410 a_52331_11510# DATA0 a_51872_11703# VDD sky130_fd_pr__pfet_01v8_hvt w=0.42u l=0.15u
M411 a_61215_55974# a_61167_55886# VDD VDD sky130_fd_pr__pfet_01v8 w=0.42u l=0.15u
M412 a_61215_40974# a_61167_40886# VDD VDD sky130_fd_pr__pfet_01v8 w=0.42u l=0.15u
M413 macro_core.qualify_row\[0\].qualify.X a_15147_37067# VSS VSS sky130_fd_pr__nfet_01v8 w=0.65u l=0.15u
M414 VDD a_58667_12381# a_58835_12283# VDD sky130_fd_pr__pfet_01v8_hvt w=1u l=0.15u
M415 VDD macro_core.write_drive.X a_67227_20916# VDD sky130_fd_pr__pfet_01v8 w=0.84u l=0.15u
M416 VDD a_59571_14459# a_59487_14557# VDD sky130_fd_pr__pfet_01v8_hvt w=0.42u l=0.15u
M417 VSS a_71836_14343# _80_.D VSS sky130_fd_pr__nfet_01v8 w=0.65u l=0.15u
M418 a_64918_13353# macro_core.phase_delay\[79\].delay_cell.Y a_64836_13353# VDD sky130_fd_pr__pfet_01v8_hvt w=0.42u l=0.15u
M419 a_73613_12015# _50_.X VSS VSS sky130_fd_pr__nfet_01v8 w=0.42u l=0.15u
M420 macro_core.phase_delay\[26\].delay_cell.A macro_core.phase_delay\[25\].delay_cell.A VDD VDD sky130_fd_pr__pfet_01v8_hvt w=1u l=0.15u
M421 a_52419_12015# a_52081_12337# VSS VSS sky130_fd_pr__nfet_01v8 w=0.65u l=0.15u
M422 _44_.Y CSb VSS VSS sky130_fd_pr__nfet_01v8 w=0.65u l=0.15u
M423 VDD macro_core.phase_delay\[0\].delay_cell.A _66_.Y VDD sky130_fd_pr__pfet_01v8_hvt w=0.84u l=0.15u
M424 macro_core.phase_delay\[0\].delay_cell.A a_66819_10383# VSS VSS sky130_fd_pr__nfet_01v8 w=0.42u l=0.15u
M425 VDD a_78155_10107# a_78071_10205# VDD sky130_fd_pr__pfet_01v8_hvt w=0.42u l=0.15u
M426 VDD macro_core.array_and_peripherals.sense_amp_0.SA_OUTB _43_.A1 VDD sky130_fd_pr__pfet_01v8 w=1.89u l=0.15u
M427 a_74694_14303# a_74526_14557# VDD VDD sky130_fd_pr__pfet_01v8_hvt w=0.75u l=0.15u
M428 VSS macro_core.array_and_peripherals.row_decoder_0.N1 macro_core.qualify_row\[1\].qualify.A VSS sky130_fd_pr__nfet_01v8 w=2u l=0.15u
M429 VDD _84_.Q _53_.Y VDD sky130_fd_pr__pfet_01v8_hvt w=1u l=0.15u
M430 a_63599_14191# macro_core.evaluation.A VDD VDD sky130_fd_pr__pfet_01v8_hvt w=1u l=0.15u
M431 a_71739_12015# a_71401_12337# VSS VSS sky130_fd_pr__nfet_01v8 w=0.65u l=0.15u
M432 macro_core.phase_delay\[12\].delay_cell.Y macro_core.phase_delay\[11\].delay_cell.Y VSS VSS sky130_fd_pr__nfet_01v8 w=0.65u l=0.15u
M433 a_56747_13686# DATA2 a_56288_13879# VDD sky130_fd_pr__pfet_01v8_hvt w=0.42u l=0.15u
M434 a_62474_12381# a_62201_12015# a_62389_12015# VDD sky130_fd_pr__pfet_01v8_hvt w=0.42u l=0.15u
M435 a_68574_11510# _44_.Y VDD VDD sky130_fd_pr__pfet_01v8_hvt w=0.42u l=0.15u
M436 _38_.A1 macro_core.sense_drive.X macro_core.array_and_peripherals.write_driver_5.BL VDD sky130_fd_pr__pfet_01v8 w=2u l=0.15u
M437 a_73615_26902# _38_.A1 macro_core.array_and_peripherals.sense_amp_5.SA_OUTB VSS sky130_fd_pr__nfet_01v8 w=0.98u l=0.15u
M438 VSS a_78155_10107# a_78113_9839# VSS sky130_fd_pr__nfet_01v8 w=0.42u l=0.15u
M439 a_49215_45974# macro_core.array_and_peripherals.wl_driver_1.WL macro_core.array_and_peripherals.write_driver_1.BL VSS sky130_fd_pr__nfet_01v8 w=0.6u l=0.15u
M440 macro_core.array_and_peripherals.write_driver_3.BLB macro_core.sense_drive.X macro_core.array_and_peripherals.sense_amp_3.SA_OUTB VDD sky130_fd_pr__pfet_01v8 w=2u l=0.15u
M441 a_74951_14557# a_74253_14191# a_74694_14303# VSS sky130_fd_pr__special_nfet_01v8 w=0.36u l=0.15u
M442 macro_core.phase_delay\[5\].delay_cell.Y macro_core.phase_delay\[4\].delay_cell.Y VDD VDD sky130_fd_pr__pfet_01v8_hvt w=1u l=0.15u
M443 macro_core.phase_delay\[51\].delay_cell.Y macro_core.phase_delay\[51\].delay_cell.A VSS VSS sky130_fd_pr__nfet_01v8 w=0.65u l=0.15u
M444 a_79215_40974# a_79167_40886# VDD VDD sky130_fd_pr__pfet_01v8 w=0.42u l=0.15u
M445 a_75077_14191# a_74087_14191# a_74951_14557# VSS sky130_fd_pr__special_nfet_01v8 w=0.36u l=0.15u
M446 macro_core.phase_delay\[56\].delay_cell.Y macro_core.phase_delay\[55\].delay_cell.Y VDD VDD sky130_fd_pr__pfet_01v8_hvt w=1u l=0.15u
M447 VDD a_62912_11703# _48_.X VDD sky130_fd_pr__pfet_01v8_hvt w=1u l=0.15u
M448 a_79215_55974# a_79167_55886# VDD VDD sky130_fd_pr__pfet_01v8 w=0.42u l=0.15u
M449 macro_core.precharge_phase.X a_64836_13353# VSS VSS sky130_fd_pr__nfet_01v8 w=0.65u l=0.15u
M450 a_75173_10161# _35_.Y VDD VDD sky130_fd_pr__pfet_01v8_hvt w=0.64u l=0.15u
M451 a_68795_11837# _49_.A0 a_68432_11703# VSS sky130_fd_pr__nfet_01v8 w=0.42u l=0.15u
M452 _93_.A a_75119_14459# VDD VDD sky130_fd_pr__pfet_01v8_hvt w=1u l=0.15u
M453 a_78669_14191# a_78503_14191# VSS VSS sky130_fd_pr__nfet_01v8 w=0.42u l=0.15u
M454 a_55429_12857# _84_.Q VSS VSS sky130_fd_pr__nfet_01v8 w=0.42u l=0.15u
M455 a_62201_12015# a_62035_12015# VSS VSS sky130_fd_pr__nfet_01v8 w=0.42u l=0.15u
M456 a_68432_11703# _49_.A0 a_68574_11510# VDD sky130_fd_pr__pfet_01v8_hvt w=0.42u l=0.15u
M457 a_85167_55886# a_85215_55974# VSS VSS sky130_fd_pr__nfet_01v8 w=1.26u l=0.15u
M458 a_85167_40886# a_85215_40974# VSS VSS sky130_fd_pr__nfet_01v8 w=1.26u l=0.15u
M459 VDD macro_core.array_and_peripherals.row_decoder_0.N2 macro_core.qualify_row\[2\].qualify.A VDD sky130_fd_pr__pfet_01v8 w=3u l=0.15u
M460 VDD a_36227_51432# macro_core.array_and_peripherals.wl_driver_2.WL VDD sky130_fd_pr__pfet_01v8 w=5.04u l=0.15u
M461 VSS a_59937_12857# a_59871_12925# VSS sky130_fd_pr__nfet_01v8 w=0.42u l=0.15u
M462 a_52301_11769# _44_.Y VSS VSS sky130_fd_pr__nfet_01v8 w=0.42u l=0.15u
M463 macro_core.phase_delay\[23\].delay_cell.Y macro_core.phase_delay\[23\].delay_cell.A VDD VDD sky130_fd_pr__pfet_01v8_hvt w=1u l=0.15u
M464 a_69423_12381# a_68641_12015# a_69339_12381# VDD sky130_fd_pr__pfet_01v8_hvt w=0.42u l=0.15u
M465 VDD _84_.Q _55_.Y VDD sky130_fd_pr__pfet_01v8_hvt w=1u l=0.15u
M466 a_74621_14557# a_74087_14191# a_74526_14557# VDD sky130_fd_pr__pfet_01v8_hvt w=0.42u l=0.15u
M467 macro_core.phase_delay\[3\].delay_cell.Y macro_core.phase_delay\[2\].delay_cell.Y VDD VDD sky130_fd_pr__pfet_01v8_hvt w=1u l=0.15u
M468 VDD a_74291_12283# a_74207_12381# VDD sky130_fd_pr__pfet_01v8_hvt w=0.42u l=0.15u
M469 a_75792_14343# _37_.A1 a_75934_14191# VSS sky130_fd_pr__nfet_01v8 w=0.42u l=0.15u
M470 _56_.Y _84_.Q a_59821_9839# VSS sky130_fd_pr__nfet_01v8 w=0.65u l=0.15u
M471 VSS _86_.CLK a_55595_14191# VSS sky130_fd_pr__nfet_01v8 w=0.42u l=0.15u
M472 VDD _86_.CLK a_62035_12015# VDD sky130_fd_pr__pfet_01v8_hvt w=0.64u l=0.15u
M473 a_53981_2473# a_53911_2375# _44_.Y VDD sky130_fd_pr__pfet_01v8_hvt w=1u l=0.15u
M474 macro_core.phase_delay\[34\].delay_cell.A macro_core.phase_delay\[32\].delay_cell.Y VDD VDD sky130_fd_pr__pfet_01v8_hvt w=1u l=0.15u
M475 macro_core.phase_delay\[64\].delay_cell.A macro_core.phase_delay\[63\].delay_cell.A VDD VDD sky130_fd_pr__pfet_01v8_hvt w=1u l=0.15u
M476 a_67215_50974# a_67167_50886# VDD VDD sky130_fd_pr__pfet_01v8 w=0.42u l=0.15u
M477 a_67215_45974# macro_core.array_and_peripherals.wl_driver_1.WL macro_core.array_and_peripherals.write_driver_4.BL VSS sky130_fd_pr__nfet_01v8 w=0.6u l=0.15u
M478 a_75934_14191# _84_.Q VSS VSS sky130_fd_pr__nfet_01v8 w=0.42u l=0.15u
M479 a_63054_11837# _44_.Y VSS VSS sky130_fd_pr__nfet_01v8 w=0.42u l=0.15u
M480 VDD a_74694_14303# a_74621_14557# VDD sky130_fd_pr__pfet_01v8_hvt w=0.42u l=0.15u
M481 VDD WEb a_54065_2473# VDD sky130_fd_pr__pfet_01v8_hvt w=1u l=0.15u
M482 a_73167_50886# a_73215_50974# VSS VSS sky130_fd_pr__nfet_01v8 w=1.26u l=0.15u
M483 a_77795_12381# a_77013_12015# a_77711_12381# VDD sky130_fd_pr__pfet_01v8_hvt w=0.42u l=0.15u
M484 a_77562_10205# a_77289_9839# a_77477_9839# VDD sky130_fd_pr__pfet_01v8_hvt w=0.42u l=0.15u
M485 a_67167_45886# a_67215_45974# VDD VDD sky130_fd_pr__pfet_01v8 w=0.42u l=0.15u
M486 a_58015_16496# _47_.A0 macro_core.array_and_peripherals.write_driver_2.BLB VSS sky130_fd_pr__nfet_01v8 w=5.04u l=0.15u
M487 VSS macro_core.write_drive.X a_46015_16496# VSS sky130_fd_pr__nfet_01v8 w=5.04u l=0.15u
M488 macro_core.phase_delay\[46\].delay_cell.Y macro_core.phase_delay\[46\].delay_cell.A VSS VSS sky130_fd_pr__nfet_01v8 w=0.65u l=0.15u
M489 VDD macro_core.array_and_peripherals.row_decoder_0.N1 macro_core.qualify_row\[1\].qualify.A VDD sky130_fd_pr__pfet_01v8 w=3u l=0.15u
M490 a_71271_13647# a_70573_13653# a_71014_13621# VSS sky130_fd_pr__special_nfet_01v8 w=0.36u l=0.15u
M491 a_75511_9839# a_75173_10161# VSS VSS sky130_fd_pr__nfet_01v8 w=0.65u l=0.15u
M492 VSS a_79110_14303# a_79068_14191# VSS sky130_fd_pr__nfet_01v8 w=0.42u l=0.15u
M493 a_52301_11769# _44_.Y VDD VDD sky130_fd_pr__pfet_01v8_hvt w=0.42u l=0.15u
M494 VDD _84_.Q _57_.Y VDD sky130_fd_pr__pfet_01v8_hvt w=1u l=0.15u
M495 VDD macro_core.precharge_drive.X macro_core.array_and_peripherals.write_driver_0.BL VDD sky130_fd_pr__pfet_01v8 w=2.52u l=0.15u
M496 a_50314_3423# a_50146_3677# VDD VDD sky130_fd_pr__pfet_01v8_hvt w=0.75u l=0.15u
M497 VDD a_50739_3579# a_50655_3677# VDD sky130_fd_pr__pfet_01v8_hvt w=0.42u l=0.15u
M498 macro_core.phase_delay\[48\].delay_cell.A macro_core.phase_delay\[46\].delay_cell.Y VSS VSS sky130_fd_pr__nfet_01v8 w=0.65u l=0.15u
M499 macro_core.phase_delay\[23\].delay_cell.A macro_core.phase_delay\[21\].delay_cell.Y VDD VDD sky130_fd_pr__pfet_01v8_hvt w=1u l=0.15u
M500 _45_.A0 a_50187_12283# VDD VDD sky130_fd_pr__pfet_01v8_hvt w=1u l=0.15u
M501 a_50314_3423# a_50146_3677# VSS VSS sky130_fd_pr__nfet_01v8 w=0.64u l=0.15u
M502 a_52173_10161# _87_.TE_B VSS VSS sky130_fd_pr__nfet_01v8 w=0.42u l=0.15u
M503 a_55215_55974# macro_core.array_and_peripherals.wl_driver_3.WL macro_core.array_and_peripherals.write_driver_2.BL VSS sky130_fd_pr__nfet_01v8 w=0.6u l=0.15u
M504 a_55215_40974# macro_core.array_and_peripherals.wl_driver_0.WL macro_core.array_and_peripherals.write_driver_2.BL VSS sky130_fd_pr__nfet_01v8 w=0.6u l=0.15u
M505 _53_.Y _34_.Y VDD VDD sky130_fd_pr__pfet_01v8_hvt w=1u l=0.15u
M506 VDD a_63599_14191# macro_core.precharge_drive.X VDD sky130_fd_pr__pfet_01v8_hvt w=1u l=0.15u
M507 a_63054_11510# _44_.Y VDD VDD sky130_fd_pr__pfet_01v8_hvt w=0.42u l=0.15u
M508 a_55167_55886# a_55215_55974# VDD VDD sky130_fd_pr__pfet_01v8 w=0.42u l=0.15u
M509 a_55167_40886# a_55215_40974# VDD VDD sky130_fd_pr__pfet_01v8 w=0.42u l=0.15u
M510 VDD macro_core.evaluation.X macro_core.array_and_peripherals.row_decoder_0.N2 VDD sky130_fd_pr__pfet_01v8 w=1.25u l=0.15u
M511 a_74441_14191# _81_.D VDD VDD sky130_fd_pr__pfet_01v8_hvt w=0.42u l=0.15u
M512 a_48861_13653# a_48695_13653# VSS VSS sky130_fd_pr__nfet_01v8 w=0.42u l=0.15u
M513 VDD a_49727_13621# a_49643_13647# VDD sky130_fd_pr__pfet_01v8_hvt w=0.42u l=0.15u
M514 macro_core.phase_delay\[73\].delay_cell.Y macro_core.phase_delay\[72\].delay_cell.Y VDD VDD sky130_fd_pr__pfet_01v8_hvt w=1u l=0.15u
M515 VSS macro_core.write_drive.X a_62415_16496# VSS sky130_fd_pr__nfet_01v8 w=5.04u l=0.15u
M516 a_74415_16496# macro_core.data_complement\[5\].complement.Y macro_core.array_and_peripherals.write_driver_5.BL VSS sky130_fd_pr__nfet_01v8 w=5.04u l=0.15u
M517 VDD _86_.CLK a_58539_14191# VDD sky130_fd_pr__pfet_01v8_hvt w=0.64u l=0.15u
M518 a_71836_14343# _92_.A a_71978_14518# VDD sky130_fd_pr__pfet_01v8_hvt w=0.42u l=0.15u
M519 VSS a_76221_14165# a_76155_14191# VSS sky130_fd_pr__nfet_01v8 w=0.42u l=0.15u
M520 a_71401_12337# _54_.Y VDD VDD sky130_fd_pr__pfet_01v8_hvt w=0.64u l=0.15u
M521 a_74123_12381# a_73425_12015# a_73866_12127# VSS sky130_fd_pr__special_nfet_01v8 w=0.36u l=0.15u
M522 VDD macro_core.evaluation.X a_12663_36833# VDD sky130_fd_pr__pfet_01v8_hvt w=0.42u l=0.15u
M523 VDD _37_.A1 macro_core.array_and_peripherals.sense_amp_6.SA_OUTB VDD sky130_fd_pr__pfet_01v8 w=1.89u l=0.15u
M524 VSS a_64611_14191# macro_core.sense_drive.X VSS sky130_fd_pr__nfet_01v8 w=0.65u l=0.15u
M525 VSS a_51872_11703# _45_.X VSS sky130_fd_pr__nfet_01v8 w=0.65u l=0.15u
M526 VSS macro_core.phase_delay\[40\].delay_cell.A a_61842_14191# VSS sky130_fd_pr__nfet_01v8 w=0.65u l=0.15u
M527 DATA4 a_66543_12015# a_66899_12265# VDD sky130_fd_pr__pfet_01v8_hvt w=1u l=0.15u
M528 VDD a_72449_11989# a_72479_12342# VDD sky130_fd_pr__pfet_01v8_hvt w=0.42u l=0.15u
M529 a_63275_11837# _48_.A0 a_62912_11703# VSS sky130_fd_pr__nfet_01v8 w=0.42u l=0.15u
M530 VDD _94_.A a_75007_9839# VDD sky130_fd_pr__pfet_01v8_hvt w=0.64u l=0.15u
M531 VDD _84_.Q _87_.TE_B VDD sky130_fd_pr__pfet_01v8_hvt w=1u l=0.15u
M532 a_61215_45974# a_61167_45886# VSS VSS sky130_fd_pr__nfet_01v8 w=1.26u l=0.15u
M533 VSS macro_core.write_drive.X a_49227_20916# VSS sky130_fd_pr__nfet_01v8 w=0.84u l=0.15u
M534 VDD a_74951_14557# a_75119_14459# VDD sky130_fd_pr__pfet_01v8_hvt w=1u l=0.15u
M535 a_67683_13647# a_66819_13653# a_67426_13621# VDD sky130_fd_pr__pfet_01v8_hvt w=0.42u l=0.15u
M536 VSS macro_core.release_phase.X a_64836_13353# VSS sky130_fd_pr__nfet_01v8 w=0.42u l=0.15u
M537 VSS _86_.CLK a_62035_12015# VSS sky130_fd_pr__nfet_01v8 w=0.42u l=0.15u
M538 a_62912_11703# _48_.A0 a_63054_11510# VDD sky130_fd_pr__pfet_01v8_hvt w=0.42u l=0.15u
M539 a_43167_45886# a_43215_45974# VSS VSS sky130_fd_pr__nfet_01v8 w=1.26u l=0.15u
M540 a_52637_14191# _46_.X VSS VSS sky130_fd_pr__nfet_01v8 w=0.42u l=0.15u
M541 a_67353_13647# a_66819_13653# a_67258_13647# VDD sky130_fd_pr__pfet_01v8_hvt w=0.42u l=0.15u
M542 a_76436_9527# _52_.A0 a_76578_9334# VDD sky130_fd_pr__pfet_01v8_hvt w=0.42u l=0.15u
M543 a_43215_50974# macro_core.array_and_peripherals.wl_driver_2.WL macro_core.array_and_peripherals.write_driver_0.BL VSS sky130_fd_pr__nfet_01v8 w=0.6u l=0.15u
M544 a_49134_13647# a_48695_13653# a_49049_13647# VSS sky130_fd_pr__special_nfet_01v8 w=0.36u l=0.15u
M545 a_49559_13647# a_48861_13653# a_49302_13621# VSS sky130_fd_pr__special_nfet_01v8 w=0.36u l=0.15u
M546 a_79167_45886# macro_core.array_and_peripherals.wl_driver_1.WL macro_core.array_and_peripherals.write_driver_6.BLB VSS sky130_fd_pr__nfet_01v8 w=0.6u l=0.15u
M547 VSS a_59403_14557# a_59571_14459# VSS sky130_fd_pr__nfet_01v8 w=0.65u l=0.15u
M548 VSS macro_core.sense_drive.X a_73615_26902# VSS sky130_fd_pr__nfet_01v8 w=0.98u l=0.15u
M549 VSS a_77987_10205# a_78155_10107# VSS sky130_fd_pr__nfet_01v8 w=0.65u l=0.15u
M550 a_43167_50886# a_43215_50974# VDD VDD sky130_fd_pr__pfet_01v8 w=0.42u l=0.15u
M551 VDD a_55227_20916# a_56027_20496# VDD sky130_fd_pr__pfet_01v8 w=5.04u l=0.15u
M552 a_66709_12337# _55_.Y VDD VDD sky130_fd_pr__pfet_01v8_hvt w=0.64u l=0.15u
M553 _50_.A0 a_74291_12283# VDD VDD sky130_fd_pr__pfet_01v8_hvt w=1u l=0.15u
M554 VDD a_67426_13621# a_67353_13647# VDD sky130_fd_pr__pfet_01v8_hvt w=0.42u l=0.15u
M555 a_52269_3311# ADDR0 VDD VDD sky130_fd_pr__pfet_01v8_hvt w=0.42u l=0.15u
M556 macro_core.phase_delay\[44\].delay_cell.A macro_core.phase_delay\[43\].delay_cell.A VDD VDD sky130_fd_pr__pfet_01v8_hvt w=1u l=0.15u
M557 VDD macro_core.phase_delay\[0\].delay_cell.A _63_.Y VDD sky130_fd_pr__pfet_01v8_hvt w=0.84u l=0.15u
M558 a_73698_12381# a_73259_12015# a_73613_12015# VSS sky130_fd_pr__special_nfet_01v8 w=0.36u l=0.15u
M559 a_55006_11445# a_54838_11471# VDD VDD sky130_fd_pr__pfet_01v8_hvt w=0.75u l=0.15u
M560 a_68432_11703# DATA4 a_68574_11837# VSS sky130_fd_pr__nfet_01v8 w=0.42u l=0.15u
M561 macro_core.array_and_peripherals.row_decoder_0.EVAL_GND macro_core.array_and_peripherals.row_decoder_0.A0B macro_core.array_and_peripherals.row_decoder_0.net3 VSS sky130_fd_pr__nfet_01v8 w=2u l=0.15u
M562 VSS a_56717_13945# a_56651_14013# VSS sky130_fd_pr__nfet_01v8 w=0.42u l=0.15u
M563 VSS a_63599_14191# macro_core.precharge_drive.X VSS sky130_fd_pr__nfet_01v8 w=0.65u l=0.15u
M564 a_79215_45974# a_79167_45886# VSS VSS sky130_fd_pr__nfet_01v8 w=1.26u l=0.15u
M565 macro_core.array_and_peripherals.write_driver_5.BLB macro_core.precharge_drive.X macro_core.array_and_peripherals.write_driver_5.BL VDD sky130_fd_pr__pfet_01v8 w=2.52u l=0.15u
M566 _34_.Y CSb VSS VSS sky130_fd_pr__nfet_01v8 w=0.65u l=0.15u
M567 VDD a_77987_10205# a_78155_10107# VDD sky130_fd_pr__pfet_01v8_hvt w=1u l=0.15u
M568 _85_.Q a_52947_3579# VSS VSS sky130_fd_pr__nfet_01v8 w=0.65u l=0.15u
M569 a_80027_20496# macro_core.data_complement\[6\].complement.Y macro_core.array_and_peripherals.write_driver_6.BL VDD sky130_fd_pr__pfet_01v8 w=5.04u l=0.15u
M570 macro_core.sense_drive.X a_64611_14191# VDD VDD sky130_fd_pr__pfet_01v8_hvt w=1u l=0.15u
M571 a_58157_12015# _78_.D VSS VSS sky130_fd_pr__nfet_01v8 w=0.42u l=0.15u
M572 macro_core.phase_delay\[38\].delay_cell.Y macro_core.phase_delay\[37\].delay_cell.Y VSS VSS sky130_fd_pr__nfet_01v8 w=0.65u l=0.15u
M573 a_76578_9661# _44_.Y VSS VSS sky130_fd_pr__nfet_01v8 w=0.42u l=0.15u
M574 a_85615_26902# macro_core.array_and_peripherals.sense_amp_7.SA_OUTB _36_.A1 VSS sky130_fd_pr__nfet_01v8 w=0.98u l=0.15u
M575 a_53231_14557# a_52449_14191# a_53147_14557# VDD sky130_fd_pr__pfet_01v8_hvt w=0.42u l=0.15u
M576 VDD macro_core.phase_delay\[40\].delay_cell.A a_61642_14191# VDD sky130_fd_pr__pfet_01v8_hvt w=1u l=0.15u
M577 a_70573_13653# a_70407_13653# VDD VDD sky130_fd_pr__pfet_01v8_hvt w=0.64u l=0.15u
M578 _57_.Y _34_.Y VDD VDD sky130_fd_pr__pfet_01v8_hvt w=1u l=0.15u
M579 a_50011_10205# a_49229_9839# a_49927_10205# VDD sky130_fd_pr__pfet_01v8_hvt w=0.42u l=0.15u
M580 VDD a_50019_12381# a_50187_12283# VDD sky130_fd_pr__pfet_01v8_hvt w=1u l=0.15u
M581 macro_core.phase_delay\[70\].delay_cell.Y macro_core.phase_delay\[70\].delay_cell.A VDD VDD sky130_fd_pr__pfet_01v8_hvt w=1u l=0.15u
M582 a_77201_12015# _82_.D VSS VSS sky130_fd_pr__nfet_01v8 w=0.42u l=0.15u
M583 a_58134_9269# a_57966_9295# VSS VSS sky130_fd_pr__nfet_01v8 w=0.64u l=0.15u
M584 VSS macro_core.qualify_row\[1\].qualify.X a_36227_46432# VSS sky130_fd_pr__nfet_01v8 w=1.68u l=0.15u
M585 VDD _33_.Y a_49063_9839# VDD sky130_fd_pr__pfet_01v8_hvt w=0.64u l=0.15u
M586 a_67215_55974# a_67167_55886# VSS VSS sky130_fd_pr__nfet_01v8 w=1.26u l=0.15u
M587 a_67215_40974# a_67167_40886# VSS VSS sky130_fd_pr__nfet_01v8 w=1.26u l=0.15u
M588 a_15233_35745# macro_core.qualify_row\[3\].qualify.A a_15147_35745# VSS sky130_fd_pr__nfet_01v8 w=0.42u l=0.15u
M589 VDD macro_core.precharge_drive.X macro_core.array_and_peripherals.write_driver_6.BLB VDD sky130_fd_pr__pfet_01v8 w=2.52u l=0.15u
M590 VSS _60_.Y a_48695_13653# VSS sky130_fd_pr__nfet_01v8 w=0.42u l=0.15u
M591 VSS _92_.A a_71235_12015# VSS sky130_fd_pr__nfet_01v8 w=0.42u l=0.15u
M592 a_49167_40886# a_49215_40974# VSS VSS sky130_fd_pr__nfet_01v8 w=1.26u l=0.15u
M593 macro_core.array_and_peripherals.row_decoder_0.EVAL_GND macro_core.array_and_peripherals.row_decoder_0.A0T macro_core.array_and_peripherals.row_decoder_0.net2 VSS sky130_fd_pr__nfet_01v8 w=2u l=0.15u
M594 VDD _92_.A a_71235_12015# VDD sky130_fd_pr__pfet_01v8_hvt w=0.64u l=0.15u
M595 a_49873_3311# a_49707_3311# VSS VSS sky130_fd_pr__nfet_01v8 w=0.42u l=0.15u
M596 a_49167_55886# a_49215_55974# VSS VSS sky130_fd_pr__nfet_01v8 w=1.26u l=0.15u
M597 VDD macro_core.qualify_row\[1\].qualify.X a_36227_46432# VDD sky130_fd_pr__pfet_01v8 w=1.68u l=0.15u
M598 a_12663_36833# macro_core.qualify_row\[1\].qualify.A VDD VDD sky130_fd_pr__pfet_01v8_hvt w=0.42u l=0.15u
M599 macro_core.qualify_row\[1\].qualify.X a_12663_36833# VDD VDD sky130_fd_pr__pfet_01v8_hvt w=1u l=0.15u
M600 VDD macro_core.evaluation.X a_15147_35745# VDD sky130_fd_pr__pfet_01v8_hvt w=0.42u l=0.15u
M601 a_57693_9301# a_57527_9301# VDD VDD sky130_fd_pr__pfet_01v8_hvt w=0.64u l=0.15u
M602 macro_core.phase_delay\[43\].delay_cell.A macro_core.phase_delay\[42\].delay_cell.A VSS VSS sky130_fd_pr__nfet_01v8 w=0.65u l=0.15u
M603 a_85167_55886# macro_core.array_and_peripherals.wl_driver_3.WL macro_core.array_and_peripherals.write_driver_7.BLB VSS sky130_fd_pr__nfet_01v8 w=0.6u l=0.15u
M604 a_85167_40886# macro_core.array_and_peripherals.wl_driver_0.WL macro_core.array_and_peripherals.write_driver_7.BLB VSS sky130_fd_pr__nfet_01v8 w=0.6u l=0.15u
M605 a_76221_14165# _84_.Q VSS VSS sky130_fd_pr__nfet_01v8 w=0.42u l=0.15u
M606 a_49927_10205# a_49229_9839# a_49670_9951# VSS sky130_fd_pr__special_nfet_01v8 w=0.36u l=0.15u
M607 macro_core.phase_delay\[21\].delay_cell.A macro_core.phase_delay\[19\].delay_cell.Y VDD VDD sky130_fd_pr__pfet_01v8_hvt w=1u l=0.15u
M608 a_60331_10703# a_59993_10383# VSS VSS sky130_fd_pr__nfet_01v8 w=0.65u l=0.15u
M609 VSS a_68861_11769# a_68795_11837# VSS sky130_fd_pr__nfet_01v8 w=0.42u l=0.15u
M610 VDD a_85227_20916# a_87627_20496# VDD sky130_fd_pr__pfet_01v8 w=5.04u l=0.15u
M611 a_64836_13353# macro_core.phase_delay\[79\].delay_cell.Y VSS VSS sky130_fd_pr__nfet_01v8 w=0.42u l=0.15u
M612 macro_core.phase_delay\[53\].delay_cell.Y macro_core.phase_delay\[53\].delay_cell.A VSS VSS sky130_fd_pr__nfet_01v8 w=0.65u l=0.15u
M613 a_75627_20496# _50_.A0 macro_core.array_and_peripherals.write_driver_5.BLB VDD sky130_fd_pr__pfet_01v8 w=5.04u l=0.15u
M614 VSS a_58134_9269# a_58092_9673# VSS sky130_fd_pr__nfet_01v8 w=0.42u l=0.15u
M615 VSS macro_core.evaluation.X a_15233_37067# VSS sky130_fd_pr__nfet_01v8 w=0.42u l=0.15u
M616 VDD macro_core.write_drive.X a_61227_20916# VDD sky130_fd_pr__pfet_01v8 w=0.84u l=0.15u
M617 VSS _89_.A a_55687_10383# VSS sky130_fd_pr__nfet_01v8 w=0.42u l=0.15u
M618 a_85215_45974# a_85167_45886# VDD VDD sky130_fd_pr__pfet_01v8 w=0.42u l=0.15u
M619 VSS _85_.Q macro_core.array_and_peripherals.row_decoder_0.A0B VSS sky130_fd_pr__nfet_01v8 w=0.84u l=0.15u
M620 a_72265_14165# _84_.Q VSS VSS sky130_fd_pr__nfet_01v8 w=0.42u l=0.15u
M621 macro_core.phase_delay\[1\].delay_cell.Y macro_core.phase_delay\[1\].delay_cell.A VSS VSS sky130_fd_pr__nfet_01v8 w=0.65u l=0.15u
M622 a_60183_10383# _56_.Y VDD VDD sky130_fd_pr__pfet_01v8_hvt w=1u l=0.15u
M623 VDD _86_.CLK _61_.Y VDD sky130_fd_pr__pfet_01v8_hvt w=0.84u l=0.15u
M624 a_49229_9839# a_49063_9839# VSS VSS sky130_fd_pr__nfet_01v8 w=0.42u l=0.15u
M625 a_55215_50974# a_55167_50886# VSS VSS sky130_fd_pr__nfet_01v8 w=1.26u l=0.15u
M626 VDD a_49940_14343# _76_.D VDD sky130_fd_pr__pfet_01v8_hvt w=1u l=0.15u
M627 a_62642_12127# a_62474_12381# VSS VSS sky130_fd_pr__nfet_01v8 w=0.64u l=0.15u
M628 macro_core.phase_delay\[19\].delay_cell.Y macro_core.phase_delay\[18\].delay_cell.Y VSS VSS sky130_fd_pr__nfet_01v8 w=0.65u l=0.15u
M629 macro_core.phase_delay\[62\].delay_cell.A macro_core.phase_delay\[61\].delay_cell.A VSS VSS sky130_fd_pr__nfet_01v8 w=0.65u l=0.15u
M630 a_58134_9269# a_57966_9295# VDD VDD sky130_fd_pr__pfet_01v8_hvt w=0.75u l=0.15u
M631 a_73167_50886# macro_core.array_and_peripherals.wl_driver_2.WL macro_core.array_and_peripherals.write_driver_5.BLB VSS sky130_fd_pr__nfet_01v8 w=0.6u l=0.15u
M632 _63_.Y macro_core.phase_delay\[0\].delay_cell.A VDD VDD sky130_fd_pr__pfet_01v8_hvt w=0.84u l=0.15u
M633 macro_core.phase_delay\[66\].delay_cell.Y macro_core.phase_delay\[65\].delay_cell.Y VDD VDD sky130_fd_pr__pfet_01v8_hvt w=1u l=0.15u
M634 a_64611_14191# _84_.Q VDD VDD sky130_fd_pr__pfet_01v8_hvt w=1u l=0.15u
M635 a_67838_14518# _84_.Q VDD VDD sky130_fd_pr__pfet_01v8_hvt w=0.42u l=0.15u
M636 a_62912_11703# DATA3 a_63054_11837# VSS sky130_fd_pr__nfet_01v8 w=0.42u l=0.15u
M637 macro_core.phase_delay\[17\].delay_cell.Y macro_core.phase_delay\[16\].delay_cell.Y VDD VDD sky130_fd_pr__pfet_01v8_hvt w=1u l=0.15u
M638 VDD a_59403_14557# a_59571_14459# VDD sky130_fd_pr__pfet_01v8_hvt w=1u l=0.15u
M639 a_79110_14303# a_78942_14557# VDD VDD sky130_fd_pr__pfet_01v8_hvt w=0.75u l=0.15u
M640 a_68891_11510# DATA4 a_68432_11703# VDD sky130_fd_pr__pfet_01v8_hvt w=0.42u l=0.15u
M641 VDD macro_core.evaluation.X macro_core.array_and_peripherals.row_decoder_0.N3 VDD sky130_fd_pr__pfet_01v8 w=1.25u l=0.15u
M642 a_50145_12015# a_49155_12015# a_50019_12381# VSS sky130_fd_pr__special_nfet_01v8 w=0.36u l=0.15u
M643 a_73215_40974# a_73167_40886# VDD VDD sky130_fd_pr__pfet_01v8 w=0.42u l=0.15u
M644 _91_.A a_67851_13621# VSS VSS sky130_fd_pr__nfet_01v8 w=0.65u l=0.15u
M645 _91_.A a_67851_13621# VDD VDD sky130_fd_pr__pfet_01v8_hvt w=1u l=0.15u
M646 a_54964_11849# a_54565_11477# a_54838_11471# VSS sky130_fd_pr__special_nfet_01v8 w=0.36u l=0.15u
M647 a_52363_10089# _87_.TE_B VDD VDD sky130_fd_pr__pfet_01v8_hvt w=1u l=0.15u
M648 a_73215_55974# a_73167_55886# VDD VDD sky130_fd_pr__pfet_01v8 w=0.42u l=0.15u
M649 VDD macro_core.write_drive.X a_79227_20916# VDD sky130_fd_pr__pfet_01v8 w=0.84u l=0.15u
M650 macro_core.phase_delay\[41\].delay_cell.A macro_core.phase_delay\[40\].delay_cell.A VSS VSS sky130_fd_pr__nfet_01v8 w=0.65u l=0.15u
M651 a_53147_14557# a_52283_14191# a_52890_14303# VDD sky130_fd_pr__pfet_01v8_hvt w=0.42u l=0.15u
M652 VDD _64_.Y a_70407_13653# VDD sky130_fd_pr__pfet_01v8_hvt w=0.64u l=0.15u
M653 VDD a_58391_9295# a_58559_9269# VDD sky130_fd_pr__pfet_01v8_hvt w=1u l=0.15u
M654 macro_core.phase_delay\[28\].delay_cell.A macro_core.phase_delay\[26\].delay_cell.Y VSS VSS sky130_fd_pr__nfet_01v8 w=0.65u l=0.15u
M655 macro_core.phase_delay\[78\].delay_cell.Y macro_core.phase_delay\[77\].delay_cell.Y VDD VDD sky130_fd_pr__pfet_01v8_hvt w=1u l=0.15u
M656 _64_.Y macro_core.phase_delay\[0\].delay_cell.A VDD VDD sky130_fd_pr__pfet_01v8_hvt w=0.84u l=0.15u
M657 a_71397_14025# a_70407_13653# a_71271_13647# VSS sky130_fd_pr__special_nfet_01v8 w=0.36u l=0.15u
M658 macro_core.phase_delay\[74\].delay_cell.Y macro_core.phase_delay\[73\].delay_cell.Y VDD VDD sky130_fd_pr__pfet_01v8_hvt w=1u l=0.15u
M659 a_49927_10205# a_49063_9839# a_49670_9951# VDD sky130_fd_pr__pfet_01v8_hvt w=0.42u l=0.15u
M660 a_49597_10205# a_49063_9839# a_49502_10205# VDD sky130_fd_pr__pfet_01v8_hvt w=0.42u l=0.15u
M661 VDD _43_.A1 macro_core.array_and_peripherals.sense_amp_0.SA_OUTB VDD sky130_fd_pr__pfet_01v8 w=1.89u l=0.15u
M662 VDD macro_core.array_and_peripherals.sense_amp_2.SA_OUTB _41_.A1 VDD sky130_fd_pr__pfet_01v8 w=1.89u l=0.15u
M663 a_52081_12337# _58_.Y VSS VSS sky130_fd_pr__nfet_01v8 w=0.42u l=0.15u
M664 a_52863_3677# a_52081_3311# a_52779_3677# VDD sky130_fd_pr__pfet_01v8_hvt w=0.42u l=0.15u
M665 a_57966_9295# a_57527_9301# a_57881_9295# VSS sky130_fd_pr__special_nfet_01v8 w=0.36u l=0.15u
M666 a_52271_12265# _58_.Y VDD VDD sky130_fd_pr__pfet_01v8_hvt w=1u l=0.15u
M667 a_75547_12265# _53_.Y VDD VDD sky130_fd_pr__pfet_01v8_hvt w=1u l=0.15u
M668 VSS a_71439_13621# a_71397_14025# VSS sky130_fd_pr__nfet_01v8 w=0.42u l=0.15u
M669 DATA5 a_71235_12015# a_71591_12265# VDD sky130_fd_pr__pfet_01v8_hvt w=1u l=0.15u
M670 a_52890_14303# a_52722_14557# VSS VSS sky130_fd_pr__nfet_01v8 w=0.64u l=0.15u
M671 a_68155_14518# _39_.A1 a_67696_14343# VDD sky130_fd_pr__pfet_01v8_hvt w=0.42u l=0.15u
M672 a_61215_50974# a_61167_50886# VDD VDD sky130_fd_pr__pfet_01v8 w=0.42u l=0.15u
M673 a_85615_26902# _36_.A1 macro_core.array_and_peripherals.sense_amp_7.SA_OUTB VSS sky130_fd_pr__nfet_01v8 w=0.98u l=0.15u
M674 a_52722_14557# a_52283_14191# a_52637_14191# VSS sky130_fd_pr__special_nfet_01v8 w=0.36u l=0.15u
M675 a_74441_14191# _81_.D VSS VSS sky130_fd_pr__nfet_01v8 w=0.42u l=0.15u
M676 VSS a_69082_12127# a_69040_12015# VSS sky130_fd_pr__nfet_01v8 w=0.42u l=0.15u
M677 macro_core.phase_delay\[18\].delay_cell.Y macro_core.phase_delay\[17\].delay_cell.Y VSS VSS sky130_fd_pr__nfet_01v8 w=0.65u l=0.15u
M678 a_61215_45974# macro_core.array_and_peripherals.wl_driver_1.WL macro_core.array_and_peripherals.write_driver_3.BL VSS sky130_fd_pr__nfet_01v8 w=0.6u l=0.15u
M679 macro_core.array_and_peripherals.write_driver_5.BLB macro_core.sense_drive.X macro_core.array_and_peripherals.sense_amp_5.SA_OUTB VDD sky130_fd_pr__pfet_01v8 w=2u l=0.15u
M680 _36_.A1 macro_core.sense_drive.X macro_core.array_and_peripherals.write_driver_7.BL VDD sky130_fd_pr__pfet_01v8 w=2u l=0.15u
M681 a_43167_45886# macro_core.array_and_peripherals.wl_driver_1.WL macro_core.array_and_peripherals.write_driver_0.BLB VSS sky130_fd_pr__nfet_01v8 w=0.6u l=0.15u
M682 VSS macro_core.phase_delay\[0\].delay_cell.A _64_.Y VSS sky130_fd_pr__nfet_01v8 w=0.42u l=0.15u
M683 a_58391_9295# a_57527_9301# a_58134_9269# VDD sky130_fd_pr__pfet_01v8_hvt w=0.42u l=0.15u
M684 VDD clkbuf_0_CLK.X a_66819_10383# VDD sky130_fd_pr__pfet_01v8_hvt w=1u l=0.15u
M685 VDD a_79535_14459# a_79451_14557# VDD sky130_fd_pr__pfet_01v8_hvt w=0.42u l=0.15u
M686 macro_core.phase_delay\[61\].delay_cell.A macro_core.phase_delay\[59\].delay_cell.Y VDD VDD sky130_fd_pr__pfet_01v8_hvt w=1u l=0.15u
M687 VSS a_63341_11769# a_63275_11837# VSS sky130_fd_pr__nfet_01v8 w=0.42u l=0.15u
M688 a_61167_45886# a_61215_45974# VDD VDD sky130_fd_pr__pfet_01v8 w=0.42u l=0.15u
M689 a_52015_16496# _46_.A0 macro_core.array_and_peripherals.write_driver_1.BLB VSS sky130_fd_pr__nfet_01v8 w=5.04u l=0.15u
M690 a_58242_12381# a_57969_12015# a_58157_12015# VDD sky130_fd_pr__pfet_01v8_hvt w=0.42u l=0.15u
M691 a_74249_12015# a_73259_12015# a_74123_12381# VSS sky130_fd_pr__special_nfet_01v8 w=0.36u l=0.15u
M692 a_55000_12791# _41_.A1 a_55142_12925# VSS sky130_fd_pr__nfet_01v8 w=0.42u l=0.15u
M693 a_55459_12598# _41_.A1 a_55000_12791# VDD sky130_fd_pr__pfet_01v8_hvt w=0.42u l=0.15u
M694 _75_.Q a_50095_10107# VDD VDD sky130_fd_pr__pfet_01v8_hvt w=1u l=0.15u
M695 a_52354_3677# a_51915_3311# a_52269_3311# VSS sky130_fd_pr__special_nfet_01v8 w=0.36u l=0.15u
M696 VSS _75_.Q a_52007_9839# VSS sky130_fd_pr__nfet_01v8 w=0.42u l=0.15u
M697 DATA2 a_55687_10383# a_56043_10383# VDD sky130_fd_pr__pfet_01v8_hvt w=1u l=0.15u
M698 VDD a_68861_11769# a_68891_11510# VDD sky130_fd_pr__pfet_01v8_hvt w=0.42u l=0.15u
M699 _90_.A a_58835_12283# VDD VDD sky130_fd_pr__pfet_01v8_hvt w=1u l=0.15u
M700 DATA7 a_75007_9839# a_75511_9839# VSS sky130_fd_pr__nfet_01v8 w=0.65u l=0.15u
M701 a_49215_55974# macro_core.array_and_peripherals.wl_driver_3.WL macro_core.array_and_peripherals.write_driver_1.BL VSS sky130_fd_pr__nfet_01v8 w=0.6u l=0.15u
M702 a_49215_40974# macro_core.array_and_peripherals.wl_driver_0.WL macro_core.array_and_peripherals.write_driver_1.BL VSS sky130_fd_pr__nfet_01v8 w=0.6u l=0.15u
M703 VSS _86_.CLK _62_.Y VSS sky130_fd_pr__nfet_01v8 w=0.42u l=0.15u
M704 VDD _86_.CLK a_49707_3311# VDD sky130_fd_pr__pfet_01v8_hvt w=0.64u l=0.15u
M705 a_69009_12381# a_68475_12015# a_68914_12381# VDD sky130_fd_pr__pfet_01v8_hvt w=0.42u l=0.15u
M706 a_79215_50974# a_79167_50886# VDD VDD sky130_fd_pr__pfet_01v8 w=0.42u l=0.15u
M707 a_58242_12381# a_57803_12015# a_58157_12015# VSS sky130_fd_pr__special_nfet_01v8 w=0.36u l=0.15u
M708 VDD _93_.A a_75191_12015# VDD sky130_fd_pr__pfet_01v8_hvt w=0.64u l=0.15u
M709 VSS _93_.A a_75191_12015# VSS sky130_fd_pr__nfet_01v8 w=0.42u l=0.15u
M710 a_44027_20496# macro_core.data_complement\[0\].complement.Y macro_core.array_and_peripherals.write_driver_0.BL VDD sky130_fd_pr__pfet_01v8 w=5.04u l=0.15u
M711 a_52449_3677# a_51915_3311# a_52354_3677# VDD sky130_fd_pr__pfet_01v8_hvt w=0.42u l=0.15u
M712 a_85167_50886# a_85215_50974# VSS VSS sky130_fd_pr__nfet_01v8 w=1.26u l=0.15u
M713 a_49615_26902# macro_core.array_and_peripherals.sense_amp_1.SA_OUTB _42_.A1 VSS sky130_fd_pr__nfet_01v8 w=0.98u l=0.15u
M714 VDD a_77264_13879# _51_.X VDD sky130_fd_pr__pfet_01v8_hvt w=1u l=0.15u
M715 _94_.A a_77879_12283# VDD VDD sky130_fd_pr__pfet_01v8_hvt w=1u l=0.15u
M716 a_52480_3311# a_52081_3311# a_52354_3677# VSS sky130_fd_pr__special_nfet_01v8 w=0.36u l=0.15u
M717 a_63371_11510# DATA3 a_62912_11703# VDD sky130_fd_pr__pfet_01v8_hvt w=0.42u l=0.15u
M718 a_79167_45886# a_79215_45974# VDD VDD sky130_fd_pr__pfet_01v8 w=0.42u l=0.15u
M719 VDD a_59508_12791# _78_.D VDD sky130_fd_pr__pfet_01v8_hvt w=1u l=0.15u
M720 a_77289_9839# a_77123_9839# VSS VSS sky130_fd_pr__nfet_01v8 w=0.42u l=0.15u
M721 VSS macro_core.write_drive.X a_58015_16496# VSS sky130_fd_pr__nfet_01v8 w=5.04u l=0.15u
M722 a_70015_16496# _49_.A0 macro_core.array_and_peripherals.write_driver_4.BLB VSS sky130_fd_pr__nfet_01v8 w=5.04u l=0.15u
M723 VDD a_75792_14343# _81_.D VDD sky130_fd_pr__pfet_01v8_hvt w=1u l=0.15u
M724 a_54838_11471# a_54565_11477# a_54753_11471# VDD sky130_fd_pr__pfet_01v8_hvt w=0.42u l=0.15u
M725 VSS macro_core.write_drive.X a_43227_20916# VSS sky130_fd_pr__nfet_01v8 w=0.84u l=0.15u
M726 a_77286_12381# a_76847_12015# a_77201_12015# VSS sky130_fd_pr__special_nfet_01v8 w=0.36u l=0.15u
M727 _51_.A0 a_79535_14459# VSS VSS sky130_fd_pr__nfet_01v8 w=0.65u l=0.15u
M728 VDD macro_core.precharge_drive.X macro_core.array_and_peripherals.write_driver_2.BL VDD sky130_fd_pr__pfet_01v8 w=2.52u l=0.15u
M729 a_71014_13621# a_70846_13647# VDD VDD sky130_fd_pr__pfet_01v8_hvt w=0.75u l=0.15u
M730 VDD macro_core.precharge_drive.X macro_core.array_and_peripherals.write_driver_0.BLB VDD sky130_fd_pr__pfet_01v8 w=2.52u l=0.15u
M731 VSS a_55429_12857# a_55363_12925# VSS sky130_fd_pr__nfet_01v8 w=0.42u l=0.15u
M732 macro_core.phase_delay\[71\].delay_cell.Y macro_core.phase_delay\[70\].delay_cell.Y VDD VDD sky130_fd_pr__pfet_01v8_hvt w=1u l=0.15u
M733 a_67215_55974# macro_core.array_and_peripherals.wl_driver_3.WL macro_core.array_and_peripherals.write_driver_4.BL VSS sky130_fd_pr__nfet_01v8 w=0.6u l=0.15u
M734 a_67215_40974# macro_core.array_and_peripherals.wl_driver_0.WL macro_core.array_and_peripherals.write_driver_4.BL VSS sky130_fd_pr__nfet_01v8 w=0.6u l=0.15u
M735 macro_core.precharge_drive.X a_63599_14191# VDD VDD sky130_fd_pr__pfet_01v8_hvt w=1u l=0.15u
M736 VDD a_49227_20916# a_50027_20496# VDD sky130_fd_pr__pfet_01v8 w=5.04u l=0.15u
M737 VSS _86_.CLK a_52283_14191# VSS sky130_fd_pr__nfet_01v8 w=0.42u l=0.15u
M738 a_59146_14303# a_58978_14557# VDD VDD sky130_fd_pr__pfet_01v8_hvt w=0.75u l=0.15u
M739 a_78942_14557# a_78669_14191# a_78857_14191# VDD sky130_fd_pr__pfet_01v8_hvt w=0.42u l=0.15u
M740 a_49509_12015# _45_.X VDD VDD sky130_fd_pr__pfet_01v8_hvt w=0.42u l=0.15u
M741 a_67167_55886# a_67215_55974# VDD VDD sky130_fd_pr__pfet_01v8 w=0.42u l=0.15u
M742 a_67167_40886# a_67215_40974# VDD VDD sky130_fd_pr__pfet_01v8 w=0.42u l=0.15u
M743 VSS macro_core.write_drive.X a_74415_16496# VSS sky130_fd_pr__nfet_01v8 w=5.04u l=0.15u
M744 a_86415_16496# macro_core.data_complement\[7\].complement.Y macro_core.array_and_peripherals.write_driver_7.BL VSS sky130_fd_pr__nfet_01v8 w=5.04u l=0.15u
M745 VDD a_76221_14165# a_76251_14518# VDD sky130_fd_pr__pfet_01v8_hvt w=0.42u l=0.15u
M746 VDD a_74123_12381# a_74291_12283# VDD sky130_fd_pr__pfet_01v8_hvt w=1u l=0.15u
M747 macro_core.phase_delay\[4\].delay_cell.Y macro_core.phase_delay\[3\].delay_cell.Y VDD VDD sky130_fd_pr__pfet_01v8_hvt w=1u l=0.15u
M748 a_59403_14557# a_58705_14191# a_59146_14303# VSS sky130_fd_pr__special_nfet_01v8 w=0.36u l=0.15u
M749 a_49215_45974# a_49167_45886# VDD VDD sky130_fd_pr__pfet_01v8 w=0.42u l=0.15u
M750 a_78368_12167# _36_.A1 a_78510_12015# VSS sky130_fd_pr__nfet_01v8 w=0.42u l=0.15u
M751 a_73215_45974# a_73167_45886# VSS VSS sky130_fd_pr__nfet_01v8 w=1.26u l=0.15u
M752 macro_core.array_and_peripherals.row_decoder_0.net2 macro_core.array_and_peripherals.row_decoder_0.A1B macro_core.array_and_peripherals.row_decoder_0.N1 VSS sky130_fd_pr__nfet_01v8 w=2u l=0.15u
M753 VSS a_64611_14191# macro_core.sense_drive.X VSS sky130_fd_pr__nfet_01v8 w=0.65u l=0.15u
M754 macro_core.phase_delay\[28\].delay_cell.Y macro_core.phase_delay\[28\].delay_cell.A VDD VDD sky130_fd_pr__pfet_01v8_hvt w=1u l=0.15u
M755 a_55167_45886# a_55215_45974# VSS VSS sky130_fd_pr__nfet_01v8 w=1.26u l=0.15u
M756 macro_core.qualify_row\[2\].qualify.X a_14227_36833# VSS VSS sky130_fd_pr__nfet_01v8 w=0.65u l=0.15u
M757 _35_.Y _84_.Q a_74357_9839# VSS sky130_fd_pr__nfet_01v8 w=0.65u l=0.15u
M758 a_52921_10703# _34_.Y VSS VSS sky130_fd_pr__nfet_01v8 w=0.65u l=0.15u
M759 a_55215_50974# macro_core.array_and_peripherals.wl_driver_2.WL macro_core.array_and_peripherals.write_driver_2.BL VSS sky130_fd_pr__nfet_01v8 w=0.6u l=0.15u
M760 VDD _86_.CLK a_49155_12015# VDD sky130_fd_pr__pfet_01v8_hvt w=0.64u l=0.15u
M761 VSS macro_core.sense_drive.X a_85615_26902# VSS sky130_fd_pr__nfet_01v8 w=0.98u l=0.15u
M762 a_52737_11791# _34_.Y VSS VSS sky130_fd_pr__nfet_01v8 w=0.65u l=0.15u
M763 a_55167_50886# a_55215_50974# VDD VDD sky130_fd_pr__pfet_01v8 w=0.42u l=0.15u
M764 VDD a_46949_14455# macro_core.evaluation.X VDD sky130_fd_pr__pfet_01v8_hvt w=1u l=0.15u
M765 VDD a_63341_11769# a_63371_11510# VDD sky130_fd_pr__pfet_01v8_hvt w=0.42u l=0.15u
M766 VDD a_67227_20916# a_68027_20496# VDD sky130_fd_pr__pfet_01v8 w=5.04u l=0.15u
M767 macro_core.write_drive.X a_61642_14191# VSS VSS sky130_fd_pr__nfet_01v8 w=0.65u l=0.15u
M768 a_78731_12015# _94_.A a_78368_12167# VSS sky130_fd_pr__nfet_01v8 w=0.42u l=0.15u
M769 VDD macro_core.phase_delay\[0\].delay_cell.A a_78503_14191# VDD sky130_fd_pr__pfet_01v8_hvt w=0.64u l=0.15u
M770 VDD _84_.Q _58_.Y VDD sky130_fd_pr__pfet_01v8_hvt w=1u l=0.15u
M771 VDD macro_core.qualify_row\[2\].qualify.A macro_core.array_and_peripherals.row_decoder_0.N2 VDD sky130_fd_pr__pfet_01v8 w=0.84u l=0.15u
M772 VDD a_58835_12283# a_58751_12381# VDD sky130_fd_pr__pfet_01v8_hvt w=0.42u l=0.15u
M773 a_61215_55974# a_61167_55886# VSS VSS sky130_fd_pr__nfet_01v8 w=1.26u l=0.15u
M774 a_61215_40974# a_61167_40886# VSS VSS sky130_fd_pr__nfet_01v8 w=1.26u l=0.15u
M775 a_43167_40886# a_43215_40974# VSS VSS sky130_fd_pr__nfet_01v8 w=1.26u l=0.15u
M776 VDD a_50187_12283# a_50103_12381# VDD sky130_fd_pr__pfet_01v8_hvt w=0.42u l=0.15u
M777 a_72020_12167# DATA5 a_72162_12015# VSS sky130_fd_pr__nfet_01v8 w=0.42u l=0.15u
M778 VDD a_77711_12381# a_77879_12283# VDD sky130_fd_pr__pfet_01v8_hvt w=1u l=0.15u
M779 macro_core.phase_delay\[65\].delay_cell.Y macro_core.phase_delay\[64\].delay_cell.Y VDD VDD sky130_fd_pr__pfet_01v8_hvt w=1u l=0.15u
M780 a_43167_55886# a_43215_55974# VSS VSS sky130_fd_pr__nfet_01v8 w=1.26u l=0.15u
M781 macro_core.array_and_peripherals.write_driver_7.BLB macro_core.precharge_drive.X macro_core.array_and_peripherals.write_driver_7.BL VDD sky130_fd_pr__pfet_01v8 w=2.52u l=0.15u
M782 a_79167_55886# macro_core.array_and_peripherals.wl_driver_3.WL macro_core.array_and_peripherals.write_driver_6.BLB VSS sky130_fd_pr__nfet_01v8 w=0.6u l=0.15u
M783 a_79167_40886# macro_core.array_and_peripherals.wl_driver_0.WL macro_core.array_and_peripherals.write_driver_6.BLB VSS sky130_fd_pr__nfet_01v8 w=0.6u l=0.15u
M784 a_67426_13621# a_67258_13647# VSS VSS sky130_fd_pr__nfet_01v8 w=0.64u l=0.15u
M785 macro_core.release_phase.X a_65103_12043# VSS VSS sky130_fd_pr__nfet_01v8 w=0.65u l=0.15u
M786 macro_core.phase_delay\[49\].delay_cell.A macro_core.phase_delay\[48\].delay_cell.A VDD VDD sky130_fd_pr__pfet_01v8_hvt w=1u l=0.15u
M787 macro_core.phase_delay\[56\].delay_cell.Y macro_core.phase_delay\[55\].delay_cell.Y VSS VSS sky130_fd_pr__nfet_01v8 w=0.65u l=0.15u
M788 a_78827_12342# _36_.A1 a_78368_12167# VDD sky130_fd_pr__pfet_01v8_hvt w=0.42u l=0.15u
M789 a_15147_35745# macro_core.qualify_row\[3\].qualify.A VDD VDD sky130_fd_pr__pfet_01v8_hvt w=0.42u l=0.15u
M790 a_69627_20496# _49_.A0 macro_core.array_and_peripherals.write_driver_4.BLB VDD sky130_fd_pr__pfet_01v8 w=5.04u l=0.15u
M791 VDD a_79227_20916# a_81627_20496# VDD sky130_fd_pr__pfet_01v8 w=5.04u l=0.15u
M792 VSS a_79367_14557# a_79535_14459# VSS sky130_fd_pr__nfet_01v8 w=0.65u l=0.15u
M793 a_58705_14191# a_58539_14191# VDD VDD sky130_fd_pr__pfet_01v8_hvt w=0.64u l=0.15u
M794 VSS a_78797_11989# a_78731_12015# VSS sky130_fd_pr__nfet_01v8 w=0.42u l=0.15u
M795 VSS a_58391_9295# a_58559_9269# VSS sky130_fd_pr__nfet_01v8 w=0.65u l=0.15u
M796 a_78113_9839# a_77123_9839# a_77987_10205# VSS sky130_fd_pr__special_nfet_01v8 w=0.36u l=0.15u
M797 VSS a_56202_14303# a_56160_14191# VSS sky130_fd_pr__nfet_01v8 w=0.42u l=0.15u
M798 macro_core.data_complement\[6\].complement.Y _51_.A0 VDD VDD sky130_fd_pr__pfet_01v8_hvt w=1u l=0.15u
M799 a_74526_14557# a_74087_14191# a_74441_14191# VSS sky130_fd_pr__special_nfet_01v8 w=0.36u l=0.15u
M800 a_76895_9334# DATA7 a_76436_9527# VDD sky130_fd_pr__pfet_01v8_hvt w=0.42u l=0.15u
M801 a_69082_12127# a_68914_12381# VDD VDD sky130_fd_pr__pfet_01v8_hvt w=0.75u l=0.15u
M802 a_15233_37067# macro_core.qualify_row\[0\].qualify.A a_15147_37067# VSS sky130_fd_pr__nfet_01v8 w=0.42u l=0.15u
M803 VSS _86_.CLK a_49155_12015# VSS sky130_fd_pr__nfet_01v8 w=0.42u l=0.15u
M804 a_79493_14191# a_78503_14191# a_79367_14557# VSS sky130_fd_pr__special_nfet_01v8 w=0.36u l=0.15u
M805 a_67767_13647# a_66985_13653# a_67683_13647# VDD sky130_fd_pr__pfet_01v8_hvt w=0.42u l=0.15u
M806 VSS a_49762_12127# a_49720_12015# VSS sky130_fd_pr__nfet_01v8 w=0.42u l=0.15u
M807 a_79215_40974# a_79167_40886# VSS VSS sky130_fd_pr__nfet_01v8 w=1.26u l=0.15u
M808 VDD macro_core.qualify_row\[1\].qualify.A macro_core.array_and_peripherals.row_decoder_0.N1 VDD sky130_fd_pr__pfet_01v8 w=0.84u l=0.15u
M809 macro_core.phase_delay\[8\].delay_cell.Y macro_core.phase_delay\[7\].delay_cell.Y VSS VSS sky130_fd_pr__nfet_01v8 w=0.65u l=0.15u
M810 macro_core.phase_delay\[55\].delay_cell.Y macro_core.phase_delay\[54\].delay_cell.Y VSS VSS sky130_fd_pr__nfet_01v8 w=0.65u l=0.15u
M811 a_79215_55974# a_79167_55886# VSS VSS sky130_fd_pr__nfet_01v8 w=1.26u l=0.15u
M812 a_52722_14557# a_52449_14191# a_52637_14191# VDD sky130_fd_pr__pfet_01v8_hvt w=0.42u l=0.15u
M813 macro_core.phase_delay\[2\].delay_cell.Y macro_core.phase_delay\[1\].delay_cell.Y VSS VSS sky130_fd_pr__nfet_01v8 w=0.65u l=0.15u
M814 _83_.Q a_59571_14459# VSS VSS sky130_fd_pr__nfet_01v8 w=0.65u l=0.15u
M815 macro_core.phase_delay\[34\].delay_cell.Y macro_core.phase_delay\[34\].delay_cell.A VDD VDD sky130_fd_pr__pfet_01v8_hvt w=1u l=0.15u
M816 VSS a_76436_9527# _52_.X VSS sky130_fd_pr__nfet_01v8 w=0.65u l=0.15u
M817 macro_core.data_complement\[5\].complement.Y _50_.A0 VSS VSS sky130_fd_pr__nfet_01v8 w=0.65u l=0.15u
M818 a_72479_12342# DATA5 a_72020_12167# VDD sky130_fd_pr__pfet_01v8_hvt w=0.42u l=0.15u
M819 VDD _84_.Q a_61238_14441# VDD sky130_fd_pr__pfet_01v8_hvt w=0.42u l=0.15u
M820 a_70573_13653# a_70407_13653# VSS VSS sky130_fd_pr__nfet_01v8 w=0.42u l=0.15u
M821 VDD a_71439_13621# a_71355_13647# VDD sky130_fd_pr__pfet_01v8_hvt w=0.42u l=0.15u
M822 VDD a_49762_12127# a_49689_12381# VDD sky130_fd_pr__pfet_01v8_hvt w=0.42u l=0.15u
M823 a_87627_20496# _52_.A0 macro_core.array_and_peripherals.write_driver_7.BLB VDD sky130_fd_pr__pfet_01v8 w=5.04u l=0.15u
M824 macro_core.data_complement\[7\].complement.Y _52_.A0 VSS VSS sky130_fd_pr__nfet_01v8 w=0.65u l=0.15u
M825 macro_core.data_complement\[0\].complement.Y _45_.A0 VSS VSS sky130_fd_pr__nfet_01v8 w=0.65u l=0.15u
M826 macro_core.data_complement\[3\].complement.Y _48_.A0 VDD VDD sky130_fd_pr__pfet_01v8_hvt w=1u l=0.15u
M827 a_49260_14025# a_48861_13653# a_49134_13647# VSS sky130_fd_pr__special_nfet_01v8 w=0.36u l=0.15u
M828 VSS a_72449_11989# a_72383_12015# VSS sky130_fd_pr__nfet_01v8 w=0.42u l=0.15u
M829 a_50571_3677# a_49707_3311# a_50314_3423# VDD sky130_fd_pr__pfet_01v8_hvt w=0.42u l=0.15u
M830 a_71413_11791# _34_.Y VSS VSS sky130_fd_pr__nfet_01v8 w=0.65u l=0.15u
M831 macro_core.phase_delay\[77\].delay_cell.Y macro_core.phase_delay\[76\].delay_cell.Y VDD VDD sky130_fd_pr__pfet_01v8_hvt w=1u l=0.15u
M832 VDD macro_core.write_drive.X a_73227_20916# VDD sky130_fd_pr__pfet_01v8 w=0.84u l=0.15u
M833 a_58978_14557# a_58705_14191# a_58893_14191# VDD sky130_fd_pr__pfet_01v8_hvt w=0.42u l=0.15u
M834 a_67173_13647# _79_.D VSS VSS sky130_fd_pr__nfet_01v8 w=0.42u l=0.15u
M835 a_50019_12381# a_49321_12015# a_49762_12127# VSS sky130_fd_pr__special_nfet_01v8 w=0.36u l=0.15u
M836 macro_core.phase_delay\[32\].delay_cell.Y macro_core.phase_delay\[32\].delay_cell.A VSS VSS sky130_fd_pr__nfet_01v8 w=0.65u l=0.15u
M837 VSS macro_core.qualify_row\[3\].qualify.X a_36227_56432# VSS sky130_fd_pr__nfet_01v8 w=1.68u l=0.15u
M838 macro_core.evaluation.X a_46949_14455# VDD VDD sky130_fd_pr__pfet_01v8_hvt w=1u l=0.15u
M839 a_77711_12381# a_77013_12015# a_77454_12127# VSS sky130_fd_pr__special_nfet_01v8 w=0.36u l=0.15u
M840 macro_core.phase_delay\[72\].delay_cell.Y macro_core.phase_delay\[71\].delay_cell.Y VDD VDD sky130_fd_pr__pfet_01v8_hvt w=1u l=0.15u
M841 _52_.A0 a_78155_10107# VDD VDD sky130_fd_pr__pfet_01v8_hvt w=1u l=0.15u
M842 a_67215_50974# a_67167_50886# VSS VSS sky130_fd_pr__nfet_01v8 w=1.26u l=0.15u
M843 VSS a_53315_14459# a_53273_14191# VSS sky130_fd_pr__nfet_01v8 w=0.42u l=0.15u
M844 VSS macro_core.phase_delay\[0\].delay_cell.A _65_.Y VSS sky130_fd_pr__nfet_01v8 w=0.42u l=0.15u
M845 a_49167_50886# a_49215_50974# VSS VSS sky130_fd_pr__nfet_01v8 w=1.26u l=0.15u
M846 macro_core.write_drive.X a_61642_14191# VDD VDD sky130_fd_pr__pfet_01v8_hvt w=1u l=0.15u
M847 VDD a_78797_11989# a_78827_12342# VDD sky130_fd_pr__pfet_01v8_hvt w=0.42u l=0.15u
M848 clkbuf_0_CLK.X a_62863_9295# VSS VSS sky130_fd_pr__nfet_01v8 w=0.42u l=0.15u
M849 VDD macro_core.qualify_row\[3\].qualify.X a_36227_56432# VDD sky130_fd_pr__pfet_01v8 w=1.68u l=0.15u
M850 a_85167_50886# macro_core.array_and_peripherals.wl_driver_2.WL macro_core.array_and_peripherals.write_driver_7.BLB VSS sky130_fd_pr__nfet_01v8 w=0.6u l=0.15u
M851 VDD macro_core.qualify_row\[0\].qualify.X a_36227_41432# VDD sky130_fd_pr__pfet_01v8 w=1.68u l=0.15u
M852 a_73425_12015# a_73259_12015# VDD VDD sky130_fd_pr__pfet_01v8_hvt w=0.64u l=0.15u
M853 a_73824_12015# a_73425_12015# a_73698_12381# VSS sky130_fd_pr__special_nfet_01v8 w=0.36u l=0.15u
M854 VSS a_58559_9269# a_58517_9673# VSS sky130_fd_pr__nfet_01v8 w=0.42u l=0.15u
M855 VSS a_36227_41432# macro_core.array_and_peripherals.wl_driver_0.WL VSS sky130_fd_pr__nfet_01v8 w=5.04u l=0.15u
M856 a_49940_14343# _42_.A1 a_50082_14191# VSS sky130_fd_pr__nfet_01v8 w=0.42u l=0.15u
M857 _37_.A1 macro_core.sense_drive.X macro_core.array_and_peripherals.write_driver_6.BL VDD sky130_fd_pr__pfet_01v8 w=2u l=0.15u
M858 a_79615_26902# _37_.A1 macro_core.array_and_peripherals.sense_amp_6.SA_OUTB VSS sky130_fd_pr__nfet_01v8 w=0.98u l=0.15u
M859 a_54753_11471# _77_.D VDD VDD sky130_fd_pr__pfet_01v8_hvt w=0.42u l=0.15u
M860 a_58410_12127# a_58242_12381# VSS VSS sky130_fd_pr__nfet_01v8 w=0.64u l=0.15u
M861 a_49229_13647# a_48695_13653# a_49134_13647# VDD sky130_fd_pr__pfet_01v8_hvt w=0.42u l=0.15u
M862 a_85215_55974# a_85167_55886# VDD VDD sky130_fd_pr__pfet_01v8 w=0.42u l=0.15u
M863 a_85215_40974# a_85167_40886# VDD VDD sky130_fd_pr__pfet_01v8 w=0.42u l=0.15u
M864 VDD macro_core.phase_delay\[0\].delay_cell.A a_77123_9839# VDD sky130_fd_pr__pfet_01v8_hvt w=0.64u l=0.15u
M865 VSS a_71014_13621# a_70972_14025# VSS sky130_fd_pr__nfet_01v8 w=0.42u l=0.15u
M866 VDD a_58539_10383# _86_.CLK VDD sky130_fd_pr__pfet_01v8_hvt w=1u l=0.15u
M867 a_56034_14557# a_55761_14191# a_55949_14191# VDD sky130_fd_pr__pfet_01v8_hvt w=0.42u l=0.15u
M868 macro_core.phase_delay\[53\].delay_cell.A macro_core.phase_delay\[51\].delay_cell.Y VSS VSS sky130_fd_pr__nfet_01v8 w=0.65u l=0.15u
M869 VDD _41_.A1 macro_core.array_and_peripherals.sense_amp_2.SA_OUTB VDD sky130_fd_pr__pfet_01v8 w=1.89u l=0.15u
M870 VDD macro_core.array_and_peripherals.sense_amp_4.SA_OUTB _39_.A1 VDD sky130_fd_pr__pfet_01v8 w=1.89u l=0.15u
M871 macro_core.data_complement\[1\].complement.Y _46_.A0 VSS VSS sky130_fd_pr__nfet_01v8 w=0.65u l=0.15u
M872 VDD _62_.Y a_57803_12015# VDD sky130_fd_pr__pfet_01v8_hvt w=0.64u l=0.15u
M873 _85_.Q a_52947_3579# VDD VDD sky130_fd_pr__pfet_01v8_hvt w=1u l=0.15u
M874 macro_core.phase_delay\[59\].delay_cell.Y macro_core.phase_delay\[58\].delay_cell.Y VDD VDD sky130_fd_pr__pfet_01v8_hvt w=1u l=0.15u
M875 a_73698_12381# a_73425_12015# a_73613_12015# VDD sky130_fd_pr__pfet_01v8_hvt w=0.42u l=0.15u
M876 macro_core.phase_delay\[37\].delay_cell.Y macro_core.phase_delay\[36\].delay_cell.Y VDD VDD sky130_fd_pr__pfet_01v8_hvt w=1u l=0.15u
M877 a_70846_13647# a_70573_13653# a_70761_13647# VDD sky130_fd_pr__pfet_01v8_hvt w=0.42u l=0.15u
M878 VSS a_53911_2375# _44_.Y VSS sky130_fd_pr__nfet_01v8 w=0.65u l=0.15u
M879 VDD a_49927_10205# a_50095_10107# VDD sky130_fd_pr__pfet_01v8_hvt w=1u l=0.15u
M880 VDD a_79367_14557# a_79535_14459# VDD sky130_fd_pr__pfet_01v8_hvt w=1u l=0.15u
M881 _49_.A0 a_69507_12283# VSS VSS sky130_fd_pr__nfet_01v8 w=0.65u l=0.15u
M882 VDD a_48744_11703# _75_.D VDD sky130_fd_pr__pfet_01v8_hvt w=1u l=0.15u
M883 VSS WEb _44_.Y VSS sky130_fd_pr__nfet_01v8 w=0.65u l=0.15u
M884 macro_core.phase_delay\[70\].delay_cell.A macro_core.phase_delay\[68\].delay_cell.Y VDD VDD sky130_fd_pr__pfet_01v8_hvt w=1u l=0.15u
M885 a_73215_50974# a_73167_50886# VDD VDD sky130_fd_pr__pfet_01v8 w=0.42u l=0.15u
M886 a_73215_45974# macro_core.array_and_peripherals.wl_driver_1.WL macro_core.array_and_peripherals.write_driver_5.BL VSS sky130_fd_pr__nfet_01v8 w=0.6u l=0.15u
M887 VDD macro_core.array_and_peripherals.row_decoder_0.A0B macro_core.array_and_peripherals.row_decoder_0.A0T VDD sky130_fd_pr__pfet_01v8 w=2u l=0.15u
M888 macro_core.array_and_peripherals.write_driver_7.BLB macro_core.sense_drive.X macro_core.array_and_peripherals.sense_amp_7.SA_OUTB VDD sky130_fd_pr__pfet_01v8 w=2u l=0.15u
M889 macro_core.precharge_drive.X a_63599_14191# VSS VSS sky130_fd_pr__nfet_01v8 w=0.65u l=0.15u
M890 a_55167_45886# macro_core.array_and_peripherals.wl_driver_1.WL macro_core.array_and_peripherals.write_driver_2.BLB VSS sky130_fd_pr__nfet_01v8 w=0.6u l=0.15u
M891 a_43615_26902# macro_core.array_and_peripherals.sense_amp_0.SA_OUTB _43_.A1 VSS sky130_fd_pr__nfet_01v8 w=0.98u l=0.15u
M892 VSS a_50369_14165# a_50303_14191# VSS sky130_fd_pr__nfet_01v8 w=0.42u l=0.15u
M893 a_49762_12127# a_49594_12381# VSS VSS sky130_fd_pr__nfet_01v8 w=0.64u l=0.15u
M894 macro_core.phase_delay\[6\].delay_cell.Y macro_core.phase_delay\[5\].delay_cell.Y VDD VDD sky130_fd_pr__pfet_01v8_hvt w=1u l=0.15u
M895 a_73167_45886# a_73215_45974# VDD VDD sky130_fd_pr__pfet_01v8 w=0.42u l=0.15u
M896 VSS _64_.Y a_70407_13653# VSS sky130_fd_pr__nfet_01v8 w=0.42u l=0.15u
M897 a_73425_12015# a_73259_12015# VSS VSS sky130_fd_pr__nfet_01v8 w=0.42u l=0.15u
M898 VSS macro_core.write_drive.X a_52015_16496# VSS sky130_fd_pr__nfet_01v8 w=5.04u l=0.15u
M899 a_64015_16496# _48_.A0 macro_core.array_and_peripherals.write_driver_3.BLB VSS sky130_fd_pr__nfet_01v8 w=5.04u l=0.15u
M900 macro_core.phase_delay\[40\].delay_cell.A macro_core.phase_delay\[38\].delay_cell.Y VDD VDD sky130_fd_pr__pfet_01v8_hvt w=1u l=0.15u
M901 a_52522_3423# a_52354_3677# VSS VSS sky130_fd_pr__nfet_01v8 w=0.64u l=0.15u
M902 macro_core.evaluation.A a_61156_14441# VDD VDD sky130_fd_pr__pfet_01v8_hvt w=1u l=0.15u
M903 a_59529_14191# a_58539_14191# a_59403_14557# VSS sky130_fd_pr__special_nfet_01v8 w=0.36u l=0.15u
M904 VSS clkbuf_0_CLK.X a_66819_10383# VSS sky130_fd_pr__nfet_01v8 w=0.42u l=0.15u
M905 VSS macro_core.array_and_peripherals.row_decoder_0.N0 macro_core.qualify_row\[0\].qualify.A VSS sky130_fd_pr__nfet_01v8 w=2u l=0.15u
M906 VSS a_49302_13621# a_49260_14025# VSS sky130_fd_pr__nfet_01v8 w=0.42u l=0.15u
M907 a_49049_13647# _76_.D VDD VDD sky130_fd_pr__pfet_01v8_hvt w=0.42u l=0.15u
M908 VDD a_59937_12857# a_59967_12598# VDD sky130_fd_pr__pfet_01v8_hvt w=0.42u l=0.15u
M909 _83_.Q a_59571_14459# VDD VDD sky130_fd_pr__pfet_01v8_hvt w=1u l=0.15u
M910 a_57881_9295# _34_.Y VDD VDD sky130_fd_pr__pfet_01v8_hvt w=0.42u l=0.15u
M911 macro_core.phase_delay\[25\].delay_cell.A macro_core.phase_delay\[23\].delay_cell.Y VDD VDD sky130_fd_pr__pfet_01v8_hvt w=1u l=0.15u
M912 a_61215_55974# macro_core.array_and_peripherals.wl_driver_3.WL macro_core.array_and_peripherals.write_driver_3.BL VSS sky130_fd_pr__nfet_01v8 w=0.6u l=0.15u
M913 a_61215_40974# macro_core.array_and_peripherals.wl_driver_0.WL macro_core.array_and_peripherals.write_driver_3.BL VSS sky130_fd_pr__nfet_01v8 w=0.6u l=0.15u
M914 a_52905_3311# a_51915_3311# a_52779_3677# VSS sky130_fd_pr__special_nfet_01v8 w=0.36u l=0.15u
M915 a_43167_55886# macro_core.array_and_peripherals.wl_driver_3.WL macro_core.array_and_peripherals.write_driver_0.BLB VSS sky130_fd_pr__nfet_01v8 w=0.6u l=0.15u
M916 a_43167_40886# macro_core.array_and_peripherals.wl_driver_0.WL macro_core.array_and_peripherals.write_driver_0.BLB VSS sky130_fd_pr__nfet_01v8 w=0.6u l=0.15u
M917 macro_core.phase_delay\[79\].delay_cell.Y macro_core.phase_delay\[78\].delay_cell.Y VSS VSS sky130_fd_pr__nfet_01v8 w=0.65u l=0.15u
M918 macro_core.phase_delay\[26\].delay_cell.A macro_core.phase_delay\[25\].delay_cell.A VSS VSS sky130_fd_pr__nfet_01v8 w=0.65u l=0.15u
M919 a_61167_55886# a_61215_55974# VDD VDD sky130_fd_pr__pfet_01v8 w=0.42u l=0.15u
M920 a_61167_40886# a_61215_40974# VDD VDD sky130_fd_pr__pfet_01v8 w=0.42u l=0.15u
M921 VSS macro_core.evaluation.X macro_core.array_and_peripherals.row_decoder_0.EVAL_GND VSS sky130_fd_pr__nfet_01v8 w=1.5u l=0.15u
M922 VDD a_43227_20916# a_45627_20496# VDD sky130_fd_pr__pfet_01v8 w=5.04u l=0.15u
M923 a_56027_20496# macro_core.data_complement\[2\].complement.Y macro_core.array_and_peripherals.write_driver_2.BL VDD sky130_fd_pr__pfet_01v8 w=5.04u l=0.15u
M924 VSS _62_.Y a_57803_12015# VSS sky130_fd_pr__nfet_01v8 w=0.42u l=0.15u
M925 a_80415_16496# macro_core.data_complement\[6\].complement.Y macro_core.array_and_peripherals.write_driver_6.BL VSS sky130_fd_pr__nfet_01v8 w=5.04u l=0.15u
M926 VDD macro_core.phase_delay\[0\].delay_cell.A _64_.Y VDD sky130_fd_pr__pfet_01v8_hvt w=0.84u l=0.15u
M927 VSS a_52947_3579# a_52905_3311# VSS sky130_fd_pr__nfet_01v8 w=0.42u l=0.15u
M928 a_62389_12015# _48_.X VDD VDD sky130_fd_pr__pfet_01v8_hvt w=0.42u l=0.15u
M929 macro_core.phase_delay\[44\].delay_cell.Y macro_core.phase_delay\[44\].delay_cell.A VDD VDD sky130_fd_pr__pfet_01v8_hvt w=1u l=0.15u
M930 a_56202_14303# a_56034_14557# VDD VDD sky130_fd_pr__pfet_01v8_hvt w=0.75u l=0.15u
M931 VDD _63_.Y a_66819_13653# VDD sky130_fd_pr__pfet_01v8_hvt w=0.64u l=0.15u
M932 VDD _86_.CLK _62_.Y VDD sky130_fd_pr__pfet_01v8_hvt w=0.84u l=0.15u
M933 DATA4 a_66543_12015# a_67047_12015# VSS sky130_fd_pr__nfet_01v8 w=0.65u l=0.15u
M934 a_43215_45974# a_43167_45886# VDD VDD sky130_fd_pr__pfet_01v8 w=0.42u l=0.15u
M935 a_74951_14557# a_74087_14191# a_74694_14303# VDD sky130_fd_pr__pfet_01v8_hvt w=0.42u l=0.15u
M936 a_52511_9839# a_52173_10161# VSS VSS sky130_fd_pr__nfet_01v8 w=0.65u l=0.15u
M937 VSS macro_core.write_drive.X a_55227_20916# VSS sky130_fd_pr__nfet_01v8 w=0.84u l=0.15u
M938 VDD a_52700_13255# _46_.X VDD sky130_fd_pr__pfet_01v8_hvt w=1u l=0.15u
M939 _86_.CLK a_58539_10383# VDD VDD sky130_fd_pr__pfet_01v8_hvt w=1u l=0.15u
M940 a_49215_50974# macro_core.array_and_peripherals.wl_driver_2.WL macro_core.array_and_peripherals.write_driver_1.BL VSS sky130_fd_pr__nfet_01v8 w=0.6u l=0.15u
M941 VDD macro_core.precharge_drive.X macro_core.array_and_peripherals.write_driver_4.BL VDD sky130_fd_pr__pfet_01v8 w=2.52u l=0.15u
M942 VDD macro_core.precharge_drive.X macro_core.array_and_peripherals.write_driver_2.BLB VDD sky130_fd_pr__pfet_01v8 w=2.52u l=0.15u
M943 a_61842_14191# _86_.CLK a_61733_14191# VSS sky130_fd_pr__nfet_01v8 w=0.65u l=0.15u
M944 a_49762_12127# a_49594_12381# VDD VDD sky130_fd_pr__pfet_01v8_hvt w=0.75u l=0.15u
M945 macro_core.phase_delay\[63\].delay_cell.A macro_core.phase_delay\[62\].delay_cell.A VSS VSS sky130_fd_pr__nfet_01v8 w=0.65u l=0.15u
M946 macro_core.phase_delay\[11\].delay_cell.Y macro_core.phase_delay\[10\].delay_cell.Y VSS VSS sky130_fd_pr__nfet_01v8 w=0.65u l=0.15u
M947 VSS macro_core.sense_drive.X a_79615_26902# VSS sky130_fd_pr__nfet_01v8 w=0.98u l=0.15u
M948 macro_core.phase_delay\[16\].delay_cell.Y macro_core.phase_delay\[15\].delay_cell.Y VDD VDD sky130_fd_pr__pfet_01v8_hvt w=1u l=0.15u
M949 VDD a_61227_20916# a_62027_20496# VDD sky130_fd_pr__pfet_01v8 w=5.04u l=0.15u
M950 a_52848_14191# a_52449_14191# a_52722_14557# VSS sky130_fd_pr__special_nfet_01v8 w=0.36u l=0.15u
M951 a_74694_14303# a_74526_14557# VSS VSS sky130_fd_pr__nfet_01v8 w=0.64u l=0.15u
M952 macro_core.phase_delay\[42\].delay_cell.A macro_core.phase_delay\[41\].delay_cell.A VSS VSS sky130_fd_pr__nfet_01v8 w=0.65u l=0.15u
M953 a_79167_40886# a_79215_40974# VDD VDD sky130_fd_pr__pfet_01v8 w=0.42u l=0.15u
M954 VSS a_67696_14343# _79_.D VSS sky130_fd_pr__nfet_01v8 w=0.65u l=0.15u
M955 macro_core.phase_delay\[1\].delay_cell.A macro_core.phase_delay\[0\].delay_cell.A VDD VDD sky130_fd_pr__pfet_01v8_hvt w=1u l=0.15u
M956 a_79167_55886# a_79215_55974# VDD VDD sky130_fd_pr__pfet_01v8 w=0.42u l=0.15u
M957 VSS a_69339_12381# a_69507_12283# VSS sky130_fd_pr__nfet_01v8 w=0.65u l=0.15u
M958 VSS macro_core.write_drive.X a_86415_16496# VSS sky130_fd_pr__nfet_01v8 w=5.04u l=0.15u
M959 a_49107_11837# _75_.Q a_48744_11703# VSS sky130_fd_pr__nfet_01v8 w=0.42u l=0.15u
M960 macro_core.phase_delay\[23\].delay_cell.Y macro_core.phase_delay\[23\].delay_cell.A VSS VSS sky130_fd_pr__nfet_01v8 w=0.65u l=0.15u
M961 VDD macro_core.array_and_peripherals.row_decoder_0.N0 macro_core.qualify_row\[0\].qualify.A VDD sky130_fd_pr__pfet_01v8 w=3u l=0.15u
M962 a_85215_45974# a_85167_45886# VSS VSS sky130_fd_pr__nfet_01v8 w=1.26u l=0.15u
M963 macro_core.array_and_peripherals.write_driver_6.BLB macro_core.precharge_drive.X macro_core.array_and_peripherals.write_driver_6.BL VDD sky130_fd_pr__pfet_01v8 w=2.52u l=0.15u
M964 a_58893_14191# _44_.Y VDD VDD sky130_fd_pr__pfet_01v8_hvt w=0.42u l=0.15u
M965 VDD a_56627_14459# a_56543_14557# VDD sky130_fd_pr__pfet_01v8_hvt w=0.42u l=0.15u
M966 VDD a_55000_12791# _77_.D VDD sky130_fd_pr__pfet_01v8_hvt w=1u l=0.15u
M967 VSS macro_core.phase_delay\[23\].delay_cell.Y a_65189_12043# VSS sky130_fd_pr__nfet_01v8 w=0.42u l=0.15u
M968 a_67215_50974# macro_core.array_and_peripherals.wl_driver_2.WL macro_core.array_and_peripherals.write_driver_4.BL VSS sky130_fd_pr__nfet_01v8 w=0.6u l=0.15u
M969 a_67167_45886# a_67215_45974# VSS VSS sky130_fd_pr__nfet_01v8 w=1.26u l=0.15u
M970 VSS a_75119_14459# a_75077_14191# VSS sky130_fd_pr__nfet_01v8 w=0.42u l=0.15u
M971 a_52081_12337# _58_.Y VDD VDD sky130_fd_pr__pfet_01v8_hvt w=0.64u l=0.15u
M972 a_69465_12015# a_68475_12015# a_69339_12381# VSS sky130_fd_pr__special_nfet_01v8 w=0.36u l=0.15u
M973 macro_core.phase_delay\[35\].delay_cell.Y macro_core.phase_delay\[34\].delay_cell.Y VDD VDD sky130_fd_pr__pfet_01v8_hvt w=1u l=0.15u
M974 a_77477_9839# _52_.X VDD VDD sky130_fd_pr__pfet_01v8_hvt w=0.42u l=0.15u
M975 a_75792_14343# _93_.A a_75934_14518# VDD sky130_fd_pr__pfet_01v8_hvt w=0.42u l=0.15u
M976 a_75357_12337# _53_.Y VDD VDD sky130_fd_pr__pfet_01v8_hvt w=0.64u l=0.15u
M977 macro_core.phase_delay\[34\].delay_cell.A macro_core.phase_delay\[32\].delay_cell.Y VSS VSS sky130_fd_pr__nfet_01v8 w=0.65u l=0.15u
M978 macro_core.phase_delay\[64\].delay_cell.A macro_core.phase_delay\[63\].delay_cell.A VSS VSS sky130_fd_pr__nfet_01v8 w=0.65u l=0.15u
M979 a_67167_50886# a_67215_50974# VDD VDD sky130_fd_pr__pfet_01v8 w=0.42u l=0.15u
M980 _43_.A1 macro_core.sense_drive.X macro_core.array_and_peripherals.write_driver_0.BL VDD sky130_fd_pr__pfet_01v8 w=2u l=0.15u
M981 a_43615_26902# _43_.A1 macro_core.array_and_peripherals.sense_amp_0.SA_OUTB VSS sky130_fd_pr__nfet_01v8 w=0.98u l=0.15u
M982 a_78797_11989# _84_.Q VDD VDD sky130_fd_pr__pfet_01v8_hvt w=0.42u l=0.15u
M983 a_50082_14518# _84_.Q VDD VDD sky130_fd_pr__pfet_01v8_hvt w=0.42u l=0.15u
M984 a_58368_12015# a_57969_12015# a_58242_12381# VSS sky130_fd_pr__special_nfet_01v8 w=0.36u l=0.15u
M985 a_49215_55974# a_49167_55886# VDD VDD sky130_fd_pr__pfet_01v8 w=0.42u l=0.15u
M986 a_49215_40974# a_49167_40886# VDD VDD sky130_fd_pr__pfet_01v8 w=0.42u l=0.15u
M987 a_61733_14191# _83_.Q a_61642_14191# VSS sky130_fd_pr__nfet_01v8 w=0.65u l=0.15u
M988 a_77837_12015# a_76847_12015# a_77711_12381# VSS sky130_fd_pr__special_nfet_01v8 w=0.36u l=0.15u
M989 a_78797_11989# _84_.Q VSS VSS sky130_fd_pr__nfet_01v8 w=0.42u l=0.15u
M990 macro_core.phase_delay\[12\].delay_cell.Y macro_core.phase_delay\[11\].delay_cell.Y VDD VDD sky130_fd_pr__pfet_01v8_hvt w=1u l=0.15u
M991 a_68861_11769# _44_.Y VSS VSS sky130_fd_pr__nfet_01v8 w=0.42u l=0.15u
M992 a_73215_40974# a_73167_40886# VSS VSS sky130_fd_pr__nfet_01v8 w=1.26u l=0.15u
M993 a_55761_14191# a_55595_14191# VDD VDD sky130_fd_pr__pfet_01v8_hvt w=0.64u l=0.15u
M994 VDD a_49302_13621# a_49229_13647# VDD sky130_fd_pr__pfet_01v8_hvt w=0.42u l=0.15u
M995 VDD a_76865_9593# a_76895_9334# VDD sky130_fd_pr__pfet_01v8_hvt w=0.42u l=0.15u
M996 _57_.Y _84_.Q a_55497_10703# VSS sky130_fd_pr__nfet_01v8 w=0.65u l=0.15u
M997 a_73215_55974# a_73167_55886# VSS VSS sky130_fd_pr__nfet_01v8 w=1.26u l=0.15u
M998 a_79367_14557# a_78669_14191# a_79110_14303# VSS sky130_fd_pr__special_nfet_01v8 w=0.36u l=0.15u
M999 a_70846_13647# a_70407_13653# a_70761_13647# VSS sky130_fd_pr__special_nfet_01v8 w=0.36u l=0.15u
M1000 macro_core.phase_delay\[23\].delay_cell.A macro_core.phase_delay\[21\].delay_cell.Y VSS VSS sky130_fd_pr__nfet_01v8 w=0.65u l=0.15u
M1001 a_55167_55886# a_55215_55974# VSS VSS sky130_fd_pr__nfet_01v8 w=1.26u l=0.15u
M1002 a_55167_40886# a_55215_40974# VSS VSS sky130_fd_pr__nfet_01v8 w=1.26u l=0.15u
M1003 macro_core.phase_delay\[64\].delay_cell.Y macro_core.phase_delay\[64\].delay_cell.A VSS VSS sky130_fd_pr__nfet_01v8 w=0.65u l=0.15u
M1004 a_52449_14191# a_52283_14191# VSS VSS sky130_fd_pr__nfet_01v8 w=0.42u l=0.15u
M1005 _62_.Y _86_.CLK VDD VDD sky130_fd_pr__pfet_01v8_hvt w=0.84u l=0.15u
M1006 VSS a_62642_12127# a_62600_12015# VSS sky130_fd_pr__nfet_01v8 w=0.42u l=0.15u
M1007 a_77412_12015# a_77013_12015# a_77286_12381# VSS sky130_fd_pr__special_nfet_01v8 w=0.36u l=0.15u
M1008 VDD a_62863_9295# clkbuf_0_CLK.X VDD sky130_fd_pr__pfet_01v8_hvt w=1u l=0.15u
M1009 a_49940_14343# _88_.A a_50082_14518# VDD sky130_fd_pr__pfet_01v8_hvt w=0.42u l=0.15u
M1010 a_69339_12381# a_68475_12015# a_69082_12127# VDD sky130_fd_pr__pfet_01v8_hvt w=0.42u l=0.15u
M1011 a_71978_14518# _84_.Q VDD VDD sky130_fd_pr__pfet_01v8_hvt w=0.42u l=0.15u
M1012 a_81627_20496# _51_.A0 macro_core.array_and_peripherals.write_driver_6.BLB VDD sky130_fd_pr__pfet_01v8 w=5.04u l=0.15u
M1013 a_52354_3677# a_52081_3311# a_52269_3311# VDD sky130_fd_pr__pfet_01v8_hvt w=0.42u l=0.15u
M1014 _47_.A0 a_56627_14459# VSS VSS sky130_fd_pr__nfet_01v8 w=0.65u l=0.15u
M1015 macro_core.phase_delay\[57\].delay_cell.Y macro_core.phase_delay\[56\].delay_cell.Y VSS VSS sky130_fd_pr__nfet_01v8 w=0.65u l=0.15u
M1016 a_53911_2375# OEb VDD VDD sky130_fd_pr__pfet_01v8_hvt w=0.42u l=0.15u
M1017 macro_core.phase_delay\[73\].delay_cell.Y macro_core.phase_delay\[72\].delay_cell.Y VSS VSS sky130_fd_pr__nfet_01v8 w=0.65u l=0.15u
M1018 VDD a_62642_12127# a_62569_12381# VDD sky130_fd_pr__pfet_01v8_hvt w=0.42u l=0.15u
M1019 a_73613_12015# _50_.X VDD VDD sky130_fd_pr__pfet_01v8_hvt w=0.42u l=0.15u
M1020 VSS a_53911_2999# _34_.Y VSS sky130_fd_pr__nfet_01v8 w=0.65u l=0.15u
M1021 a_57966_9295# a_57693_9301# a_57881_9295# VDD sky130_fd_pr__pfet_01v8_hvt w=0.42u l=0.15u
M1022 VSS a_61642_14191# macro_core.write_drive.X VSS sky130_fd_pr__nfet_01v8 w=0.65u l=0.15u
M1023 a_70761_13647# _80_.D VDD VDD sky130_fd_pr__pfet_01v8_hvt w=0.42u l=0.15u
M1024 a_66353_11791# _34_.Y VSS VSS sky130_fd_pr__nfet_01v8 w=0.65u l=0.15u
M1025 a_61215_50974# a_61167_50886# VSS VSS sky130_fd_pr__nfet_01v8 w=1.26u l=0.15u
M1026 a_72449_11989# _44_.Y VDD VDD sky130_fd_pr__pfet_01v8_hvt w=0.42u l=0.15u
M1027 a_73866_12127# a_73698_12381# VSS VSS sky130_fd_pr__nfet_01v8 w=0.64u l=0.15u
M1028 VSS OEb _34_.Y VSS sky130_fd_pr__nfet_01v8 w=0.65u l=0.15u
M1029 a_72449_11989# _44_.Y VSS VSS sky130_fd_pr__nfet_01v8 w=0.42u l=0.15u
M1030 macro_core.phase_delay\[13\].delay_cell.Y macro_core.phase_delay\[12\].delay_cell.Y VSS VSS sky130_fd_pr__nfet_01v8 w=0.65u l=0.15u
M1031 VSS a_49670_9951# a_49628_9839# VSS sky130_fd_pr__nfet_01v8 w=0.42u l=0.15u
M1032 _87_.TE_B _84_.Q a_52921_10703# VSS sky130_fd_pr__nfet_01v8 w=0.65u l=0.15u
M1033 a_68861_11769# _44_.Y VDD VDD sky130_fd_pr__pfet_01v8_hvt w=0.42u l=0.15u
M1034 a_43167_50886# a_43215_50974# VSS VSS sky130_fd_pr__nfet_01v8 w=1.26u l=0.15u
M1035 a_49502_10205# a_49063_9839# a_49417_9839# VSS sky130_fd_pr__special_nfet_01v8 w=0.36u l=0.15u
M1036 a_79167_50886# macro_core.array_and_peripherals.wl_driver_2.WL macro_core.array_and_peripherals.write_driver_6.BLB VSS sky130_fd_pr__nfet_01v8 w=0.6u l=0.15u
M1037 VSS _86_.CLK _60_.Y VSS sky130_fd_pr__nfet_01v8 w=0.42u l=0.15u
M1038 VSS a_58835_12283# a_58793_12015# VSS sky130_fd_pr__nfet_01v8 w=0.42u l=0.15u
M1039 VDD macro_core.phase_delay\[0\].delay_cell.A a_73259_12015# VDD sky130_fd_pr__pfet_01v8_hvt w=0.64u l=0.15u
M1040 a_77286_12381# a_77013_12015# a_77201_12015# VDD sky130_fd_pr__pfet_01v8_hvt w=0.42u l=0.15u
M1041 macro_core.phase_delay\[51\].delay_cell.A macro_core.phase_delay\[50\].delay_cell.A VSS VSS sky130_fd_pr__nfet_01v8 w=0.65u l=0.15u
M1042 a_58391_9295# a_57693_9301# a_58134_9269# VSS sky130_fd_pr__special_nfet_01v8 w=0.36u l=0.15u
M1043 a_77987_10205# a_77289_9839# a_77730_9951# VSS sky130_fd_pr__special_nfet_01v8 w=0.36u l=0.15u
M1044 a_72295_14518# _38_.A1 a_71836_14343# VDD sky130_fd_pr__pfet_01v8_hvt w=0.42u l=0.15u
M1045 a_65189_12043# macro_core.phase_delay\[0\].delay_cell.A a_65103_12043# VSS sky130_fd_pr__nfet_01v8 w=0.42u l=0.15u
M1046 macro_core.phase_delay\[46\].delay_cell.A macro_core.phase_delay\[44\].delay_cell.Y VDD VDD sky130_fd_pr__pfet_01v8_hvt w=1u l=0.15u
M1047 VDD macro_core.write_drive.X a_85227_20916# VDD sky130_fd_pr__pfet_01v8 w=0.84u l=0.15u
M1048 a_78669_14191# a_78503_14191# VDD VDD sky130_fd_pr__pfet_01v8_hvt w=0.64u l=0.15u
M1049 macro_core.phase_delay\[78\].delay_cell.Y macro_core.phase_delay\[77\].delay_cell.Y VSS VSS sky130_fd_pr__nfet_01v8 w=0.65u l=0.15u
M1050 VDD a_52522_3423# a_52449_3677# VDD sky130_fd_pr__pfet_01v8_hvt w=0.42u l=0.15u
M1051 a_49628_9839# a_49229_9839# a_49502_10205# VSS sky130_fd_pr__special_nfet_01v8 w=0.36u l=0.15u
M1052 macro_core.phase_delay\[44\].delay_cell.A macro_core.phase_delay\[43\].delay_cell.A VSS VSS sky130_fd_pr__nfet_01v8 w=0.65u l=0.15u
M1053 a_54065_2767# CSb a_53981_2767# VDD sky130_fd_pr__pfet_01v8_hvt w=1u l=0.15u
M1054 a_75035_14557# a_74253_14191# a_74951_14557# VDD sky130_fd_pr__pfet_01v8_hvt w=0.42u l=0.15u
M1055 VSS a_68432_11703# _49_.X VSS sky130_fd_pr__nfet_01v8 w=0.65u l=0.15u
M1056 a_59937_12857# _84_.Q VDD VDD sky130_fd_pr__pfet_01v8_hvt w=0.42u l=0.15u
M1057 a_79215_50974# a_79167_50886# VSS VSS sky130_fd_pr__nfet_01v8 w=1.26u l=0.15u
M1058 a_44415_16496# macro_core.data_complement\[0\].complement.Y macro_core.array_and_peripherals.write_driver_0.BL VSS sky130_fd_pr__nfet_01v8 w=5.04u l=0.15u
M1059 macro_core.phase_delay\[15\].delay_cell.Y macro_core.phase_delay\[14\].delay_cell.Y VDD VDD sky130_fd_pr__pfet_01v8_hvt w=1u l=0.15u
M1060 VDD _42_.A1 macro_core.array_and_peripherals.sense_amp_1.SA_OUTB VDD sky130_fd_pr__pfet_01v8 w=1.89u l=0.15u
M1061 VDD macro_core.array_and_peripherals.sense_amp_3.SA_OUTB _40_.A1 VDD sky130_fd_pr__pfet_01v8 w=1.89u l=0.15u
M1062 DATA5 a_71235_12015# a_71739_12015# VSS sky130_fd_pr__nfet_01v8 w=0.65u l=0.15u
M1063 macro_core.phase_delay\[50\].delay_cell.A macro_core.phase_delay\[49\].delay_cell.A VSS VSS sky130_fd_pr__nfet_01v8 w=0.65u l=0.15u
M1064 VDD CLK a_62863_9295# VDD sky130_fd_pr__pfet_01v8_hvt w=1u l=0.15u
M1065 macro_core.phase_delay\[14\].delay_cell.Y macro_core.phase_delay\[13\].delay_cell.Y VSS VSS sky130_fd_pr__nfet_01v8 w=0.65u l=0.15u
M1066 VDD a_77730_9951# a_77657_10205# VDD sky130_fd_pr__pfet_01v8_hvt w=0.42u l=0.15u
M1067 a_49417_9839# _75_.D VSS VSS sky130_fd_pr__nfet_01v8 w=0.42u l=0.15u
M1068 _48_.A0 a_63067_12283# VSS VSS sky130_fd_pr__nfet_01v8 w=0.65u l=0.15u
M1069 a_68829_12015# _49_.X VSS VSS sky130_fd_pr__nfet_01v8 w=0.42u l=0.15u
M1070 VDD _86_.CLK a_55595_14191# VDD sky130_fd_pr__pfet_01v8_hvt w=0.64u l=0.15u
M1071 macro_core.phase_delay\[75\].delay_cell.Y macro_core.phase_delay\[74\].delay_cell.Y VDD VDD sky130_fd_pr__pfet_01v8_hvt w=1u l=0.15u
M1072 VDD a_71836_14343# _80_.D VDD sky130_fd_pr__pfet_01v8_hvt w=1u l=0.15u
M1073 a_48886_11837# _84_.Q VSS VSS sky130_fd_pr__nfet_01v8 w=0.42u l=0.15u
M1074 DATA3 a_59827_10383# a_60183_10383# VDD sky130_fd_pr__pfet_01v8_hvt w=1u l=0.15u
M1075 a_55497_10703# _34_.Y VSS VSS sky130_fd_pr__nfet_01v8 w=0.65u l=0.15u
M1076 macro_core.array_and_peripherals.write_driver_6.BLB macro_core.sense_drive.X macro_core.array_and_peripherals.sense_amp_6.SA_OUTB VDD sky130_fd_pr__pfet_01v8 w=2u l=0.15u
M1077 macro_core.phase_delay\[53\].delay_cell.Y macro_core.phase_delay\[53\].delay_cell.A VDD VDD sky130_fd_pr__pfet_01v8_hvt w=1u l=0.15u
M1078 a_49167_45886# macro_core.array_and_peripherals.wl_driver_1.WL macro_core.array_and_peripherals.write_driver_1.BLB VSS sky130_fd_pr__nfet_01v8 w=0.6u l=0.15u
M1079 macro_core.sense_drive.X a_64611_14191# VSS VSS sky130_fd_pr__nfet_01v8 w=0.65u l=0.15u
M1080 VDD a_51872_11703# _45_.X VDD sky130_fd_pr__pfet_01v8_hvt w=1u l=0.15u
M1081 VSS macro_core.sense_drive.X a_43615_26902# VSS sky130_fd_pr__nfet_01v8 w=0.98u l=0.15u
M1082 a_74652_14191# a_74253_14191# a_74526_14557# VSS sky130_fd_pr__special_nfet_01v8 w=0.36u l=0.15u
M1083 VSS a_56459_14557# a_56627_14459# VSS sky130_fd_pr__nfet_01v8 w=0.65u l=0.15u
M1084 a_54753_11471# _77_.D VSS VSS sky130_fd_pr__nfet_01v8 w=0.42u l=0.15u
M1085 VDD macro_core.qualify_row\[2\].qualify.X a_36227_51432# VDD sky130_fd_pr__pfet_01v8 w=1.68u l=0.15u
M1086 macro_core.qualify_row\[1\].qualify.X a_12663_36833# VSS VSS sky130_fd_pr__nfet_01v8 w=0.65u l=0.15u
M1087 a_14313_36833# macro_core.qualify_row\[2\].qualify.A a_14227_36833# VSS sky130_fd_pr__nfet_01v8 w=0.42u l=0.15u
M1088 VSS a_61642_14191# macro_core.write_drive.X VSS sky130_fd_pr__nfet_01v8 w=0.65u l=0.15u
M1089 VSS macro_core.phase_delay\[0\].delay_cell.A a_73259_12015# VSS sky130_fd_pr__nfet_01v8 w=0.42u l=0.15u
M1090 VDD macro_core.array_and_peripherals.sense_amp_6.SA_OUTB _37_.A1 VDD sky130_fd_pr__pfet_01v8 w=1.89u l=0.15u
M1091 a_46949_14455# _86_.CLK VDD VDD sky130_fd_pr__pfet_01v8_hvt w=0.42u l=0.15u
M1092 VDD macro_core.phase_delay\[0\].delay_cell.A _65_.Y VDD sky130_fd_pr__pfet_01v8_hvt w=0.84u l=0.15u
M1093 VSS a_73866_12127# a_73824_12015# VSS sky130_fd_pr__nfet_01v8 w=0.42u l=0.15u
M1094 macro_core.phase_delay\[10\].delay_cell.Y macro_core.phase_delay\[10\].delay_cell.A VSS VSS sky130_fd_pr__nfet_01v8 w=0.65u l=0.15u
M1095 VDD _39_.A1 macro_core.array_and_peripherals.sense_amp_4.SA_OUTB VDD sky130_fd_pr__pfet_01v8 w=1.89u l=0.15u
M1096 a_50369_14165# _84_.Q VSS VSS sky130_fd_pr__nfet_01v8 w=0.42u l=0.15u
M1097 VSS a_56288_13879# _47_.X VSS sky130_fd_pr__nfet_01v8 w=0.65u l=0.15u
M1098 VSS a_36227_51432# macro_core.array_and_peripherals.wl_driver_2.WL VSS sky130_fd_pr__nfet_01v8 w=5.04u l=0.15u
M1099 VDD a_72265_14165# a_72295_14518# VDD sky130_fd_pr__pfet_01v8_hvt w=0.42u l=0.15u
M1100 DATA0 a_52007_9839# a_52363_10089# VDD sky130_fd_pr__pfet_01v8_hvt w=1u l=0.15u
M1101 _54_.Y _84_.Q a_71413_11791# VSS sky130_fd_pr__nfet_01v8 w=0.65u l=0.15u
M1102 macro_core.array_and_peripherals.write_driver_0.BLB macro_core.precharge_drive.X macro_core.array_and_peripherals.write_driver_0.BL VDD sky130_fd_pr__pfet_01v8 w=2.52u l=0.15u
M1103 a_59937_12857# _84_.Q VSS VSS sky130_fd_pr__nfet_01v8 w=0.42u l=0.15u
M1104 VDD _61_.Y a_54399_11477# VDD sky130_fd_pr__pfet_01v8_hvt w=0.64u l=0.15u
M1105 macro_core.phase_delay\[44\].delay_cell.Y macro_core.phase_delay\[44\].delay_cell.A VSS VSS sky130_fd_pr__nfet_01v8 w=0.65u l=0.15u
M1106 VSS a_58539_10383# _86_.CLK VSS sky130_fd_pr__nfet_01v8 w=0.42u l=0.15u
M1107 a_49215_45974# a_49167_45886# VSS VSS sky130_fd_pr__nfet_01v8 w=1.26u l=0.15u
M1108 a_56585_14191# a_55595_14191# a_56459_14557# VSS sky130_fd_pr__special_nfet_01v8 w=0.36u l=0.15u
M1109 a_48886_11510# _84_.Q VDD VDD sky130_fd_pr__pfet_01v8_hvt w=0.42u l=0.15u
M1110 VSS a_55263_11471# a_55431_11445# VSS sky130_fd_pr__nfet_01v8 w=0.65u l=0.15u
M1111 VDD a_55263_11471# a_55431_11445# VDD sky130_fd_pr__pfet_01v8_hvt w=1u l=0.15u
M1112 a_85215_50974# a_85167_50886# VDD VDD sky130_fd_pr__pfet_01v8 w=0.42u l=0.15u
M1113 a_85215_45974# macro_core.array_and_peripherals.wl_driver_1.WL macro_core.array_and_peripherals.write_driver_7.BL VSS sky130_fd_pr__nfet_01v8 w=0.6u l=0.15u
M1114 VDD a_67851_13621# a_67767_13647# VDD sky130_fd_pr__pfet_01v8_hvt w=0.42u l=0.15u
M1115 VSS a_49173_11769# a_49107_11837# VSS sky130_fd_pr__nfet_01v8 w=0.42u l=0.15u
M1116 a_50027_20496# macro_core.data_complement\[1\].complement.Y macro_core.array_and_peripherals.write_driver_1.BL VDD sky130_fd_pr__pfet_01v8 w=5.04u l=0.15u
M1117 _47_.A0 a_56627_14459# VDD VDD sky130_fd_pr__pfet_01v8_hvt w=1u l=0.15u
M1118 VDD macro_core.phase_delay\[79\].delay_cell.Y a_64611_14191# VDD sky130_fd_pr__pfet_01v8_hvt w=1u l=0.15u
M1119 a_57693_9301# a_57527_9301# VSS VSS sky130_fd_pr__nfet_01v8 w=0.42u l=0.15u
M1120 a_75363_10089# _35_.Y VDD VDD sky130_fd_pr__pfet_01v8_hvt w=1u l=0.15u
M1121 _75_.Q a_50095_10107# VSS VSS sky130_fd_pr__nfet_01v8 w=0.65u l=0.15u
M1122 a_67167_45886# macro_core.array_and_peripherals.wl_driver_1.WL macro_core.array_and_peripherals.write_driver_4.BLB VSS sky130_fd_pr__nfet_01v8 w=0.6u l=0.15u
M1123 a_55615_26902# macro_core.array_and_peripherals.sense_amp_2.SA_OUTB _41_.A1 VSS sky130_fd_pr__nfet_01v8 w=0.98u l=0.15u
M1124 a_85167_45886# a_85215_45974# VDD VDD sky130_fd_pr__pfet_01v8 w=0.42u l=0.15u
M1125 a_55263_11471# a_54399_11477# a_55006_11445# VDD sky130_fd_pr__pfet_01v8_hvt w=0.42u l=0.15u
M1126 VSS macro_core.write_drive.X a_64015_16496# VSS sky130_fd_pr__nfet_01v8 w=5.04u l=0.15u
M1127 a_76015_16496# _50_.A0 macro_core.array_and_peripherals.write_driver_5.BLB VSS sky130_fd_pr__nfet_01v8 w=5.04u l=0.15u
M1128 a_58893_14191# _44_.Y VSS VSS sky130_fd_pr__nfet_01v8 w=0.42u l=0.15u
M1129 a_75934_14518# _84_.Q VDD VDD sky130_fd_pr__pfet_01v8_hvt w=0.42u l=0.15u
M1130 DATA1 a_51915_12015# a_52271_12265# VDD sky130_fd_pr__pfet_01v8_hvt w=1u l=0.15u
M1131 DATA6 a_75191_12015# a_75547_12265# VDD sky130_fd_pr__pfet_01v8_hvt w=1u l=0.15u
M1132 a_48744_11703# _75_.Q a_48886_11510# VDD sky130_fd_pr__pfet_01v8_hvt w=0.42u l=0.15u
M1133 VSS a_77730_9951# a_77688_9839# VSS sky130_fd_pr__nfet_01v8 w=0.42u l=0.15u
M1134 macro_core.phase_delay\[66\].delay_cell.Y macro_core.phase_delay\[65\].delay_cell.Y VSS VSS sky130_fd_pr__nfet_01v8 w=0.65u l=0.15u
M1135 a_77562_10205# a_77123_9839# a_77477_9839# VSS sky130_fd_pr__special_nfet_01v8 w=0.36u l=0.15u
M1136 macro_core.phase_delay\[54\].delay_cell.Y macro_core.phase_delay\[53\].delay_cell.Y VDD VDD sky130_fd_pr__pfet_01v8_hvt w=1u l=0.15u
M1137 macro_core.phase_delay\[38\].delay_cell.Y macro_core.phase_delay\[37\].delay_cell.Y VDD VDD sky130_fd_pr__pfet_01v8_hvt w=1u l=0.15u
M1138 VDD macro_core.precharge_drive.X macro_core.array_and_peripherals.write_driver_3.BL VDD sky130_fd_pr__pfet_01v8 w=2.52u l=0.15u
M1139 a_67683_13647# a_66985_13653# a_67426_13621# VSS sky130_fd_pr__special_nfet_01v8 w=0.36u l=0.15u
M1140 VDD macro_core.precharge_drive.X macro_core.array_and_peripherals.write_driver_1.BLB VDD sky130_fd_pr__pfet_01v8 w=2.52u l=0.15u
M1141 macro_core.phase_delay\[10\].delay_cell.A macro_core.phase_delay\[8\].delay_cell.Y VSS VSS sky130_fd_pr__nfet_01v8 w=0.65u l=0.15u
M1142 VSS a_52779_3677# a_52947_3579# VSS sky130_fd_pr__nfet_01v8 w=0.65u l=0.15u
M1143 a_58475_9295# a_57693_9301# a_58391_9295# VDD sky130_fd_pr__pfet_01v8_hvt w=0.42u l=0.15u
M1144 VDD _84_.Q _35_.Y VDD sky130_fd_pr__pfet_01v8_hvt w=1u l=0.15u
M1145 a_49502_10205# a_49229_9839# a_49417_9839# VDD sky130_fd_pr__pfet_01v8_hvt w=0.42u l=0.15u
M1146 a_73215_55974# macro_core.array_and_peripherals.wl_driver_3.WL macro_core.array_and_peripherals.write_driver_5.BL VSS sky130_fd_pr__nfet_01v8 w=0.6u l=0.15u
M1147 a_73215_40974# macro_core.array_and_peripherals.wl_driver_0.WL macro_core.array_and_peripherals.write_driver_5.BL VSS sky130_fd_pr__nfet_01v8 w=0.6u l=0.15u
M1148 VDD a_55006_11445# a_54933_11471# VDD sky130_fd_pr__pfet_01v8_hvt w=0.42u l=0.15u
M1149 DATA0 a_52007_9839# a_52511_9839# VSS sky130_fd_pr__nfet_01v8 w=0.65u l=0.15u
M1150 a_77289_9839# a_77123_9839# VDD VDD sky130_fd_pr__pfet_01v8_hvt w=0.64u l=0.15u
M1151 a_56191_10703# a_55853_10383# VSS VSS sky130_fd_pr__nfet_01v8 w=0.65u l=0.15u
M1152 a_55167_40886# macro_core.array_and_peripherals.wl_driver_0.WL macro_core.array_and_peripherals.write_driver_2.BLB VSS sky130_fd_pr__nfet_01v8 w=0.6u l=0.15u
M1153 a_74253_14191# a_74087_14191# VSS VSS sky130_fd_pr__nfet_01v8 w=0.42u l=0.15u
M1154 VDD a_77879_12283# a_77795_12381# VDD sky130_fd_pr__pfet_01v8_hvt w=0.42u l=0.15u
M1155 macro_core.phase_delay\[28\].delay_cell.A macro_core.phase_delay\[26\].delay_cell.Y VDD VDD sky130_fd_pr__pfet_01v8_hvt w=1u l=0.15u
M1156 a_55167_55886# macro_core.array_and_peripherals.wl_driver_3.WL macro_core.array_and_peripherals.write_driver_2.BLB VSS sky130_fd_pr__nfet_01v8 w=0.6u l=0.15u
M1157 a_62642_12127# a_62474_12381# VDD VDD sky130_fd_pr__pfet_01v8_hvt w=0.75u l=0.15u
M1158 VSS a_62899_12381# a_63067_12283# VSS sky130_fd_pr__nfet_01v8 w=0.65u l=0.15u
M1159 a_73167_40886# a_73215_40974# VDD VDD sky130_fd_pr__pfet_01v8 w=0.42u l=0.15u
M1160 a_68027_20496# macro_core.data_complement\[4\].complement.Y macro_core.array_and_peripherals.write_driver_4.BL VDD sky130_fd_pr__pfet_01v8 w=5.04u l=0.15u
M1161 a_49203_11510# _43_.A1 a_48744_11703# VDD sky130_fd_pr__pfet_01v8_hvt w=0.42u l=0.15u
M1162 a_58092_9673# a_57693_9301# a_57966_9295# VSS sky130_fd_pr__special_nfet_01v8 w=0.36u l=0.15u
M1163 a_77688_9839# a_77289_9839# a_77562_10205# VSS sky130_fd_pr__special_nfet_01v8 w=0.36u l=0.15u
M1164 a_73167_55886# a_73215_55974# VDD VDD sky130_fd_pr__pfet_01v8 w=0.42u l=0.15u
M1165 VDD macro_core.evaluation.X macro_core.array_and_peripherals.row_decoder_0.N1 VDD sky130_fd_pr__pfet_01v8 w=1.25u l=0.15u
M1166 a_45627_20496# _45_.A0 macro_core.array_and_peripherals.write_driver_0.BLB VDD sky130_fd_pr__pfet_01v8 w=5.04u l=0.15u
M1167 VDD a_55227_20916# a_57627_20496# VDD sky130_fd_pr__pfet_01v8 w=5.04u l=0.15u
M1168 a_68125_14165# _84_.Q VSS VSS sky130_fd_pr__nfet_01v8 w=0.42u l=0.15u
M1169 macro_core.phase_delay\[7\].delay_cell.Y macro_core.phase_delay\[6\].delay_cell.Y VSS VSS sky130_fd_pr__nfet_01v8 w=0.65u l=0.15u
M1170 VSS macro_core.write_drive.X a_80415_16496# VSS sky130_fd_pr__nfet_01v8 w=5.04u l=0.15u
M1171 a_57969_12015# a_57803_12015# VDD VDD sky130_fd_pr__pfet_01v8_hvt w=0.64u l=0.15u
M1172 a_50019_12381# a_49155_12015# a_49762_12127# VDD sky130_fd_pr__pfet_01v8_hvt w=0.42u l=0.15u
M1173 macro_core.phase_delay\[74\].delay_cell.Y macro_core.phase_delay\[73\].delay_cell.Y VSS VSS sky130_fd_pr__nfet_01v8 w=0.65u l=0.15u
M1174 a_55215_45974# a_55167_45886# VDD VDD sky130_fd_pr__pfet_01v8 w=0.42u l=0.15u
M1175 VDD a_79110_14303# a_79037_14557# VDD sky130_fd_pr__pfet_01v8_hvt w=0.42u l=0.15u
M1176 a_49689_12381# a_49155_12015# a_49594_12381# VDD sky130_fd_pr__pfet_01v8_hvt w=0.42u l=0.15u
M1177 VSS macro_core.write_drive.X a_67227_20916# VSS sky130_fd_pr__nfet_01v8 w=0.84u l=0.15u
M1178 a_76251_14518# _37_.A1 a_75792_14343# VDD sky130_fd_pr__pfet_01v8_hvt w=0.42u l=0.15u
M1179 VSS macro_core.array_and_peripherals.row_decoder_0.N3 macro_core.qualify_row\[3\].qualify.A VSS sky130_fd_pr__nfet_01v8 w=2u l=0.15u
M1180 VSS a_50187_12283# a_50145_12015# VSS sky130_fd_pr__nfet_01v8 w=0.42u l=0.15u
M1181 a_51872_11703# _45_.A0 a_52014_11510# VDD sky130_fd_pr__pfet_01v8_hvt w=0.42u l=0.15u
M1182 _61_.Y _86_.CLK VDD VDD sky130_fd_pr__pfet_01v8_hvt w=0.84u l=0.15u
M1183 VSS _86_.CLK a_49707_3311# VSS sky130_fd_pr__nfet_01v8 w=0.42u l=0.15u
M1184 a_77477_9839# _52_.X VSS VSS sky130_fd_pr__nfet_01v8 w=0.42u l=0.15u
M1185 macro_core.phase_delay\[64\].delay_cell.Y macro_core.phase_delay\[64\].delay_cell.A VDD VDD sky130_fd_pr__pfet_01v8_hvt w=1u l=0.15u
M1186 a_59993_10383# _56_.Y VSS VSS sky130_fd_pr__nfet_01v8 w=0.42u l=0.15u
M1187 a_61215_50974# macro_core.array_and_peripherals.wl_driver_2.WL macro_core.array_and_peripherals.write_driver_3.BL VSS sky130_fd_pr__nfet_01v8 w=0.6u l=0.15u
M1188 a_61167_45886# a_61215_45974# VSS VSS sky130_fd_pr__nfet_01v8 w=1.26u l=0.15u
M1189 _51_.A0 a_79535_14459# VDD VDD sky130_fd_pr__pfet_01v8_hvt w=1u l=0.15u
M1190 a_77013_12015# a_76847_12015# VDD VDD sky130_fd_pr__pfet_01v8_hvt w=0.64u l=0.15u
M1191 a_76865_9593# _44_.Y VDD VDD sky130_fd_pr__pfet_01v8_hvt w=0.42u l=0.15u
M1192 VDD _86_.CLK a_57527_9301# VDD sky130_fd_pr__pfet_01v8_hvt w=0.64u l=0.15u
M1193 VDD macro_core.precharge_drive.X macro_core.array_and_peripherals.write_driver_4.BLB VDD sky130_fd_pr__pfet_01v8 w=2.52u l=0.15u
M1194 VDD macro_core.precharge_drive.X macro_core.array_and_peripherals.write_driver_6.BL VDD sky130_fd_pr__pfet_01v8 w=2.52u l=0.15u
M1195 a_58157_12015# _78_.D VDD VDD sky130_fd_pr__pfet_01v8_hvt w=0.42u l=0.15u
M1196 a_69339_12381# a_68641_12015# a_69082_12127# VSS sky130_fd_pr__special_nfet_01v8 w=0.36u l=0.15u
M1197 a_78071_10205# a_77289_9839# a_77987_10205# VDD sky130_fd_pr__pfet_01v8_hvt w=0.42u l=0.15u
M1198 a_43167_50886# macro_core.array_and_peripherals.wl_driver_2.WL macro_core.array_and_peripherals.write_driver_0.BLB VSS sky130_fd_pr__nfet_01v8 w=0.6u l=0.15u
M1199 macro_core.qualify_row\[3\].qualify.X a_15147_35745# VSS VSS sky130_fd_pr__nfet_01v8 w=0.65u l=0.15u
M1200 VDD macro_core.array_and_peripherals.row_decoder_0.A1B macro_core.array_and_peripherals.row_decoder_0.A1T VDD sky130_fd_pr__pfet_01v8 w=2u l=0.15u
M1201 _65_.Y macro_core.phase_delay\[0\].delay_cell.A VDD VDD sky130_fd_pr__pfet_01v8_hvt w=0.84u l=0.15u
M1202 macro_core.phase_delay\[36\].delay_cell.Y macro_core.phase_delay\[35\].delay_cell.Y VSS VSS sky130_fd_pr__nfet_01v8 w=0.65u l=0.15u
M1203 a_61167_50886# a_61215_50974# VDD VDD sky130_fd_pr__pfet_01v8 w=0.42u l=0.15u
M1204 macro_core.phase_delay\[51\].delay_cell.Y macro_core.phase_delay\[51\].delay_cell.A VDD VDD sky130_fd_pr__pfet_01v8_hvt w=1u l=0.15u
M1205 VDD a_73227_20916# a_74027_20496# VDD sky130_fd_pr__pfet_01v8 w=5.04u l=0.15u
M1206 a_63682_14191# macro_core.evaluation.A a_63599_14191# VSS sky130_fd_pr__nfet_01v8 w=0.65u l=0.15u
M1207 a_47104_14197# _86_.CLK a_47032_14197# VSS sky130_fd_pr__nfet_01v8 w=0.42u l=0.15u
M1208 VDD a_64611_14191# macro_core.sense_drive.X VDD sky130_fd_pr__pfet_01v8_hvt w=1u l=0.15u
M1209 a_68914_12381# a_68641_12015# a_68829_12015# VDD sky130_fd_pr__pfet_01v8_hvt w=0.42u l=0.15u
M1210 _86_.CLK a_58539_10383# VSS VSS sky130_fd_pr__nfet_01v8 w=0.42u l=0.15u
M1211 a_77201_12015# _82_.D VDD VDD sky130_fd_pr__pfet_01v8_hvt w=0.42u l=0.15u
M1212 VSS a_76865_9593# a_76799_9661# VSS sky130_fd_pr__nfet_01v8 w=0.42u l=0.15u
M1213 a_43215_55974# a_43167_55886# VDD VDD sky130_fd_pr__pfet_01v8 w=0.42u l=0.15u
M1214 a_43215_40974# a_43167_40886# VDD VDD sky130_fd_pr__pfet_01v8 w=0.42u l=0.15u
M1215 a_53063_13103# _46_.A0 a_52700_13255# VSS sky130_fd_pr__nfet_01v8 w=0.42u l=0.15u
M1216 VDD macro_core.write_drive.X a_49227_20916# VDD sky130_fd_pr__pfet_01v8 w=0.84u l=0.15u
M1217 a_52890_14303# a_52722_14557# VDD VDD sky130_fd_pr__pfet_01v8_hvt w=0.75u l=0.15u
M1218 VDD a_56459_14557# a_56627_14459# VDD sky130_fd_pr__pfet_01v8_hvt w=1u l=0.15u
M1219 VSS _63_.Y a_66819_13653# VSS sky130_fd_pr__nfet_01v8 w=0.42u l=0.15u
M1220 macro_core.phase_delay\[26\].delay_cell.Y macro_core.phase_delay\[26\].delay_cell.A VDD VDD sky130_fd_pr__pfet_01v8_hvt w=1u l=0.15u
M1221 DATA2 a_55687_10383# a_56191_10703# VSS sky130_fd_pr__nfet_01v8 w=0.65u l=0.15u
M1222 a_79167_45886# a_79215_45974# VSS VSS sky130_fd_pr__nfet_01v8 w=1.26u l=0.15u
M1223 VSS _33_.Y a_49063_9839# VSS sky130_fd_pr__nfet_01v8 w=0.42u l=0.15u
M1224 VDD a_49173_11769# a_49203_11510# VDD sky130_fd_pr__pfet_01v8_hvt w=0.42u l=0.15u
M1225 a_52081_3311# a_51915_3311# VDD VDD sky130_fd_pr__pfet_01v8_hvt w=0.64u l=0.15u
M1226 _86_.Q a_50739_3579# VSS VSS sky130_fd_pr__nfet_01v8 w=0.65u l=0.15u
M1227 a_57969_12015# a_57803_12015# VSS VSS sky130_fd_pr__nfet_01v8 w=0.42u l=0.15u
M1228 VSS a_74291_12283# a_74249_12015# VSS sky130_fd_pr__nfet_01v8 w=0.42u l=0.15u
M1229 a_79167_50886# a_79215_50974# VDD VDD sky130_fd_pr__pfet_01v8 w=0.42u l=0.15u
M1230 VSS a_52890_14303# a_52848_14191# VSS sky130_fd_pr__nfet_01v8 w=0.42u l=0.15u
M1231 a_66985_13653# a_66819_13653# VDD VDD sky130_fd_pr__pfet_01v8_hvt w=0.64u l=0.15u
M1232 VDD _88_.A a_51915_12015# VDD sky130_fd_pr__pfet_01v8_hvt w=0.64u l=0.15u
M1233 VSS _88_.A a_51915_12015# VSS sky130_fd_pr__nfet_01v8 w=0.42u l=0.15u
M1234 _35_.Y _34_.Y VDD VDD sky130_fd_pr__pfet_01v8_hvt w=1u l=0.15u
M1235 macro_core.array_and_peripherals.write_driver_0.BLB macro_core.sense_drive.X macro_core.array_and_peripherals.sense_amp_0.SA_OUTB VDD sky130_fd_pr__pfet_01v8 w=2u l=0.15u
M1236 _41_.A1 macro_core.sense_drive.X macro_core.array_and_peripherals.write_driver_2.BL VDD sky130_fd_pr__pfet_01v8 w=2u l=0.15u
M1237 a_55615_26902# _41_.A1 macro_core.array_and_peripherals.sense_amp_2.SA_OUTB VSS sky130_fd_pr__nfet_01v8 w=0.98u l=0.15u
M1238 VSS _65_.Y a_74087_14191# VSS sky130_fd_pr__nfet_01v8 w=0.42u l=0.15u
M1239 VDD a_63599_14191# macro_core.precharge_drive.X VDD sky130_fd_pr__pfet_01v8_hvt w=1u l=0.15u
M1240 a_77013_12015# a_76847_12015# VSS VSS sky130_fd_pr__nfet_01v8 w=0.42u l=0.15u
M1241 a_85215_55974# a_85167_55886# VSS VSS sky130_fd_pr__nfet_01v8 w=1.26u l=0.15u
M1242 a_85215_40974# a_85167_40886# VSS VSS sky130_fd_pr__nfet_01v8 w=1.26u l=0.15u
M1243 VDD macro_core.array_and_peripherals.row_decoder_0.N3 macro_core.qualify_row\[3\].qualify.A VDD sky130_fd_pr__pfet_01v8 w=3u l=0.15u
M1244 macro_core.data_complement\[4\].complement.Y _49_.A0 VSS VSS sky130_fd_pr__nfet_01v8 w=0.65u l=0.15u
M1245 a_48744_11703# _43_.A1 a_48886_11837# VSS sky130_fd_pr__nfet_01v8 w=0.42u l=0.15u
M1246 a_67167_55886# a_67215_55974# VSS VSS sky130_fd_pr__nfet_01v8 w=1.26u l=0.15u
M1247 a_67167_40886# a_67215_40974# VSS VSS sky130_fd_pr__nfet_01v8 w=1.26u l=0.15u
M1248 macro_core.array_and_peripherals.row_decoder_0.EVAL_GND macro_core.array_and_peripherals.row_decoder_0.A0B macro_core.array_and_peripherals.row_decoder_0.net1 VSS sky130_fd_pr__nfet_01v8 w=2u l=0.15u
M1249 VDD a_53315_14459# a_53231_14557# VDD sky130_fd_pr__pfet_01v8_hvt w=0.42u l=0.15u
M1250 a_78857_14191# _51_.X VDD VDD sky130_fd_pr__pfet_01v8_hvt w=0.42u l=0.15u
M1251 a_52779_3677# a_51915_3311# a_52522_3423# VDD sky130_fd_pr__pfet_01v8_hvt w=0.42u l=0.15u
M1252 macro_core.phase_delay\[30\].delay_cell.Y macro_core.phase_delay\[30\].delay_cell.A VDD VDD sky130_fd_pr__pfet_01v8_hvt w=1u l=0.15u
M1253 a_63341_11769# _44_.Y VSS VSS sky130_fd_pr__nfet_01v8 w=0.42u l=0.15u
M1254 a_59403_14557# a_58539_14191# a_59146_14303# VDD sky130_fd_pr__pfet_01v8_hvt w=0.42u l=0.15u
M1255 VSS macro_core.precharge_phase.X a_63682_14191# VSS sky130_fd_pr__nfet_01v8 w=0.65u l=0.15u
M1256 a_55263_11471# a_54565_11477# a_55006_11445# VSS sky130_fd_pr__special_nfet_01v8 w=0.36u l=0.15u
M1257 a_59073_14557# a_58539_14191# a_58978_14557# VDD sky130_fd_pr__pfet_01v8_hvt w=0.42u l=0.15u
M1258 macro_core.phase_delay\[68\].delay_cell.Y macro_core.phase_delay\[67\].delay_cell.Y VDD VDD sky130_fd_pr__pfet_01v8_hvt w=1u l=0.15u
M1259 VSS a_50095_10107# a_50053_9839# VSS sky130_fd_pr__nfet_01v8 w=0.42u l=0.15u
M1260 a_76221_14165# _84_.Q VDD VDD sky130_fd_pr__pfet_01v8_hvt w=0.42u l=0.15u
M1261 VDD _66_.Y a_76847_12015# VDD sky130_fd_pr__pfet_01v8_hvt w=0.64u l=0.15u
M1262 VDD a_50369_14165# a_50399_14518# VDD sky130_fd_pr__pfet_01v8_hvt w=0.42u l=0.15u
M1263 a_50571_3677# a_49873_3311# a_50314_3423# VSS sky130_fd_pr__special_nfet_01v8 w=0.36u l=0.15u
M1264 a_49215_50974# a_49167_50886# VDD VDD sky130_fd_pr__pfet_01v8 w=0.42u l=0.15u
M1265 VSS a_58410_12127# a_58368_12015# VSS sky130_fd_pr__nfet_01v8 w=0.42u l=0.15u
M1266 macro_core.phase_delay\[70\].delay_cell.Y macro_core.phase_delay\[70\].delay_cell.A VSS VSS sky130_fd_pr__nfet_01v8 w=0.65u l=0.15u
M1267 a_73215_50974# a_73167_50886# VSS VSS sky130_fd_pr__nfet_01v8 w=1.26u l=0.15u
M1268 macro_core.phase_delay\[32\].delay_cell.A macro_core.phase_delay\[30\].delay_cell.Y VDD VDD sky130_fd_pr__pfet_01v8_hvt w=1u l=0.15u
M1269 macro_core.phase_delay\[67\].delay_cell.Y macro_core.phase_delay\[66\].delay_cell.Y VDD VDD sky130_fd_pr__pfet_01v8_hvt w=1u l=0.15u
M1270 a_49670_9951# a_49502_10205# VDD VDD sky130_fd_pr__pfet_01v8_hvt w=0.75u l=0.15u
M1271 macro_core.phase_delay\[25\].delay_cell.A macro_core.phase_delay\[23\].delay_cell.Y VSS VSS sky130_fd_pr__nfet_01v8 w=0.65u l=0.15u
M1272 a_55167_50886# a_55215_50974# VSS VSS sky130_fd_pr__nfet_01v8 w=1.26u l=0.15u
M1273 VDD a_59146_14303# a_59073_14557# VDD sky130_fd_pr__pfet_01v8_hvt w=0.42u l=0.15u
M1274 a_59146_14303# a_58978_14557# VSS VSS sky130_fd_pr__nfet_01v8 w=0.64u l=0.15u
M1275 a_72265_14165# _84_.Q VDD VDD sky130_fd_pr__pfet_01v8_hvt w=0.42u l=0.15u
M1276 macro_core.phase_delay\[28\].delay_cell.Y macro_core.phase_delay\[28\].delay_cell.A VSS VSS sky130_fd_pr__nfet_01v8 w=0.65u l=0.15u
M1277 a_49167_45886# a_49215_45974# VDD VDD sky130_fd_pr__pfet_01v8 w=0.42u l=0.15u
M1278 a_58978_14557# a_58539_14191# a_58893_14191# VSS sky130_fd_pr__special_nfet_01v8 w=0.36u l=0.15u
M1279 VSS a_63599_14191# macro_core.precharge_drive.X VSS sky130_fd_pr__nfet_01v8 w=0.65u l=0.15u
M1280 a_49643_13647# a_48861_13653# a_49559_13647# VDD sky130_fd_pr__pfet_01v8_hvt w=0.42u l=0.15u
M1281 VDD a_58410_12127# a_58337_12381# VDD sky130_fd_pr__pfet_01v8_hvt w=0.42u l=0.15u
M1282 VSS a_77454_12127# a_77412_12015# VSS sky130_fd_pr__nfet_01v8 w=0.42u l=0.15u
M1283 _84_.Q a_58559_9269# VSS VSS sky130_fd_pr__nfet_01v8 w=0.65u l=0.15u
M1284 a_49670_9951# a_49502_10205# VSS VSS sky130_fd_pr__nfet_01v8 w=0.64u l=0.15u
M1285 VSS macro_core.array_and_peripherals.row_decoder_0.A0B macro_core.array_and_peripherals.row_decoder_0.A0T VSS sky130_fd_pr__nfet_01v8 w=2u l=0.15u
M1286 a_51872_11703# DATA0 a_52014_11837# VSS sky130_fd_pr__nfet_01v8 w=0.42u l=0.15u
M1287 VDD a_52947_3579# a_52863_3677# VDD sky130_fd_pr__pfet_01v8_hvt w=0.42u l=0.15u
M1288 a_63341_11769# _44_.Y VDD VDD sky130_fd_pr__pfet_01v8_hvt w=0.42u l=0.15u
M1289 a_77406_13686# _44_.Y VDD VDD sky130_fd_pr__pfet_01v8_hvt w=0.42u l=0.15u
M1290 a_52522_3423# a_52354_3677# VDD VDD sky130_fd_pr__pfet_01v8_hvt w=0.75u l=0.15u
M1291 macro_core.phase_delay\[30\].delay_cell.A macro_core.phase_delay\[28\].delay_cell.Y VDD VDD sky130_fd_pr__pfet_01v8_hvt w=1u l=0.15u
M1292 a_59650_12598# _84_.Q VDD VDD sky130_fd_pr__pfet_01v8_hvt w=0.42u l=0.15u
M1293 a_66709_12337# _55_.Y VSS VSS sky130_fd_pr__nfet_01v8 w=0.42u l=0.15u
M1294 macro_core.data_complement\[2\].complement.Y _47_.A0 VSS VSS sky130_fd_pr__nfet_01v8 w=0.65u l=0.15u
M1295 a_52014_11837# _44_.Y VSS VSS sky130_fd_pr__nfet_01v8 w=0.42u l=0.15u
M1296 VSS _86_.CLK _61_.Y VSS sky130_fd_pr__nfet_01v8 w=0.42u l=0.15u
M1297 macro_core.phase_delay\[1\].delay_cell.Y macro_core.phase_delay\[1\].delay_cell.A VDD VDD sky130_fd_pr__pfet_01v8_hvt w=1u l=0.15u
M1298 _46_.A0 a_53315_14459# VSS VSS sky130_fd_pr__nfet_01v8 w=0.65u l=0.15u
M1299 a_68059_14191# _91_.A a_67696_14343# VSS sky130_fd_pr__nfet_01v8 w=0.42u l=0.15u
M1300 _53_.Y _84_.Q a_74817_11791# VSS sky130_fd_pr__nfet_01v8 w=0.65u l=0.15u
M1301 VDD macro_core.precharge_phase.X a_63599_14191# VDD sky130_fd_pr__pfet_01v8_hvt w=1u l=0.15u
M1302 VSS a_71271_13647# a_71439_13621# VSS sky130_fd_pr__nfet_01v8 w=0.65u l=0.15u
M1303 a_62983_12381# a_62201_12015# a_62899_12381# VDD sky130_fd_pr__pfet_01v8_hvt w=0.42u l=0.15u
M1304 a_77264_13879# _51_.A0 a_77406_13686# VDD sky130_fd_pr__pfet_01v8_hvt w=0.42u l=0.15u
M1305 a_54933_11471# a_54399_11477# a_54838_11471# VDD sky130_fd_pr__pfet_01v8_hvt w=0.42u l=0.15u
M1306 a_56415_16496# macro_core.data_complement\[2\].complement.Y macro_core.array_and_peripherals.write_driver_2.BL VSS sky130_fd_pr__nfet_01v8 w=5.04u l=0.15u
M1307 a_59508_12791# _90_.A a_59650_12598# VDD sky130_fd_pr__pfet_01v8_hvt w=0.42u l=0.15u
M1308 VDD _40_.A1 macro_core.array_and_peripherals.sense_amp_3.SA_OUTB VDD sky130_fd_pr__pfet_01v8 w=1.89u l=0.15u
M1309 VDD macro_core.array_and_peripherals.sense_amp_5.SA_OUTB _38_.A1 VDD sky130_fd_pr__pfet_01v8 w=1.89u l=0.15u
M1310 VSS macro_core.write_drive.X a_44415_16496# VSS sky130_fd_pr__nfet_01v8 w=5.04u l=0.15u
M1311 a_74123_12381# a_73259_12015# a_73866_12127# VDD sky130_fd_pr__pfet_01v8_hvt w=0.42u l=0.15u
M1312 macro_core.phase_delay\[5\].delay_cell.Y macro_core.phase_delay\[4\].delay_cell.Y VSS VSS sky130_fd_pr__nfet_01v8 w=0.65u l=0.15u
M1313 a_71271_13647# a_70407_13653# a_71014_13621# VDD sky130_fd_pr__pfet_01v8_hvt w=0.42u l=0.15u
M1314 VDD a_78368_12167# _82_.D VDD sky130_fd_pr__pfet_01v8_hvt w=1u l=0.15u
M1315 VSS _61_.Y a_54399_11477# VSS sky130_fd_pr__nfet_01v8 w=0.42u l=0.15u
M1316 VSS a_62912_11703# _48_.X VSS sky130_fd_pr__nfet_01v8 w=0.65u l=0.15u
M1317 macro_core.phase_delay\[49\].delay_cell.A macro_core.phase_delay\[48\].delay_cell.A VSS VSS sky130_fd_pr__nfet_01v8 w=0.65u l=0.15u
M1318 a_67809_14025# a_66819_13653# a_67683_13647# VSS sky130_fd_pr__special_nfet_01v8 w=0.36u l=0.15u
M1319 a_52842_13430# _44_.Y VDD VDD sky130_fd_pr__pfet_01v8_hvt w=0.42u l=0.15u
M1320 VSS _66_.Y a_76847_12015# VSS sky130_fd_pr__nfet_01v8 w=0.42u l=0.15u
M1321 a_50655_3677# a_49873_3311# a_50571_3677# VDD sky130_fd_pr__pfet_01v8_hvt w=0.42u l=0.15u
M1322 macro_core.phase_delay\[65\].delay_cell.Y macro_core.phase_delay\[64\].delay_cell.Y VSS VSS sky130_fd_pr__nfet_01v8 w=0.65u l=0.15u
M1323 VDD _86_.CLK _60_.Y VDD sky130_fd_pr__pfet_01v8_hvt w=0.84u l=0.15u
M1324 a_56430_13686# _44_.Y VDD VDD sky130_fd_pr__pfet_01v8_hvt w=0.42u l=0.15u
M1325 a_70972_14025# a_70573_13653# a_70846_13647# VSS sky130_fd_pr__special_nfet_01v8 w=0.36u l=0.15u
M1326 a_43215_45974# a_43167_45886# VSS VSS sky130_fd_pr__nfet_01v8 w=1.26u l=0.15u
M1327 VDD macro_core.evaluation.A a_46949_14455# VDD sky130_fd_pr__pfet_01v8_hvt w=0.42u l=0.15u
M1328 a_74526_14557# a_74253_14191# a_74441_14191# VDD sky130_fd_pr__pfet_01v8_hvt w=0.42u l=0.15u
M1329 VSS a_67851_13621# a_67809_14025# VSS sky130_fd_pr__nfet_01v8 w=0.42u l=0.15u
M1330 a_52842_13103# _44_.Y VSS VSS sky130_fd_pr__nfet_01v8 w=0.42u l=0.15u
M1331 macro_core.phase_delay\[58\].delay_cell.Y macro_core.phase_delay\[57\].delay_cell.Y VDD VDD sky130_fd_pr__pfet_01v8_hvt w=1u l=0.15u
M1332 a_79215_45974# macro_core.array_and_peripherals.wl_driver_1.WL macro_core.array_and_peripherals.write_driver_6.BL VSS sky130_fd_pr__nfet_01v8 w=0.6u l=0.15u
M1333 a_14227_36833# macro_core.qualify_row\[2\].qualify.A VDD VDD sky130_fd_pr__pfet_01v8_hvt w=0.42u l=0.15u
M1334 a_56034_14557# a_55595_14191# a_55949_14191# VSS sky130_fd_pr__special_nfet_01v8 w=0.36u l=0.15u
M1335 a_56459_14557# a_55761_14191# a_56202_14303# VSS sky130_fd_pr__special_nfet_01v8 w=0.36u l=0.15u
M1336 VDD _86_.CLK a_51915_3311# VDD sky130_fd_pr__pfet_01v8_hvt w=0.64u l=0.15u
M1337 a_61167_45886# macro_core.array_and_peripherals.wl_driver_1.WL macro_core.array_and_peripherals.write_driver_3.BLB VSS sky130_fd_pr__nfet_01v8 w=0.6u l=0.15u
M1338 a_52014_11510# _44_.Y VDD VDD sky130_fd_pr__pfet_01v8_hvt w=0.42u l=0.15u
M1339 _55_.Y _84_.Q a_66353_11791# VSS sky130_fd_pr__nfet_01v8 w=0.65u l=0.15u
M1340 macro_core.phase_delay\[40\].delay_cell.A macro_core.phase_delay\[38\].delay_cell.Y VSS VSS sky130_fd_pr__nfet_01v8 w=0.65u l=0.15u
M1341 macro_core.phase_delay\[3\].delay_cell.Y macro_core.phase_delay\[2\].delay_cell.Y VSS VSS sky130_fd_pr__nfet_01v8 w=0.65u l=0.15u
M1342 VSS macro_core.sense_drive.X a_55615_26902# VSS sky130_fd_pr__nfet_01v8 w=0.98u l=0.15u
M1343 VDD a_71014_13621# a_70941_13647# VDD sky130_fd_pr__pfet_01v8_hvt w=0.42u l=0.15u
M1344 a_52700_13255# _46_.A0 a_52842_13430# VDD sky130_fd_pr__pfet_01v8_hvt w=0.42u l=0.15u
M1345 macro_core.data_complement\[5\].complement.Y _50_.A0 VDD VDD sky130_fd_pr__pfet_01v8_hvt w=1u l=0.15u
M1346 macro_core.sense_drive.X a_64611_14191# VSS VSS sky130_fd_pr__nfet_01v8 w=0.65u l=0.15u
M1347 a_56288_13879# _47_.A0 a_56430_13686# VDD sky130_fd_pr__pfet_01v8_hvt w=0.42u l=0.15u
M1348 _90_.A a_58835_12283# VSS VSS sky130_fd_pr__nfet_01v8 w=0.65u l=0.15u
M1349 VSS macro_core.phase_delay\[59\].delay_cell.Y a_47104_14197# VSS sky130_fd_pr__nfet_01v8 w=0.42u l=0.15u
M1350 a_49594_12381# a_49155_12015# a_49509_12015# VSS sky130_fd_pr__special_nfet_01v8 w=0.36u l=0.15u
M1351 macro_core.data_complement\[0\].complement.Y _45_.A0 VDD VDD sky130_fd_pr__pfet_01v8_hvt w=1u l=0.15u
M1352 a_59650_12925# _84_.Q VSS VSS sky130_fd_pr__nfet_01v8 w=0.42u l=0.15u
M1353 a_49173_11769# _84_.Q VSS VSS sky130_fd_pr__nfet_01v8 w=0.42u l=0.15u
M1354 a_56129_14557# a_55595_14191# a_56034_14557# VDD sky130_fd_pr__pfet_01v8_hvt w=0.42u l=0.15u
M1355 VDD a_49559_13647# a_49727_13621# VDD sky130_fd_pr__pfet_01v8_hvt w=1u l=0.15u
M1356 a_63025_12015# a_62035_12015# a_62899_12381# VSS sky130_fd_pr__special_nfet_01v8 w=0.36u l=0.15u
M1357 _49_.A0 a_69507_12283# VDD VDD sky130_fd_pr__pfet_01v8_hvt w=1u l=0.15u
M1358 macro_core.phase_delay\[34\].delay_cell.Y macro_core.phase_delay\[34\].delay_cell.A VSS VSS sky130_fd_pr__nfet_01v8 w=0.65u l=0.15u
M1359 VDD _86_.Q macro_core.array_and_peripherals.row_decoder_0.A1B VDD sky130_fd_pr__pfet_01v8 w=0.84u l=0.15u
M1360 VSS _86_.CLK a_58539_14191# VSS sky130_fd_pr__nfet_01v8 w=0.42u l=0.15u
M1361 VSS a_49559_13647# a_49727_13621# VSS sky130_fd_pr__nfet_01v8 w=0.65u l=0.15u
M1362 _58_.Y _34_.Y VDD VDD sky130_fd_pr__pfet_01v8_hvt w=1u l=0.15u
M1363 VSS a_50314_3423# a_50272_3311# VSS sky130_fd_pr__nfet_01v8 w=0.42u l=0.15u
M1364 VDD a_72020_12167# _50_.X VDD sky130_fd_pr__pfet_01v8_hvt w=1u l=0.15u
M1365 a_74357_9839# _34_.Y VSS VSS sky130_fd_pr__nfet_01v8 w=0.65u l=0.15u
M1366 macro_core.array_and_peripherals.write_driver_2.BLB macro_core.precharge_drive.X macro_core.array_and_peripherals.write_driver_2.BL VDD sky130_fd_pr__pfet_01v8 w=2.52u l=0.15u
M1367 VDD _86_.CLK a_52283_14191# VDD sky130_fd_pr__pfet_01v8_hvt w=0.64u l=0.15u
M1368 a_68914_12381# a_68475_12015# a_68829_12015# VSS sky130_fd_pr__special_nfet_01v8 w=0.36u l=0.15u
M1369 a_50146_3677# a_49707_3311# a_50061_3311# VSS sky130_fd_pr__special_nfet_01v8 w=0.36u l=0.15u
M1370 a_49167_40886# macro_core.array_and_peripherals.wl_driver_0.WL macro_core.array_and_peripherals.write_driver_1.BLB VSS sky130_fd_pr__nfet_01v8 w=0.6u l=0.15u
M1371 a_49559_13647# a_48695_13653# a_49302_13621# VDD sky130_fd_pr__pfet_01v8_hvt w=0.42u l=0.15u
M1372 a_49167_55886# macro_core.array_and_peripherals.wl_driver_3.WL macro_core.array_and_peripherals.write_driver_1.BLB VSS sky130_fd_pr__nfet_01v8 w=0.6u l=0.15u
M1373 VDD a_49227_20916# a_51627_20496# VDD sky130_fd_pr__pfet_01v8 w=5.04u l=0.15u
M1374 a_62027_20496# macro_core.data_complement\[3\].complement.Y macro_core.array_and_peripherals.write_driver_3.BL VDD sky130_fd_pr__pfet_01v8 w=5.04u l=0.15u
M1375 VSS a_49927_10205# a_50095_10107# VSS sky130_fd_pr__nfet_01v8 w=0.65u l=0.15u
M1376 a_67615_26902# macro_core.array_and_peripherals.sense_amp_4.SA_OUTB _39_.A1 VSS sky130_fd_pr__nfet_01v8 w=0.98u l=0.15u
M1377 VSS macro_core.write_drive.X a_76015_16496# VSS sky130_fd_pr__nfet_01v8 w=5.04u l=0.15u
M1378 a_88015_16496# _52_.A0 macro_core.array_and_peripherals.write_driver_7.BLB VSS sky130_fd_pr__nfet_01v8 w=5.04u l=0.15u
M1379 VSS a_74694_14303# a_74652_14191# VSS sky130_fd_pr__nfet_01v8 w=0.42u l=0.15u
M1380 a_50272_3311# a_49873_3311# a_50146_3677# VSS sky130_fd_pr__special_nfet_01v8 w=0.36u l=0.15u
M1381 VSS a_53147_14557# a_53315_14459# VSS sky130_fd_pr__nfet_01v8 w=0.65u l=0.15u
M1382 VSS a_52700_13255# _46_.X VSS sky130_fd_pr__nfet_01v8 w=0.65u l=0.15u
M1383 a_77454_12127# a_77286_12381# VSS VSS sky130_fd_pr__nfet_01v8 w=0.64u l=0.15u
M1384 a_74817_11791# _34_.Y VSS VSS sky130_fd_pr__nfet_01v8 w=0.65u l=0.15u
M1385 VSS macro_core.write_drive.X a_61227_20916# VSS sky130_fd_pr__nfet_01v8 w=0.84u l=0.15u
M1386 a_49173_11769# _84_.Q VDD VDD sky130_fd_pr__pfet_01v8_hvt w=0.42u l=0.15u
M1387 VSS a_36227_46432# macro_core.array_and_peripherals.wl_driver_1.WL VSS sky130_fd_pr__nfet_01v8 w=5.04u l=0.15u
M1388 a_62899_12381# a_62035_12015# a_62642_12127# VDD sky130_fd_pr__pfet_01v8_hvt w=0.42u l=0.15u
M1389 a_67047_12015# a_66709_12337# VSS VSS sky130_fd_pr__nfet_01v8 w=0.65u l=0.15u
M1390 a_62569_12381# a_62035_12015# a_62474_12381# VDD sky130_fd_pr__pfet_01v8_hvt w=0.42u l=0.15u
M1391 a_49215_55974# a_49167_55886# VSS VSS sky130_fd_pr__nfet_01v8 w=1.26u l=0.15u
M1392 a_49215_40974# a_49167_40886# VSS VSS sky130_fd_pr__nfet_01v8 w=1.26u l=0.15u
M1393 VDD macro_core.precharge_drive.X macro_core.array_and_peripherals.write_driver_3.BLB VDD sky130_fd_pr__pfet_01v8 w=2.52u l=0.15u
M1394 VDD macro_core.precharge_drive.X macro_core.array_and_peripherals.write_driver_5.BL VDD sky130_fd_pr__pfet_01v8 w=2.52u l=0.15u
M1395 a_53911_2375# OEb VSS VSS sky130_fd_pr__nfet_01v8 w=0.42u l=0.15u
M1396 a_58517_9673# a_57527_9301# a_58391_9295# VSS sky130_fd_pr__special_nfet_01v8 w=0.36u l=0.15u
M1397 VDD a_66819_10383# macro_core.phase_delay\[0\].delay_cell.A VDD sky130_fd_pr__pfet_01v8_hvt w=1u l=0.15u
M1398 a_85215_40974# macro_core.array_and_peripherals.wl_driver_0.WL macro_core.array_and_peripherals.write_driver_7.BL VSS sky130_fd_pr__nfet_01v8 w=0.6u l=0.15u
M1399 VSS a_49940_14343# _76_.D VSS sky130_fd_pr__nfet_01v8 w=0.65u l=0.15u
M1400 a_59871_12925# _90_.A a_59508_12791# VSS sky130_fd_pr__nfet_01v8 w=0.42u l=0.15u
M1401 a_85215_55974# macro_core.array_and_peripherals.wl_driver_3.WL macro_core.array_and_peripherals.write_driver_7.BL VSS sky130_fd_pr__nfet_01v8 w=0.6u l=0.15u
M1402 VDD a_36227_46432# macro_core.array_and_peripherals.wl_driver_1.WL VDD sky130_fd_pr__pfet_01v8 w=5.04u l=0.15u
M1403 VSS a_46949_14455# macro_core.evaluation.X VSS sky130_fd_pr__nfet_01v8 w=0.65u l=0.15u
M1404 a_53273_14191# a_52283_14191# a_53147_14557# VSS sky130_fd_pr__special_nfet_01v8 w=0.36u l=0.15u
M1405 a_67426_13621# a_67258_13647# VDD VDD sky130_fd_pr__pfet_01v8_hvt w=0.75u l=0.15u
M1406 a_50061_3311# ADDR1 VSS VSS sky130_fd_pr__nfet_01v8 w=0.42u l=0.15u
M1407 a_67167_55886# macro_core.array_and_peripherals.wl_driver_3.WL macro_core.array_and_peripherals.write_driver_4.BLB VSS sky130_fd_pr__nfet_01v8 w=0.6u l=0.15u
M1408 a_67167_40886# macro_core.array_and_peripherals.wl_driver_0.WL macro_core.array_and_peripherals.write_driver_4.BLB VSS sky130_fd_pr__nfet_01v8 w=0.6u l=0.15u
M1409 a_67258_13647# a_66985_13653# a_67173_13647# VDD sky130_fd_pr__pfet_01v8_hvt w=0.42u l=0.15u
M1410 macro_core.data_complement\[1\].complement.Y _46_.A0 VDD VDD sky130_fd_pr__pfet_01v8_hvt w=1u l=0.15u
M1411 a_64694_14191# _84_.Q a_64611_14191# VSS sky130_fd_pr__nfet_01v8 w=0.65u l=0.15u
M1412 VDD macro_core.phase_delay\[23\].delay_cell.Y a_65103_12043# VDD sky130_fd_pr__pfet_01v8_hvt w=0.42u l=0.15u
M1413 _52_.A0 a_78155_10107# VSS VSS sky130_fd_pr__nfet_01v8 w=0.65u l=0.15u
M1414 a_85167_55886# a_85215_55974# VDD VDD sky130_fd_pr__pfet_01v8 w=0.42u l=0.15u
M1415 a_85167_40886# a_85215_40974# VDD VDD sky130_fd_pr__pfet_01v8 w=0.42u l=0.15u
M1416 a_57627_20496# _47_.A0 macro_core.array_and_peripherals.write_driver_2.BLB VDD sky130_fd_pr__pfet_01v8 w=5.04u l=0.15u
M1417 VDD a_67227_20916# a_69627_20496# VDD sky130_fd_pr__pfet_01v8 w=5.04u l=0.15u
M1418 macro_core.phase_delay\[8\].delay_cell.Y macro_core.phase_delay\[7\].delay_cell.Y VDD VDD sky130_fd_pr__pfet_01v8_hvt w=1u l=0.15u
M1419 VSS macro_core.evaluation.X a_14313_36833# VSS sky130_fd_pr__nfet_01v8 w=0.42u l=0.15u
M1420 VDD macro_core.write_drive.X a_43227_20916# VDD sky130_fd_pr__pfet_01v8 w=0.84u l=0.15u
M1421 a_55006_11445# a_54838_11471# VSS VSS sky130_fd_pr__nfet_01v8 w=0.64u l=0.15u
M1422 a_78857_14191# _51_.X VSS VSS sky130_fd_pr__nfet_01v8 w=0.42u l=0.15u
M1423 a_52173_10161# _87_.TE_B VDD VDD sky130_fd_pr__pfet_01v8_hvt w=0.64u l=0.15u
M1424 a_55853_10383# _57_.Y VSS VSS sky130_fd_pr__nfet_01v8 w=0.42u l=0.15u
M1425 a_67215_45974# a_67167_45886# VDD VDD sky130_fd_pr__pfet_01v8 w=0.42u l=0.15u
M1426 VSS macro_core.write_drive.X a_79227_20916# VSS sky130_fd_pr__nfet_01v8 w=0.84u l=0.15u
M1427 a_77406_14013# _44_.Y VSS VSS sky130_fd_pr__nfet_01v8 w=0.42u l=0.15u
M1428 a_58410_12127# a_58242_12381# VDD VDD sky130_fd_pr__pfet_01v8_hvt w=0.75u l=0.15u
M1429 a_54565_11477# a_54399_11477# VDD VDD sky130_fd_pr__pfet_01v8_hvt w=0.64u l=0.15u
M1430 macro_core.array_and_peripherals.row_decoder_0.net1 macro_core.array_and_peripherals.row_decoder_0.A1B macro_core.array_and_peripherals.row_decoder_0.N0 VSS sky130_fd_pr__nfet_01v8 w=2u l=0.15u
M1431 a_67838_14191# _84_.Q VSS VSS sky130_fd_pr__nfet_01v8 w=0.42u l=0.15u
M1432 VDD a_53129_13077# a_53159_13430# VDD sky130_fd_pr__pfet_01v8_hvt w=0.42u l=0.15u
M1433 VSS a_58667_12381# a_58835_12283# VSS sky130_fd_pr__nfet_01v8 w=0.65u l=0.15u
M1434 _89_.A a_55431_11445# VDD VDD sky130_fd_pr__pfet_01v8_hvt w=1u l=0.15u
M1435 macro_core.phase_delay\[37\].delay_cell.Y macro_core.phase_delay\[36\].delay_cell.Y VSS VSS sky130_fd_pr__nfet_01v8 w=0.65u l=0.15u
M1436 a_73167_45886# a_73215_45974# VSS VSS sky130_fd_pr__nfet_01v8 w=1.26u l=0.15u
M1437 _89_.A a_55431_11445# VSS VSS sky130_fd_pr__nfet_01v8 w=0.65u l=0.15u
M1438 macro_core.phase_delay\[46\].delay_cell.Y macro_core.phase_delay\[46\].delay_cell.A VDD VDD sky130_fd_pr__pfet_01v8_hvt w=1u l=0.15u
M1439 _54_.Y _34_.Y VDD VDD sky130_fd_pr__pfet_01v8_hvt w=1u l=0.15u
M1440 a_73215_50974# macro_core.array_and_peripherals.wl_driver_2.WL macro_core.array_and_peripherals.write_driver_5.BL VSS sky130_fd_pr__nfet_01v8 w=0.6u l=0.15u
M1441 a_59104_14191# a_58705_14191# a_58978_14557# VSS sky130_fd_pr__special_nfet_01v8 w=0.36u l=0.15u
M1442 macro_core.phase_delay\[70\].delay_cell.A macro_core.phase_delay\[68\].delay_cell.Y VSS VSS sky130_fd_pr__nfet_01v8 w=0.65u l=0.15u
M1443 macro_core.phase_delay\[54\].delay_cell.Y macro_core.phase_delay\[53\].delay_cell.Y VSS VSS sky130_fd_pr__nfet_01v8 w=0.65u l=0.15u
M1444 a_55167_50886# macro_core.array_and_peripherals.wl_driver_2.WL macro_core.array_and_peripherals.write_driver_2.BLB VSS sky130_fd_pr__nfet_01v8 w=0.6u l=0.15u
M1445 VDD a_69339_12381# a_69507_12283# VDD sky130_fd_pr__pfet_01v8_hvt w=1u l=0.15u
M1446 macro_core.phase_delay\[18\].delay_cell.Y macro_core.phase_delay\[17\].delay_cell.Y VDD VDD sky130_fd_pr__pfet_01v8_hvt w=1u l=0.15u
M1447 VDD a_52890_14303# a_52817_14557# VDD sky130_fd_pr__pfet_01v8_hvt w=0.42u l=0.15u
M1448 VDD a_52301_11769# a_52331_11510# VDD sky130_fd_pr__pfet_01v8_hvt w=0.42u l=0.15u
M1449 a_55389_11849# a_54399_11477# a_55263_11471# VSS sky130_fd_pr__special_nfet_01v8 w=0.36u l=0.15u
M1450 a_73167_50886# a_73215_50974# VDD VDD sky130_fd_pr__pfet_01v8 w=0.42u l=0.15u
M1451 VDD a_85227_20916# a_86027_20496# VDD sky130_fd_pr__pfet_01v8 w=5.04u l=0.15u
M1452 VSS a_77711_12381# a_77879_12283# VSS sky130_fd_pr__nfet_01v8 w=0.65u l=0.15u
M1453 a_55347_11471# a_54565_11477# a_55263_11471# VDD sky130_fd_pr__pfet_01v8_hvt w=0.42u l=0.15u
M1454 macro_core.phase_delay\[71\].delay_cell.Y macro_core.phase_delay\[70\].delay_cell.Y VSS VSS sky130_fd_pr__nfet_01v8 w=0.65u l=0.15u
M1455 _42_.A1 macro_core.sense_drive.X macro_core.array_and_peripherals.write_driver_1.BL VDD sky130_fd_pr__pfet_01v8 w=2u l=0.15u
M1456 a_49615_26902# _42_.A1 macro_core.array_and_peripherals.sense_amp_1.SA_OUTB VSS sky130_fd_pr__nfet_01v8 w=0.98u l=0.15u
M1457 VSS a_55431_11445# a_55389_11849# VSS sky130_fd_pr__nfet_01v8 w=0.42u l=0.15u
M1458 macro_core.phase_delay\[48\].delay_cell.A macro_core.phase_delay\[46\].delay_cell.Y VDD VDD sky130_fd_pr__pfet_01v8_hvt w=1u l=0.15u
M1459 a_77987_10205# a_77123_9839# a_77730_9951# VDD sky130_fd_pr__pfet_01v8_hvt w=0.42u l=0.15u
M1460 a_77657_10205# a_77123_9839# a_77562_10205# VDD sky130_fd_pr__pfet_01v8_hvt w=0.42u l=0.15u
M1461 a_55215_55974# a_55167_55886# VDD VDD sky130_fd_pr__pfet_01v8 w=0.42u l=0.15u
M1462 a_55215_40974# a_55167_40886# VDD VDD sky130_fd_pr__pfet_01v8 w=0.42u l=0.15u
M1463 a_59821_9839# _34_.Y VSS VSS sky130_fd_pr__nfet_01v8 w=0.65u l=0.15u
M1464 VDD a_64611_14191# macro_core.sense_drive.X VDD sky130_fd_pr__pfet_01v8_hvt w=1u l=0.15u
M1465 a_53129_13077# _44_.Y VDD VDD sky130_fd_pr__pfet_01v8_hvt w=0.42u l=0.15u
M1466 macro_core.qualify_row\[0\].qualify.X a_15147_37067# VDD VDD sky130_fd_pr__pfet_01v8_hvt w=1u l=0.15u
M1467 a_56430_14013# _44_.Y VSS VSS sky130_fd_pr__nfet_01v8 w=0.42u l=0.15u
M1468 a_61167_55886# a_61215_55974# VSS VSS sky130_fd_pr__nfet_01v8 w=1.26u l=0.15u
M1469 a_61167_40886# a_61215_40974# VSS VSS sky130_fd_pr__nfet_01v8 w=1.26u l=0.15u
M1470 a_53129_13077# _44_.Y VSS VSS sky130_fd_pr__nfet_01v8 w=0.42u l=0.15u
M1471 VDD macro_core.evaluation.X a_15147_37067# VDD sky130_fd_pr__pfet_01v8_hvt w=0.42u l=0.15u
M1472 a_79451_14557# a_78669_14191# a_79367_14557# VDD sky130_fd_pr__pfet_01v8_hvt w=0.42u l=0.15u
M1473 a_54065_2473# CSb a_53981_2473# VDD sky130_fd_pr__pfet_01v8_hvt w=1u l=0.15u
M1474 VSS a_68125_14165# a_68059_14191# VSS sky130_fd_pr__nfet_01v8 w=0.42u l=0.15u
M1475 VDD a_56717_13945# a_56747_13686# VDD sky130_fd_pr__pfet_01v8_hvt w=0.42u l=0.15u
M1476 macro_core.write_drive.X a_61642_14191# VDD VDD sky130_fd_pr__pfet_01v8_hvt w=1u l=0.15u
M1477 VSS macro_core.phase_delay\[79\].delay_cell.Y a_64694_14191# VSS sky130_fd_pr__nfet_01v8 w=0.65u l=0.15u
M1478 VDD clkbuf_0_CLK.X a_58539_10383# VDD sky130_fd_pr__pfet_01v8_hvt w=1u l=0.15u
M1479 macro_core.phase_delay\[21\].delay_cell.Y macro_core.phase_delay\[21\].delay_cell.A VDD VDD sky130_fd_pr__pfet_01v8_hvt w=1u l=0.15u
M1480 a_77627_14013# _51_.A0 a_77264_13879# VSS sky130_fd_pr__nfet_01v8 w=0.42u l=0.15u
M1481 a_43215_50974# a_43167_50886# VDD VDD sky130_fd_pr__pfet_01v8 w=0.42u l=0.15u
M1482 _39_.A1 macro_core.sense_drive.X macro_core.array_and_peripherals.write_driver_4.BL VDD sky130_fd_pr__pfet_01v8 w=2u l=0.15u
M1483 a_67615_26902# _39_.A1 macro_core.array_and_peripherals.sense_amp_4.SA_OUTB VSS sky130_fd_pr__nfet_01v8 w=0.98u l=0.15u
M1484 VSS a_59571_14459# a_59529_14191# VSS sky130_fd_pr__nfet_01v8 w=0.42u l=0.15u
M1485 macro_core.phase_delay\[21\].delay_cell.A macro_core.phase_delay\[19\].delay_cell.Y VSS VSS sky130_fd_pr__nfet_01v8 w=0.65u l=0.15u
M1486 macro_core.phase_delay\[26\].delay_cell.Y macro_core.phase_delay\[26\].delay_cell.A VSS VSS sky130_fd_pr__nfet_01v8 w=0.65u l=0.15u
M1487 a_43215_45974# macro_core.array_and_peripherals.wl_driver_1.WL macro_core.array_and_peripherals.write_driver_0.BL VSS sky130_fd_pr__nfet_01v8 w=0.6u l=0.15u
M1488 macro_core.array_and_peripherals.write_driver_2.BLB macro_core.sense_drive.X macro_core.array_and_peripherals.sense_amp_2.SA_OUTB VDD sky130_fd_pr__pfet_01v8 w=2u l=0.15u
M1489 macro_core.evaluation.X a_46949_14455# VSS VSS sky130_fd_pr__nfet_01v8 w=0.65u l=0.15u
M1490 a_56288_13879# DATA2 a_56430_14013# VSS sky130_fd_pr__nfet_01v8 w=0.42u l=0.15u
M1491 VDD a_53147_14557# a_53315_14459# VDD sky130_fd_pr__pfet_01v8_hvt w=1u l=0.15u
M1492 a_65103_12043# macro_core.phase_delay\[0\].delay_cell.A VDD VDD sky130_fd_pr__pfet_01v8_hvt w=0.42u l=0.15u
.ends sram_4x8_wrapper
