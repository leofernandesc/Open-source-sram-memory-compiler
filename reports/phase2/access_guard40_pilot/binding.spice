.subckt sky130_fd_sc_hd__and2_1 A B VGND VNB VPB VPWR X
X0 VGND a_59_75# X VNB sky130_fd_pr__nfet_01v8 w=650000u l=150000u
X1 VPWR A a_59_75# VPB sky130_fd_pr__pfet_01v8_hvt w=420000u l=150000u
X2 a_59_75# A a_145_75# VNB sky130_fd_pr__nfet_01v8 w=420000u l=150000u
X3 a_59_75# B VPWR VPB sky130_fd_pr__pfet_01v8_hvt w=420000u l=150000u
X4 a_145_75# B VGND VNB sky130_fd_pr__nfet_01v8 w=420000u l=150000u
X5 VPWR a_59_75# X VPB sky130_fd_pr__pfet_01v8_hvt w=1e+06u l=150000u
.ends

.subckt sky130_fd_sc_hd__and2_4 A B VGND VNB VPB VPWR X
X0 a_27_47# B VPWR VPB sky130_fd_pr__pfet_01v8_hvt w=1e+06u l=150000u
X1 VPWR A a_27_47# VPB sky130_fd_pr__pfet_01v8_hvt w=1e+06u l=150000u
X2 a_110_47# B VGND VNB sky130_fd_pr__nfet_01v8 w=650000u l=150000u
X3 VGND a_27_47# X VNB sky130_fd_pr__nfet_01v8 w=650000u l=150000u
X4 a_27_47# A a_110_47# VNB sky130_fd_pr__nfet_01v8 w=650000u l=150000u
X5 X a_27_47# VGND VNB sky130_fd_pr__nfet_01v8 w=650000u l=150000u
X6 VPWR a_27_47# X VPB sky130_fd_pr__pfet_01v8_hvt w=1e+06u l=150000u
X7 VPWR a_27_47# X VPB sky130_fd_pr__pfet_01v8_hvt w=1e+06u l=150000u
X8 VGND a_27_47# X VNB sky130_fd_pr__nfet_01v8 w=650000u l=150000u
X9 X a_27_47# VPWR VPB sky130_fd_pr__pfet_01v8_hvt w=1e+06u l=150000u
X10 X a_27_47# VGND VNB sky130_fd_pr__nfet_01v8 w=650000u l=150000u
X11 X a_27_47# VPWR VPB sky130_fd_pr__pfet_01v8_hvt w=1e+06u l=150000u
.ends

.subckt sky130_fd_sc_hd__and3_2 A B C VGND VNB VPB VPWR X
X0 X a_29_311# VGND VNB sky130_fd_pr__nfet_01v8 w=650000u l=150000u
X1 X a_29_311# VPWR VPB sky130_fd_pr__pfet_01v8_hvt w=1e+06u l=150000u
X2 a_184_53# C VGND VNB sky130_fd_pr__nfet_01v8 w=420000u l=150000u
X3 a_29_311# A VPWR VPB sky130_fd_pr__pfet_01v8_hvt w=420000u l=150000u
X4 VGND a_29_311# X VNB sky130_fd_pr__nfet_01v8 w=650000u l=150000u
X5 a_112_53# B a_184_53# VNB sky130_fd_pr__nfet_01v8 w=420000u l=150000u
X6 a_29_311# A a_112_53# VNB sky130_fd_pr__nfet_01v8 w=420000u l=150000u
X7 VPWR a_29_311# X VPB sky130_fd_pr__pfet_01v8_hvt w=1e+06u l=150000u
X8 VPWR B a_29_311# VPB sky130_fd_pr__pfet_01v8_hvt w=420000u l=150000u
X9 a_29_311# C VPWR VPB sky130_fd_pr__pfet_01v8_hvt w=420000u l=150000u
.ends

.subckt sky130_fd_sc_hd__and3_4 A B C VGND VNB VPB VPWR X
X0 a_185_47# B a_294_47# VNB sky130_fd_pr__nfet_01v8 w=650000u l=150000u
X1 X a_94_47# VGND VNB sky130_fd_pr__nfet_01v8 w=650000u l=150000u
X2 VPWR B a_94_47# VPB sky130_fd_pr__pfet_01v8_hvt w=1e+06u l=150000u
X3 a_94_47# A VPWR VPB sky130_fd_pr__pfet_01v8_hvt w=1e+06u l=150000u
X4 a_94_47# A a_185_47# VNB sky130_fd_pr__nfet_01v8 w=650000u l=150000u
X5 a_94_47# C VPWR VPB sky130_fd_pr__pfet_01v8_hvt w=1e+06u l=150000u
X6 VGND a_94_47# X VNB sky130_fd_pr__nfet_01v8 w=650000u l=150000u
X7 X a_94_47# VPWR VPB sky130_fd_pr__pfet_01v8_hvt w=1e+06u l=150000u
X8 VPWR a_94_47# X VPB sky130_fd_pr__pfet_01v8_hvt w=1e+06u l=150000u
X9 a_294_47# C VGND VNB sky130_fd_pr__nfet_01v8 w=650000u l=150000u
X10 X a_94_47# VGND VNB sky130_fd_pr__nfet_01v8 w=650000u l=150000u
X11 VGND a_94_47# X VNB sky130_fd_pr__nfet_01v8 w=650000u l=150000u
X12 X a_94_47# VPWR VPB sky130_fd_pr__pfet_01v8_hvt w=1e+06u l=150000u
X13 VPWR a_94_47# X VPB sky130_fd_pr__pfet_01v8_hvt w=1e+06u l=150000u
.ends

.subckt sky130_fd_sc_hd__clkinv_1 A VGND VNB VPB VPWR Y
X0 Y A VPWR VPB sky130_fd_pr__pfet_01v8_hvt w=840000u l=150000u
X1 Y A VGND VNB sky130_fd_pr__nfet_01v8 w=420000u l=150000u
X2 VPWR A Y VPB sky130_fd_pr__pfet_01v8_hvt w=840000u l=150000u
.ends

.subckt sky130_fd_sc_hd__dfxtp_1 CLK D VGND VNB VPB VPWR Q
X0 a_891_413# a_193_47# a_975_413# VPB sky130_fd_pr__pfet_01v8_hvt w=420000u l=150000u
X1 a_1059_315# a_891_413# VGND VNB sky130_fd_pr__nfet_01v8 w=650000u l=150000u
X2 a_466_413# a_27_47# a_561_413# VPB sky130_fd_pr__pfet_01v8_hvt w=420000u l=150000u
X3 a_634_159# a_27_47# a_891_413# VPB sky130_fd_pr__pfet_01v8_hvt w=420000u l=150000u
X4 a_381_47# a_193_47# a_466_413# VPB sky130_fd_pr__pfet_01v8_hvt w=420000u l=150000u
X5 VPWR D a_381_47# VPB sky130_fd_pr__pfet_01v8_hvt w=420000u l=150000u
X6 VPWR a_466_413# a_634_159# VPB sky130_fd_pr__pfet_01v8_hvt w=750000u l=150000u
X7 VGND a_466_413# a_634_159# VNB sky130_fd_pr__nfet_01v8 w=640000u l=150000u
X8 a_1017_47# a_1059_315# VGND VNB sky130_fd_pr__nfet_01v8 w=420000u l=150000u
X9 a_1059_315# a_891_413# VPWR VPB sky130_fd_pr__pfet_01v8_hvt w=1e+06u l=150000u
X10 a_561_413# a_634_159# VPWR VPB sky130_fd_pr__pfet_01v8_hvt w=420000u l=150000u
X11 VPWR a_1059_315# Q VPB sky130_fd_pr__pfet_01v8_hvt w=1e+06u l=150000u
X12 a_891_413# a_27_47# a_1017_47# VNB sky130_fd_pr__special_nfet_01v8 w=360000u l=150000u
X13 a_634_159# a_193_47# a_891_413# VNB sky130_fd_pr__special_nfet_01v8 w=360000u l=150000u
X14 a_592_47# a_634_159# VGND VNB sky130_fd_pr__nfet_01v8 w=420000u l=150000u
X15 a_466_413# a_193_47# a_592_47# VNB sky130_fd_pr__special_nfet_01v8 w=360000u l=150000u
X16 VGND a_27_47# a_193_47# VNB sky130_fd_pr__nfet_01v8 w=420000u l=150000u
X17 a_381_47# a_27_47# a_466_413# VNB sky130_fd_pr__special_nfet_01v8 w=360000u l=150000u
X18 a_27_47# CLK VGND VNB sky130_fd_pr__nfet_01v8 w=420000u l=150000u
X19 a_27_47# CLK VPWR VPB sky130_fd_pr__pfet_01v8_hvt w=640000u l=150000u
X20 VPWR a_27_47# a_193_47# VPB sky130_fd_pr__pfet_01v8_hvt w=640000u l=150000u
X21 VGND D a_381_47# VNB sky130_fd_pr__nfet_01v8 w=420000u l=150000u
X22 a_975_413# a_1059_315# VPWR VPB sky130_fd_pr__pfet_01v8_hvt w=420000u l=150000u
X23 VGND a_1059_315# Q VNB sky130_fd_pr__nfet_01v8 w=650000u l=150000u
.ends

.subckt sky130_fd_sc_hd__ebufn_1 A TE_B VGND VNB VPB VPWR Z
X0 VGND TE_B a_193_369# VNB sky130_fd_pr__nfet_01v8 w=420000u l=150000u
X1 VGND a_193_369# a_531_47# VNB sky130_fd_pr__nfet_01v8 w=650000u l=150000u
X2 a_531_47# a_27_47# Z VNB sky130_fd_pr__nfet_01v8 w=650000u l=150000u
X3 VPWR TE_B a_383_297# VPB sky130_fd_pr__pfet_01v8_hvt w=1e+06u l=150000u
X4 a_383_297# a_27_47# Z VPB sky130_fd_pr__pfet_01v8_hvt w=1e+06u l=150000u
X5 a_27_47# A VPWR VPB sky130_fd_pr__pfet_01v8_hvt w=640000u l=150000u
X6 VPWR TE_B a_193_369# VPB sky130_fd_pr__pfet_01v8_hvt w=640000u l=150000u
X7 a_27_47# A VGND VNB sky130_fd_pr__nfet_01v8 w=420000u l=150000u
.ends

.subckt sky130_fd_sc_hd__inv_1 A VGND VNB VPB VPWR Y
X0 VGND A Y VNB sky130_fd_pr__nfet_01v8 w=650000u l=150000u
X1 VPWR A Y VPB sky130_fd_pr__pfet_01v8_hvt w=1e+06u l=150000u
.ends

.subckt sky130_fd_sc_hd__mux2_1 A0 A1 S VGND VNB VPB VPWR X
X0 VPWR S a_218_374# VPB sky130_fd_pr__pfet_01v8_hvt w=420000u l=150000u
X1 a_76_199# A0 a_439_47# VNB sky130_fd_pr__nfet_01v8 w=420000u l=150000u
X2 a_535_374# a_505_21# VPWR VPB sky130_fd_pr__pfet_01v8_hvt w=420000u l=150000u
X3 VPWR S a_505_21# VPB sky130_fd_pr__pfet_01v8_hvt w=420000u l=150000u
X4 a_76_199# A1 a_535_374# VPB sky130_fd_pr__pfet_01v8_hvt w=420000u l=150000u
X5 a_218_47# A1 a_76_199# VNB sky130_fd_pr__nfet_01v8 w=420000u l=150000u
X6 a_218_374# A0 a_76_199# VPB sky130_fd_pr__pfet_01v8_hvt w=420000u l=150000u
X7 X a_76_199# VGND VNB sky130_fd_pr__nfet_01v8 w=650000u l=150000u
X8 X a_76_199# VPWR VPB sky130_fd_pr__pfet_01v8_hvt w=1e+06u l=150000u
X9 VGND S a_218_47# VNB sky130_fd_pr__nfet_01v8 w=420000u l=150000u
X10 VGND S a_505_21# VNB sky130_fd_pr__nfet_01v8 w=420000u l=150000u
X11 a_439_47# a_505_21# VGND VNB sky130_fd_pr__nfet_01v8 w=420000u l=150000u
.ends

.subckt sky130_fd_sc_hd__nand2_1 A B VGND VNB VPB VPWR Y
X0 Y A VPWR VPB sky130_fd_pr__pfet_01v8_hvt w=1e+06u l=150000u
X1 VPWR B Y VPB sky130_fd_pr__pfet_01v8_hvt w=1e+06u l=150000u
X2 VGND B a_113_47# VNB sky130_fd_pr__nfet_01v8 w=650000u l=150000u
X3 a_113_47# A Y VNB sky130_fd_pr__nfet_01v8 w=650000u l=150000u
.ends

.subckt sky130_fd_sc_hd__nor3b_1 A B C_N VGND VNB VPB VPWR Y
X0 Y A VGND VNB sky130_fd_pr__nfet_01v8 w=650000u l=150000u
X1 VPWR C_N a_91_199# VPB sky130_fd_pr__pfet_01v8_hvt w=420000u l=150000u
X2 a_161_297# B a_245_297# VPB sky130_fd_pr__pfet_01v8_hvt w=1e+06u l=150000u
X3 VGND C_N a_91_199# VNB sky130_fd_pr__nfet_01v8 w=420000u l=150000u
X4 Y a_91_199# a_161_297# VPB sky130_fd_pr__pfet_01v8_hvt w=1e+06u l=150000u
X5 a_245_297# A VPWR VPB sky130_fd_pr__pfet_01v8_hvt w=1e+06u l=150000u
X6 VGND B Y VNB sky130_fd_pr__nfet_01v8 w=650000u l=150000u
X7 Y a_91_199# VGND VNB sky130_fd_pr__nfet_01v8 w=650000u l=150000u
.ends

.subckt sky130_fd_sc_hd__or2_1 A B VGND VNB VPB VPWR X
X0 a_150_297# A VPWR VPB sky130_fd_pr__pfet_01v8_hvt w=420000u l=150000u
X1 VGND a_68_297# X VNB sky130_fd_pr__nfet_01v8 w=650000u l=150000u
X2 VGND B a_68_297# VNB sky130_fd_pr__nfet_01v8 w=420000u l=150000u
X3 a_68_297# A VGND VNB sky130_fd_pr__nfet_01v8 w=420000u l=150000u
X4 a_68_297# B a_150_297# VPB sky130_fd_pr__pfet_01v8_hvt w=420000u l=150000u
X5 VPWR a_68_297# X VPB sky130_fd_pr__pfet_01v8_hvt w=1e+06u l=150000u
.ends

.subckt sram_4x8_wrapper CLK ADDR0 ADDR1 DATA0 DATA1 DATA2 DATA3 DATA4 DATA5 DATA6 DATA7 CSb OEb WEb VDD VSS
Xmapped0 CLK VSS VSS VDD VDD n18 sky130_fd_sc_hd__clkinv_1
Xmapped1 OEb CSb WEb VSS VSS VDD VDD n19 sky130_fd_sc_hd__nor3b_1
Xmapped2 n20 n19 VSS VSS VDD VDD n21 sky130_fd_sc_hd__nand2_1
Xmapped3 n22 n23 n20 VSS VSS VDD VDD n24 sky130_fd_sc_hd__mux2_1
Xmapped4 n25 n26 n20 VSS VSS VDD VDD n27 sky130_fd_sc_hd__mux2_1
Xmapped5 n28 n29 n20 VSS VSS VDD VDD n30 sky130_fd_sc_hd__mux2_1
Xmapped6 n31 n32 n20 VSS VSS VDD VDD n33 sky130_fd_sc_hd__mux2_1
Xmapped7 n34 n35 n20 VSS VSS VDD VDD n36 sky130_fd_sc_hd__mux2_1
Xmapped8 n37 n38 n20 VSS VSS VDD VDD n39 sky130_fd_sc_hd__mux2_1
Xmapped9 n40 n41 n20 VSS VSS VDD VDD n42 sky130_fd_sc_hd__mux2_1
Xmapped10 n43 n44 n20 VSS VSS VDD VDD n45 sky130_fd_sc_hd__mux2_1
Xmapped11 WEb CSb OEb VSS VSS VDD VDD n46 sky130_fd_sc_hd__nor3b_1
Xmapped12 n47 DATA0 n46 VSS VSS VDD VDD n48 sky130_fd_sc_hd__mux2_1
Xmapped13 n49 DATA1 n46 VSS VSS VDD VDD n50 sky130_fd_sc_hd__mux2_1
Xmapped14 n51 DATA2 n46 VSS VSS VDD VDD n52 sky130_fd_sc_hd__mux2_1
Xmapped15 n53 DATA3 n46 VSS VSS VDD VDD n54 sky130_fd_sc_hd__mux2_1
Xmapped16 n55 DATA4 n46 VSS VSS VDD VDD n56 sky130_fd_sc_hd__mux2_1
Xmapped17 n57 DATA5 n46 VSS VSS VDD VDD n58 sky130_fd_sc_hd__mux2_1
Xmapped18 n59 DATA6 n46 VSS VSS VDD VDD n60 sky130_fd_sc_hd__mux2_1
Xmapped19 n61 DATA7 n46 VSS VSS VDD VDD n62 sky130_fd_sc_hd__mux2_1
Xmapped20 n20 n19 VSS VSS VDD VDD n63 sky130_fd_sc_hd__nand2_1
Xmapped21 n20 n19 VSS VSS VDD VDD n64 sky130_fd_sc_hd__nand2_1
Xmapped22 n20 n19 VSS VSS VDD VDD n65 sky130_fd_sc_hd__nand2_1
Xmapped23 n20 n19 VSS VSS VDD VDD n66 sky130_fd_sc_hd__nand2_1
Xmapped24 n20 n19 VSS VSS VDD VDD n67 sky130_fd_sc_hd__nand2_1
Xmapped25 n20 n19 VSS VSS VDD VDD n68 sky130_fd_sc_hd__nand2_1
Xmapped26 n20 n19 VSS VSS VDD VDD n69 sky130_fd_sc_hd__nand2_1
Xmapped27 CLK VSS VSS VDD VDD n70 sky130_fd_sc_hd__clkinv_1
Xmapped28 CLK VSS VSS VDD VDD n71 sky130_fd_sc_hd__clkinv_1
Xmapped29 CLK VSS VSS VDD VDD n72 sky130_fd_sc_hd__clkinv_1
Xmapped30 CLK VSS VSS VDD VDD n73 sky130_fd_sc_hd__clkinv_1
Xmapped31 CLK VSS VSS VDD VDD n74 sky130_fd_sc_hd__clkinv_1
Xmapped32 CLK VSS VSS VDD VDD n75 sky130_fd_sc_hd__clkinv_1
Xmapped33 CLK VSS VSS VDD VDD n76 sky130_fd_sc_hd__clkinv_1
Xmapped34 CLK n48 VSS VSS VDD VDD n47 sky130_fd_sc_hd__dfxtp_1
Xmapped35 CLK n50 VSS VSS VDD VDD n49 sky130_fd_sc_hd__dfxtp_1
Xmapped36 CLK n52 VSS VSS VDD VDD n51 sky130_fd_sc_hd__dfxtp_1
Xmapped37 CLK n54 VSS VSS VDD VDD n53 sky130_fd_sc_hd__dfxtp_1
Xmapped38 CLK n56 VSS VSS VDD VDD n55 sky130_fd_sc_hd__dfxtp_1
Xmapped39 CLK n58 VSS VSS VDD VDD n57 sky130_fd_sc_hd__dfxtp_1
Xmapped40 CLK n60 VSS VSS VDD VDD n59 sky130_fd_sc_hd__dfxtp_1
Xmapped41 CLK n62 VSS VSS VDD VDD n61 sky130_fd_sc_hd__dfxtp_1
Xmapped42 n18 n45 VSS VSS VDD VDD n43 sky130_fd_sc_hd__dfxtp_1
Xmapped43 n70 n42 VSS VSS VDD VDD n40 sky130_fd_sc_hd__dfxtp_1
Xmapped44 n71 n39 VSS VSS VDD VDD n37 sky130_fd_sc_hd__dfxtp_1
Xmapped45 n72 n36 VSS VSS VDD VDD n34 sky130_fd_sc_hd__dfxtp_1
Xmapped46 n73 n33 VSS VSS VDD VDD n31 sky130_fd_sc_hd__dfxtp_1
Xmapped47 n74 n30 VSS VSS VDD VDD n28 sky130_fd_sc_hd__dfxtp_1
Xmapped48 n75 n27 VSS VSS VDD VDD n25 sky130_fd_sc_hd__dfxtp_1
Xmapped49 n76 n24 VSS VSS VDD VDD n22 sky130_fd_sc_hd__dfxtp_1
Xmapped50 CLK n46 VSS VSS VDD VDD n77 sky130_fd_sc_hd__dfxtp_1
Xmapped51 CLK n19 VSS VSS VDD VDD n20 sky130_fd_sc_hd__dfxtp_1
Xmapped52 CLK ADDR0 VSS VSS VDD VDD n78 sky130_fd_sc_hd__dfxtp_1
Xmapped53 CLK ADDR1 VSS VSS VDD VDD n79 sky130_fd_sc_hd__dfxtp_1
Xmapped54 n43 n69 VSS VSS VDD VDD DATA0 sky130_fd_sc_hd__ebufn_1
Xmapped55 n40 n68 VSS VSS VDD VDD DATA1 sky130_fd_sc_hd__ebufn_1
Xmapped56 n37 n67 VSS VSS VDD VDD DATA2 sky130_fd_sc_hd__ebufn_1
Xmapped57 n34 n66 VSS VSS VDD VDD DATA3 sky130_fd_sc_hd__ebufn_1
Xmapped58 n31 n65 VSS VSS VDD VDD DATA4 sky130_fd_sc_hd__ebufn_1
Xmapped59 n28 n64 VSS VSS VDD VDD DATA5 sky130_fd_sc_hd__ebufn_1
Xmapped60 n25 n63 VSS VSS VDD VDD DATA6 sky130_fd_sc_hd__ebufn_1
Xmapped61 n22 n21 VSS VSS VDD VDD DATA7 sky130_fd_sc_hd__ebufn_1
Xmapped62 n20 n77 VSS VSS VDD VDD n80 sky130_fd_sc_hd__or2_1
Xmapped63 VDD VSS n78 n79 n93 n94 n99 n100 n47 n49 n51 n53 n55 n57 n59 n61 n85 n86 n87 n88 n89 n90 n91 n92 n44 n41 n38 n35 n32 n29 n26 n23 n95 n96 n97 n98 n81 n82 n83 n84 leaf_fabric
Xmapped64 n47 VSS VSS VDD VDD n85 sky130_fd_sc_hd__inv_1
Xmapped65 n49 VSS VSS VDD VDD n86 sky130_fd_sc_hd__inv_1
Xmapped66 n51 VSS VSS VDD VDD n87 sky130_fd_sc_hd__inv_1
Xmapped67 n53 VSS VSS VDD VDD n88 sky130_fd_sc_hd__inv_1
Xmapped68 n55 VSS VSS VDD VDD n89 sky130_fd_sc_hd__inv_1
Xmapped69 n57 VSS VSS VDD VDD n90 sky130_fd_sc_hd__inv_1
Xmapped70 n59 VSS VSS VDD VDD n91 sky130_fd_sc_hd__inv_1
Xmapped71 n61 VSS VSS VDD VDD n92 sky130_fd_sc_hd__inv_1
Xmapped72 n80 CLK n101 VSS VSS VDD VDD n93 sky130_fd_sc_hd__and3_2
Xmapped73 CLK VSS VSS VDD VDD n102 sky130_fd_sc_hd__inv_1
Xmapped74 n103 VSS VSS VDD VDD n104 sky130_fd_sc_hd__inv_1
Xmapped75 n104 VSS VSS VDD VDD n105 sky130_fd_sc_hd__inv_1
Xmapped76 n105 VSS VSS VDD VDD n106 sky130_fd_sc_hd__inv_1
Xmapped77 n106 VSS VSS VDD VDD n107 sky130_fd_sc_hd__inv_1
Xmapped78 n107 VSS VSS VDD VDD n108 sky130_fd_sc_hd__inv_1
Xmapped79 n108 VSS VSS VDD VDD n109 sky130_fd_sc_hd__inv_1
Xmapped80 n109 VSS VSS VDD VDD n110 sky130_fd_sc_hd__inv_1
Xmapped81 n110 VSS VSS VDD VDD n111 sky130_fd_sc_hd__inv_1
Xmapped82 n111 VSS VSS VDD VDD n112 sky130_fd_sc_hd__inv_1
Xmapped83 n112 VSS VSS VDD VDD n113 sky130_fd_sc_hd__inv_1
Xmapped84 n102 VSS VSS VDD VDD n114 sky130_fd_sc_hd__inv_1
Xmapped85 n113 VSS VSS VDD VDD n115 sky130_fd_sc_hd__inv_1
Xmapped86 n115 VSS VSS VDD VDD n116 sky130_fd_sc_hd__inv_1
Xmapped87 n116 VSS VSS VDD VDD n117 sky130_fd_sc_hd__inv_1
Xmapped88 n117 VSS VSS VDD VDD n118 sky130_fd_sc_hd__inv_1
Xmapped89 n118 VSS VSS VDD VDD n119 sky130_fd_sc_hd__inv_1
Xmapped90 n119 VSS VSS VDD VDD n120 sky130_fd_sc_hd__inv_1
Xmapped91 n120 VSS VSS VDD VDD n121 sky130_fd_sc_hd__inv_1
Xmapped92 n121 VSS VSS VDD VDD n122 sky130_fd_sc_hd__inv_1
Xmapped93 n122 VSS VSS VDD VDD n123 sky130_fd_sc_hd__inv_1
Xmapped94 n123 VSS VSS VDD VDD n124 sky130_fd_sc_hd__inv_1
Xmapped95 n114 VSS VSS VDD VDD n125 sky130_fd_sc_hd__inv_1
Xmapped96 n124 VSS VSS VDD VDD n126 sky130_fd_sc_hd__inv_1
Xmapped97 n126 VSS VSS VDD VDD n127 sky130_fd_sc_hd__inv_1
Xmapped98 n127 VSS VSS VDD VDD n128 sky130_fd_sc_hd__inv_1
Xmapped99 n128 VSS VSS VDD VDD n129 sky130_fd_sc_hd__inv_1
Xmapped100 n129 VSS VSS VDD VDD n130 sky130_fd_sc_hd__inv_1
Xmapped101 n130 VSS VSS VDD VDD n131 sky130_fd_sc_hd__inv_1
Xmapped102 n131 VSS VSS VDD VDD n132 sky130_fd_sc_hd__inv_1
Xmapped103 n132 VSS VSS VDD VDD n133 sky130_fd_sc_hd__inv_1
Xmapped104 n133 VSS VSS VDD VDD n134 sky130_fd_sc_hd__inv_1
Xmapped105 n134 VSS VSS VDD VDD n135 sky130_fd_sc_hd__inv_1
Xmapped106 n125 VSS VSS VDD VDD n136 sky130_fd_sc_hd__inv_1
Xmapped107 n135 VSS VSS VDD VDD n137 sky130_fd_sc_hd__inv_1
Xmapped108 n137 VSS VSS VDD VDD n138 sky130_fd_sc_hd__inv_1
Xmapped109 n138 VSS VSS VDD VDD n139 sky130_fd_sc_hd__inv_1
Xmapped110 n139 VSS VSS VDD VDD n140 sky130_fd_sc_hd__inv_1
Xmapped111 n140 VSS VSS VDD VDD n141 sky130_fd_sc_hd__inv_1
Xmapped112 n141 VSS VSS VDD VDD n142 sky130_fd_sc_hd__inv_1
Xmapped113 n142 VSS VSS VDD VDD n143 sky130_fd_sc_hd__inv_1
Xmapped114 n143 VSS VSS VDD VDD n144 sky130_fd_sc_hd__inv_1
Xmapped115 n144 VSS VSS VDD VDD n145 sky130_fd_sc_hd__inv_1
Xmapped116 n145 VSS VSS VDD VDD n146 sky130_fd_sc_hd__inv_1
Xmapped117 n136 VSS VSS VDD VDD n147 sky130_fd_sc_hd__inv_1
Xmapped118 n146 VSS VSS VDD VDD n148 sky130_fd_sc_hd__inv_1
Xmapped119 n148 VSS VSS VDD VDD n149 sky130_fd_sc_hd__inv_1
Xmapped120 n149 VSS VSS VDD VDD n150 sky130_fd_sc_hd__inv_1
Xmapped121 n150 VSS VSS VDD VDD n151 sky130_fd_sc_hd__inv_1
Xmapped122 n151 VSS VSS VDD VDD n152 sky130_fd_sc_hd__inv_1
Xmapped123 n152 VSS VSS VDD VDD n153 sky130_fd_sc_hd__inv_1
Xmapped124 n153 VSS VSS VDD VDD n154 sky130_fd_sc_hd__inv_1
Xmapped125 n154 VSS VSS VDD VDD n155 sky130_fd_sc_hd__inv_1
Xmapped126 n155 VSS VSS VDD VDD n156 sky130_fd_sc_hd__inv_1
Xmapped127 n156 VSS VSS VDD VDD n101 sky130_fd_sc_hd__inv_1
Xmapped128 n147 VSS VSS VDD VDD n157 sky130_fd_sc_hd__inv_1
Xmapped129 n101 VSS VSS VDD VDD n158 sky130_fd_sc_hd__inv_1
Xmapped130 n158 VSS VSS VDD VDD n159 sky130_fd_sc_hd__inv_1
Xmapped131 n159 VSS VSS VDD VDD n160 sky130_fd_sc_hd__inv_1
Xmapped132 n160 VSS VSS VDD VDD n161 sky130_fd_sc_hd__inv_1
Xmapped133 n161 VSS VSS VDD VDD n162 sky130_fd_sc_hd__inv_1
Xmapped134 n162 VSS VSS VDD VDD n163 sky130_fd_sc_hd__inv_1
Xmapped135 n163 VSS VSS VDD VDD n164 sky130_fd_sc_hd__inv_1
Xmapped136 n164 VSS VSS VDD VDD n165 sky130_fd_sc_hd__inv_1
Xmapped137 n165 VSS VSS VDD VDD n166 sky130_fd_sc_hd__inv_1
Xmapped138 n166 VSS VSS VDD VDD n167 sky130_fd_sc_hd__inv_1
Xmapped139 n157 VSS VSS VDD VDD n168 sky130_fd_sc_hd__inv_1
Xmapped140 n167 VSS VSS VDD VDD n169 sky130_fd_sc_hd__inv_1
Xmapped141 n169 VSS VSS VDD VDD n170 sky130_fd_sc_hd__inv_1
Xmapped142 n170 VSS VSS VDD VDD n171 sky130_fd_sc_hd__inv_1
Xmapped143 n171 VSS VSS VDD VDD n172 sky130_fd_sc_hd__inv_1
Xmapped144 n172 VSS VSS VDD VDD n173 sky130_fd_sc_hd__inv_1
Xmapped145 n173 VSS VSS VDD VDD n174 sky130_fd_sc_hd__inv_1
Xmapped146 n174 VSS VSS VDD VDD n175 sky130_fd_sc_hd__inv_1
Xmapped147 n175 VSS VSS VDD VDD n176 sky130_fd_sc_hd__inv_1
Xmapped148 n176 VSS VSS VDD VDD n177 sky130_fd_sc_hd__inv_1
Xmapped149 n177 VSS VSS VDD VDD n178 sky130_fd_sc_hd__inv_1
Xmapped150 n168 VSS VSS VDD VDD n179 sky130_fd_sc_hd__inv_1
Xmapped151 n179 VSS VSS VDD VDD n180 sky130_fd_sc_hd__inv_1
Xmapped152 n180 VSS VSS VDD VDD n103 sky130_fd_sc_hd__inv_1
Xmapped153 n80 n181 VSS VSS VDD VDD n94 sky130_fd_sc_hd__and2_4
Xmapped154 n182 n178 VSS VSS VDD VDD n181 sky130_fd_sc_hd__or2_1
Xmapped155 n81 n93 VSS VSS VDD VDD n95 sky130_fd_sc_hd__and2_1
Xmapped156 n82 n93 VSS VSS VDD VDD n96 sky130_fd_sc_hd__and2_1
Xmapped157 n83 n93 VSS VSS VDD VDD n97 sky130_fd_sc_hd__and2_1
Xmapped158 n84 n93 VSS VSS VDD VDD n98 sky130_fd_sc_hd__and2_1
Xmapped159 CLK n118 VSS VSS VDD VDD n182 sky130_fd_sc_hd__and2_1
Xmapped160 n20 n178 VSS VSS VDD VDD n99 sky130_fd_sc_hd__and2_4
Xmapped161 n77 CLK n135 VSS VSS VDD VDD n100 sky130_fd_sc_hd__and3_4
.ends sram_4x8_wrapper
