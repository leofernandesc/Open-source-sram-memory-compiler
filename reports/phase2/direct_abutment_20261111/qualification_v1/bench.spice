* Mapped synchronous SRAM with real HD control and all 32 bitcells
.lib "/opt/pdks/sky130A/libs.tech/ngspice/sky130.lib.spice" tt
.include "binding.spice"
.include "fabric.spice"
.temp 27
.options method=gear reltol=1e-4 vabstol=1e-8 iabstol=1e-12
VSS_SRC VSS 0 0
VDD_SRC VDD 0 PWL(0 0 1n 1.8)
.model HOST_SWITCH sw ron=1 roff=1e12 vt=.9 vh=.1
.model HOST_WEAK_SWITCH sw ron=1k roff=1e12 vt=.9 vh=.1
.options klu
V_CLK CLK 0 PWL(0n 0 10n 0 10.05n 1.8 20n 1.8 20.05n 0 30n 0 30.05n 1.8 40n 1.8 40.05n 0 50n 0 50.05n 1.8 60n 1.8 60.05n 0 70n 0 70.05n 1.8 80n 1.8 80.05n 0 90n 0 90.05n 1.8 100n 1.8 100.05n 0 110n 0 110.05n 1.8 120n 1.8 120.05n 0 130n 0 130.05n 1.8 140n 1.8 140.05n 0 150n 0 150.05n 1.8 160n 1.8 160.05n 0 170n 0 170.05n 1.8 180n 1.8 180.05n 0 190n 0 190.05n 1.8 200n 1.8 200.05n 0 210n 0 210.05n 1.8 220n 1.8 220.05n 0 230n 0 230.05n 1.8 240n 1.8 240.05n 0 250n 0 250.05n 1.8 260n 1.8 260.05n 0 270n 0 270.05n 1.8 280n 1.8 280.05n 0 290n 0 290.05n 1.8 300n 1.8 300.05n 0 310n 0 310.05n 1.8 320n 1.8 320.05n 0 330n 0 330.05n 1.8 340n 1.8 340.05n 0 350n 0 350.05n 1.8 360n 1.8 360.05n 0)
V_CSb CSb 0 PWL(0n 0 1n 1.8 7n 1.8 7.05n 1.8 27n 1.8 27.05n 1.8 47n 1.8 47.05n 0 67n 0 67.05n 0 87n 0 87.05n 0 107n 0 107.05n 0 127n 0 127.05n 0 142.5n 0 142.55n 1.8 144n 1.8 144.05n 0 147n 0 147.05n 0 162.5n 0 162.55n 1.8 164n 1.8 164.05n 0 167n 0 167.05n 0 187n 0 187.05n 0 202.5n 0 202.55n 1.8 204n 1.8 204.05n 0 207n 0 207.05n 0 227n 0 227.05n 0 242.5n 0 242.55n 1.8 244n 1.8 244.05n 0 247n 0 247.05n 1.8 267n 1.8 267.05n 0 282.5n 0 282.55n 1.8 284n 1.8 284.05n 0 287n 0 287.05n 0 302.5n 0 302.55n 1.8 304n 1.8 304.05n 0 307n 0 307.05n 0 322.5n 0 322.55n 1.8 324n 1.8 324.05n 0 327n 0 327.05n 0 342.5n 0 342.55n 1.8 344n 1.8 344.05n 0 347n 0 347.05n 0 362.5n 0 362.55n 1.8 364n 1.8 364.05n 0)
V_OEb OEb 0 PWL(0n 0 1n 1.8 7n 1.8 7.05n 1.8 27n 1.8 27.05n 1.8 47n 1.8 47.05n 1.8 67n 1.8 67.05n 1.8 87n 1.8 87.05n 1.8 107n 1.8 107.05n 1.8 127n 1.8 127.05n 0 147n 0 147.05n 0 167n 0 167.05n 1.8 187n 1.8 187.05n 0 207n 0 207.05n 1.8 227n 1.8 227.05n 0 247n 0 247.05n 1.8 267n 1.8 267.05n 0 287n 0 287.05n 0 307n 0 307.05n 0 327n 0 327.05n 0 347n 0 347.05n 0)
V_WEb WEb 0 PWL(0n 0 1n 1.8 7n 1.8 7.05n 1.8 27n 1.8 27.05n 1.8 47n 1.8 47.05n 0 67n 0 67.05n 0 87n 0 87.05n 0 107n 0 107.05n 0 127n 0 127.05n 1.8 147n 1.8 147.05n 1.8 167n 1.8 167.05n 0 187n 0 187.05n 1.8 207n 1.8 207.05n 0 227n 0 227.05n 1.8 247n 1.8 247.05n 1.8 267n 1.8 267.05n 1.8 287n 1.8 287.05n 1.8 307n 1.8 307.05n 1.8 327n 1.8 327.05n 1.8 347n 1.8 347.05n 1.8)
V_ADDR0 ADDR0 0 PWL(0n 0 7n 0 7.05n 0 27n 0 27.05n 0 47n 0 47.05n 0 67n 0 67.05n 1.8 87n 1.8 87.05n 0 107n 0 107.05n 1.8 127n 1.8 127.05n 0 147n 0 147.05n 1.8 167n 1.8 167.05n 0 187n 0 187.05n 0 207n 0 207.05n 1.8 227n 1.8 227.05n 1.8 247n 1.8 247.05n 0 267n 0 267.05n 0 287n 0 287.05n 1.8 307n 1.8 307.05n 0 327n 0 327.05n 1.8 347n 1.8 347.05n 1.8)
V_ADDR1 ADDR1 0 PWL(0n 0 7n 0 7.05n 0 27n 0 27.05n 0 47n 0 47.05n 0 67n 0 67.05n 0 87n 0 87.05n 1.8 107n 1.8 107.05n 1.8 127n 1.8 127.05n 0 147n 0 147.05n 0 167n 0 167.05n 0 187n 0 187.05n 0 207n 0 207.05n 0 227n 0 227.05n 0 247n 0 247.05n 0 267n 0 267.05n 0 287n 0 287.05n 0 307n 0 307.05n 1.8 327n 1.8 327.05n 1.8 347n 1.8 347.05n 1.8)
V_HOST_EN HOST_EN 0 PWL(0n 0 8n 0 8.05n 0 28n 0 28.05n 0 48n 0 48.05n 1.8 68n 1.8 68.05n 1.8 88n 1.8 88.05n 1.8 108n 1.8 108.05n 1.8 129.9n 1.8 129.95n 0 148n 0 148.05n 0 167.3n 0 167.35n 1.8 189.9n 1.8 189.95n 0 207.6n 0 207.65n 1.8 229.9n 1.8 229.95n 0 248n 0 248.05n 0 268n 0 268.05n 0 288n 0 288.05n 0 308n 0 308.05n 0 328n 0 328.05n 0 348n 0 348.05n 0)
V_HOST_WEAK_EN HOST_WEAK_EN 0 PWL(0n 0 141.5n 0 141.55n 1.8 145.5n 1.8 145.55n 0 161.5n 0 161.55n 1.8 165.5n 1.8 165.55n 0 201.5n 0 201.55n 1.8 205.5n 1.8 205.55n 0 241.5n 0 241.55n 1.8 245.5n 1.8 245.55n 0 281.5n 0 281.55n 1.8 285.5n 1.8 285.55n 0 301.5n 0 301.55n 1.8 305.5n 1.8 305.55n 0 321.5n 0 321.55n 1.8 325.5n 1.8 325.55n 0 341.5n 0 341.55n 1.8 345.5n 1.8 345.55n 0 361.5n 0 361.55n 1.8 365.5n 1.8 365.55n 0)
V_HOST0 HOST0 0 PWL(0n 0 47.1n 0 47.15n 0 67.1n 0 67.15n 1.8 87.1n 1.8 87.15n 1.8 107.1n 1.8 107.15n 0 141.2n 0 141.25n 1.8 161.2n 1.8 161.25n 0 167.1n 0 167.15n 1.8 201.2n 1.8 201.25n 0 207.1n 0 207.15n 0 241.2n 0 241.25n 1.8 281.2n 1.8 281.25n 0 301.2n 0 301.25n 1.8 321.2n 1.8 321.25n 0 341.2n 0 341.25n 1.8 361.2n 1.8 361.25n 1.8)
V_HOST1 HOST1 0 PWL(0n 0 47.1n 0 47.15n 1.8 67.1n 1.8 67.15n 0 87.1n 0 87.15n 1.8 107.1n 1.8 107.15n 0 141.2n 0 141.25n 0 161.2n 0 161.25n 1.8 167.1n 1.8 167.15n 0 201.2n 0 201.25n 1.8 207.1n 1.8 207.15n 1.8 241.2n 1.8 241.25n 0 281.2n 0 281.25n 1.8 301.2n 1.8 301.25n 0 321.2n 0 321.25n 0 341.2n 0 341.25n 1.8 361.2n 1.8 361.25n 1.8)
V_HOST2 HOST2 0 PWL(0n 0 47.1n 0 47.15n 0 67.1n 0 67.15n 1.8 87.1n 1.8 87.15n 1.8 107.1n 1.8 107.15n 0 141.2n 0 141.25n 1.8 161.2n 1.8 161.25n 0 167.1n 0 167.15n 1.8 201.2n 1.8 201.25n 0 207.1n 0 207.15n 0 241.2n 0 241.25n 1.8 281.2n 1.8 281.25n 0 301.2n 0 301.25n 1.8 321.2n 1.8 321.25n 0 341.2n 0 341.25n 1.8 361.2n 1.8 361.25n 1.8)
V_HOST3 HOST3 0 PWL(0n 0 47.1n 0 47.15n 1.8 67.1n 1.8 67.15n 0 87.1n 0 87.15n 1.8 107.1n 1.8 107.15n 0 141.2n 0 141.25n 0 161.2n 0 161.25n 1.8 167.1n 1.8 167.15n 0 201.2n 0 201.25n 1.8 207.1n 1.8 207.15n 1.8 241.2n 1.8 241.25n 0 281.2n 0 281.25n 1.8 301.2n 1.8 301.25n 0 321.2n 0 321.25n 0 341.2n 0 341.25n 1.8 361.2n 1.8 361.25n 1.8)
V_HOST4 HOST4 0 PWL(0n 0 47.1n 0 47.15n 0 67.1n 0 67.15n 1.8 87.1n 1.8 87.15n 0 107.1n 0 107.15n 1.8 141.2n 1.8 141.25n 1.8 161.2n 1.8 161.25n 0 167.1n 0 167.15n 1.8 201.2n 1.8 201.25n 0 207.1n 0 207.15n 0 241.2n 0 241.25n 1.8 281.2n 1.8 281.25n 0 301.2n 0 301.25n 1.8 321.2n 1.8 321.25n 1.8 341.2n 1.8 341.25n 0 361.2n 0 361.25n 0)
V_HOST5 HOST5 0 PWL(0n 0 47.1n 0 47.15n 1.8 67.1n 1.8 67.15n 0 87.1n 0 87.15n 0 107.1n 0 107.15n 1.8 141.2n 1.8 141.25n 0 161.2n 0 161.25n 1.8 167.1n 1.8 167.15n 0 201.2n 0 201.25n 1.8 207.1n 1.8 207.15n 1.8 241.2n 1.8 241.25n 0 281.2n 0 281.25n 1.8 301.2n 1.8 301.25n 0 321.2n 0 321.25n 1.8 341.2n 1.8 341.25n 0 361.2n 0 361.25n 0)
V_HOST6 HOST6 0 PWL(0n 0 47.1n 0 47.15n 0 67.1n 0 67.15n 1.8 87.1n 1.8 87.15n 0 107.1n 0 107.15n 1.8 141.2n 1.8 141.25n 1.8 161.2n 1.8 161.25n 0 167.1n 0 167.15n 1.8 201.2n 1.8 201.25n 0 207.1n 0 207.15n 0 241.2n 0 241.25n 1.8 281.2n 1.8 281.25n 0 301.2n 0 301.25n 1.8 321.2n 1.8 321.25n 1.8 341.2n 1.8 341.25n 0 361.2n 0 361.25n 0)
V_HOST7 HOST7 0 PWL(0n 0 47.1n 0 47.15n 1.8 67.1n 1.8 67.15n 0 87.1n 0 87.15n 0 107.1n 0 107.15n 1.8 141.2n 1.8 141.25n 0 161.2n 0 161.25n 1.8 167.1n 1.8 167.15n 0 201.2n 0 201.25n 1.8 207.1n 1.8 207.15n 1.8 241.2n 1.8 241.25n 0 281.2n 0 281.25n 1.8 301.2n 1.8 301.25n 0 321.2n 0 321.25n 1.8 341.2n 1.8 341.25n 0 361.2n 0 361.25n 0)
S_HOST0 METER_HOST0 HOST0 HOST_EN 0 HOST_SWITCH
v_sense_host0 METER_HOST0 DATA0 0
S_WEAK0 METER_WEAK0 HOST0 HOST_WEAK_EN 0 HOST_WEAK_SWITCH
v_sense_weak0 METER_WEAK0 DATA0 0
S_HOST1 METER_HOST1 HOST1 HOST_EN 0 HOST_SWITCH
v_sense_host1 METER_HOST1 DATA1 0
S_WEAK1 METER_WEAK1 HOST1 HOST_WEAK_EN 0 HOST_WEAK_SWITCH
v_sense_weak1 METER_WEAK1 DATA1 0
S_HOST2 METER_HOST2 HOST2 HOST_EN 0 HOST_SWITCH
v_sense_host2 METER_HOST2 DATA2 0
S_WEAK2 METER_WEAK2 HOST2 HOST_WEAK_EN 0 HOST_WEAK_SWITCH
v_sense_weak2 METER_WEAK2 DATA2 0
S_HOST3 METER_HOST3 HOST3 HOST_EN 0 HOST_SWITCH
v_sense_host3 METER_HOST3 DATA3 0
S_WEAK3 METER_WEAK3 HOST3 HOST_WEAK_EN 0 HOST_WEAK_SWITCH
v_sense_weak3 METER_WEAK3 DATA3 0
S_HOST4 METER_HOST4 HOST4 HOST_EN 0 HOST_SWITCH
v_sense_host4 METER_HOST4 DATA4 0
S_WEAK4 METER_WEAK4 HOST4 HOST_WEAK_EN 0 HOST_WEAK_SWITCH
v_sense_weak4 METER_WEAK4 DATA4 0
S_HOST5 METER_HOST5 HOST5 HOST_EN 0 HOST_SWITCH
v_sense_host5 METER_HOST5 DATA5 0
S_WEAK5 METER_WEAK5 HOST5 HOST_WEAK_EN 0 HOST_WEAK_SWITCH
v_sense_weak5 METER_WEAK5 DATA5 0
S_HOST6 METER_HOST6 HOST6 HOST_EN 0 HOST_SWITCH
v_sense_host6 METER_HOST6 DATA6 0
S_WEAK6 METER_WEAK6 HOST6 HOST_WEAK_EN 0 HOST_WEAK_SWITCH
v_sense_weak6 METER_WEAK6 DATA6 0
S_HOST7 METER_HOST7 HOST7 HOST_EN 0 HOST_SWITCH
v_sense_host7 METER_HOST7 DATA7 0
S_WEAK7 METER_WEAK7 HOST7 HOST_WEAK_EN 0 HOST_WEAK_SWITCH
v_sense_weak7 METER_WEAK7 DATA7 0
XDUT ADDR0 ADDR1 CLK CSb DATA0 DATA1 DATA2 DATA3 DATA4 DATA5 DATA6 DATA7 OEb VDD VSS WEb sram_4x8_wrapper
.save v(DATA0) v(DATA1) v(DATA2) v(DATA3) v(DATA4) v(DATA5) v(DATA6) v(DATA7) v(xdut.e635) v(xdut.e717) v(xdut.e728) v(xdut.e729) v(xdut.e607) v(xdut.e608) v(xdut.e609) v(xdut.e585) v(xdut.e26) v(xdut.e25) v(xdut.e24) v(xdut.e23) v(xdut.e22) v(xdut.e21) v(xdut.e20) v(xdut.e19) v(xdut.e69) v(xdut.e16) v(xdut.e50) v(xdut.e51) v(xdut.e52) v(xdut.e636) v(xdut.e53) v(xdut.e54) v(xdut.e55) v(xdut.e56) v(xdut.e57) v(xdut.e59) v(xdut.e60) v(xdut.e61) v(xdut.e62) v(xdut.e63) v(xdut.e64) v(xdut.e65) v(VDD) v(CLK) v(CSb) v(OEb) v(WEb) v(HOST_EN) v(xdut.e610) v(xdut.e611) v(xdut.e612) v(xdut.e613) v(xdut.e614) v(xdut.e615) v(xdut.e616) v(xdut.e617) v(xdut.e618) v(xdut.e619) v(xdut.e620) v(xdut.e621) v(xdut.e622) v(xdut.e623) v(xdut.e624) v(xdut.e625) v(xdut.e591) v(xdut.e592) v(xdut.e593) v(xdut.e594) v(xdut.e67) v(xdut.e66) v(xdut.e58) v(xdut.e72) v(xdut.e73) v(xdut.e74) v(xdut.e75) v(xdut.e76) v(xdut.e77) v(xdut.e78) v(xdut.e97) v(xdut.e112) v(xdut.e176) v(xdut.e238) v(xdut.e291) v(xdut.e346) v(xdut.e385) v(xdut.e418) v(xdut.e98) v(xdut.e113) v(xdut.e177) v(xdut.e239) v(xdut.e292) v(xdut.e347) v(xdut.e386) v(xdut.e419) v(xdut.e99) v(xdut.e114) v(xdut.e178) v(xdut.e240) v(xdut.e293) v(xdut.e348) v(xdut.e387) v(xdut.e420) v(xdut.e100) v(xdut.e115) v(xdut.e179) v(xdut.e241) v(xdut.e294) v(xdut.e349) v(xdut.e388) v(xdut.e421) v(xdut.e28) v(xdut.e30) v(xdut.e32) v(xdut.e34) v(xdut.e36) v(xdut.e38) v(xdut.e40) v(xdut.e42) v(xdut.e68) v(xdut.e70) v(xdut.e71) v(xdut.e49) v(xdut.e48) v(xdut.e47) v(xdut.e46) v(xdut.e45) v(xdut.e44) v(xdut.e18) v(HOST_WEAK_EN) v(HOST0) i(v_sense_host0) i(v_sense_weak0) v(HOST1) i(v_sense_host1) i(v_sense_weak1) v(HOST2) i(v_sense_host2) i(v_sense_weak2) v(HOST3) i(v_sense_host3) i(v_sense_weak3) v(HOST4) i(v_sense_host4) i(v_sense_weak4) v(HOST5) i(v_sense_host5) i(v_sense_weak5) v(HOST6) i(v_sense_host6) i(v_sense_weak6) v(HOST7) i(v_sense_host7) i(v_sense_weak7)
.control
set num_threads=1
set noaskquit
set wr_singlescale
set wr_vecnames
tran 10p 370n 0 10p
wrdata waveform.dat v(DATA0) v(DATA1) v(DATA2) v(DATA3) v(DATA4) v(DATA5) v(DATA6) v(DATA7) v(xdut.e635) v(xdut.e717) v(xdut.e728) v(xdut.e729) v(xdut.e607) v(xdut.e608) v(xdut.e609) v(xdut.e585) v(xdut.e26) v(xdut.e25) v(xdut.e24) v(xdut.e23) v(xdut.e22) v(xdut.e21) v(xdut.e20) v(xdut.e19) v(xdut.e69) v(xdut.e16) v(xdut.e50) v(xdut.e51) v(xdut.e52) v(xdut.e636) v(xdut.e53) v(xdut.e54) v(xdut.e55) v(xdut.e56) v(xdut.e57) v(xdut.e59) v(xdut.e60) v(xdut.e61) v(xdut.e62) v(xdut.e63) v(xdut.e64) v(xdut.e65) v(VDD) v(CLK) v(CSb) v(OEb) v(WEb) v(HOST_EN) v(xdut.e610) v(xdut.e611) v(xdut.e612) v(xdut.e613) v(xdut.e614) v(xdut.e615) v(xdut.e616) v(xdut.e617) v(xdut.e618) v(xdut.e619) v(xdut.e620) v(xdut.e621) v(xdut.e622) v(xdut.e623) v(xdut.e624) v(xdut.e625) v(xdut.e591) v(xdut.e592) v(xdut.e593) v(xdut.e594) v(xdut.e67) v(xdut.e66) v(xdut.e58) v(xdut.e72) v(xdut.e73) v(xdut.e74) v(xdut.e75) v(xdut.e76) v(xdut.e77) v(xdut.e78) v(xdut.e97) v(xdut.e112) v(xdut.e176) v(xdut.e238) v(xdut.e291) v(xdut.e346) v(xdut.e385) v(xdut.e418) v(xdut.e98) v(xdut.e113) v(xdut.e177) v(xdut.e239) v(xdut.e292) v(xdut.e347) v(xdut.e386) v(xdut.e419) v(xdut.e99) v(xdut.e114) v(xdut.e178) v(xdut.e240) v(xdut.e293) v(xdut.e348) v(xdut.e387) v(xdut.e420) v(xdut.e100) v(xdut.e115) v(xdut.e179) v(xdut.e241) v(xdut.e294) v(xdut.e349) v(xdut.e388) v(xdut.e421) v(xdut.e28) v(xdut.e30) v(xdut.e32) v(xdut.e34) v(xdut.e36) v(xdut.e38) v(xdut.e40) v(xdut.e42) v(xdut.e68) v(xdut.e70) v(xdut.e71) v(xdut.e49) v(xdut.e48) v(xdut.e47) v(xdut.e46) v(xdut.e45) v(xdut.e44) v(xdut.e18) v(HOST_WEAK_EN) v(HOST0) i(v_sense_host0) i(v_sense_weak0) v(HOST1) i(v_sense_host1) i(v_sense_weak1) v(HOST2) i(v_sense_host2) i(v_sense_weak2) v(HOST3) i(v_sense_host3) i(v_sense_weak3) v(HOST4) i(v_sense_host4) i(v_sense_weak4) v(HOST5) i(v_sense_host5) i(v_sense_weak5) v(HOST6) i(v_sense_host6) i(v_sense_weak6) v(HOST7) i(v_sense_host7) i(v_sense_weak7)
quit
.endc
.end
