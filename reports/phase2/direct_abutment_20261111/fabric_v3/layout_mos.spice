.model sky130_fd_pr__nfet_01v8 nmos
.model sky130_fd_pr__pfet_01v8 pmos
.model sky130_fd_pr__pfet_01v8_hvt pmos
.model sky130_fd_pr__special_nfet_01v8 nmos
.subckt leaf_fabric VDD VSS A0 A1 PCLK PRECH SCLK WE DIN0 DIN1 DIN2 DIN3 DIN4 DIN5 DIN6 DIN7 DIN_B0 DIN_B1 DIN_B2 DIN_B3 DIN_B4 DIN_B5 DIN_B6 DIN_B7 DOUT0 DOUT1 DOUT2 DOUT3 DOUT4 DOUT5 DOUT6 DOUT7 ROW0 ROW1 ROW2 ROW3 DEC0 DEC1 DEC2 DEC3
M0 a_617_39736# a_665_39824# VSS VSS sky130_fd_pr__nfet_01v8 w=1.26u l=0.15u
M1 a_14465_39824# a_14417_39736# VDD VDD sky130_fd_pr__pfet_01v8 w=0.42u l=0.15u
M2 a_14465_37024# a_14417_36936# VDD VDD sky130_fd_pr__pfet_01v8 w=0.42u l=0.15u
M3 VSS WE a_45015_9496# VSS sky130_fd_pr__nfet_01v8 w=5.04u l=0.15u
M4 a_14465_39824# wl_driver_1.WL write_driver_4.BL VSS sky130_fd_pr__nfet_01v8 w=0.6u l=0.15u
M5 a_665_39824# a_617_39736# VDD VDD sky130_fd_pr__pfet_01v8 w=0.42u l=0.15u
M6 VDD WE a_6227_13916# VDD sky130_fd_pr__pfet_01v8 w=0.84u l=0.15u
M7 a_665_37024# a_617_36936# VDD VDD sky130_fd_pr__pfet_01v8 w=0.42u l=0.15u
M8 a_14465_45424# a_14417_45336# VDD VDD sky130_fd_pr__pfet_01v8 w=0.42u l=0.15u
M9 a_21015_9496# DIN3 write_driver_3.BLB VSS sky130_fd_pr__nfet_01v8 w=5.04u l=0.15u
M10 a_25415_9496# DIN_B4 write_driver_4.BL VSS sky130_fd_pr__nfet_01v8 w=5.04u l=0.15u
M11 a_10967_36936# a_11015_37024# VSS VSS sky130_fd_pr__nfet_01v8 w=1.26u l=0.15u
M12 VSS SCLK a_24615_19902# VSS sky130_fd_pr__nfet_01v8 w=0.98u l=0.15u
M13 a_665_45424# a_617_45336# VDD VDD sky130_fd_pr__pfet_01v8 w=0.42u l=0.15u
M14 VDD DOUT1 sense_amp_1.SA_OUTB VDD sky130_fd_pr__pfet_01v8 w=1.89u l=0.15u
M15 a_10967_45336# a_11015_45424# VSS VSS sky130_fd_pr__nfet_01v8 w=1.26u l=0.15u
M16 write_driver_4.BLB PRECH write_driver_4.BL VDD sky130_fd_pr__pfet_01v8 w=2.52u l=0.15u
M17 a_617_42536# a_665_42624# VSS VSS sky130_fd_pr__nfet_01v8 w=1.26u l=0.15u
M18 VDD a_18227_13916# a_20627_13496# VDD sky130_fd_pr__pfet_01v8 w=5.04u l=0.15u
M19 a_31027_13496# DIN_B5 write_driver_5.BL VDD sky130_fd_pr__pfet_01v8 w=5.04u l=0.15u
M20 a_36615_19902# sense_amp_6.SA_OUTB DOUT6 VSS sky130_fd_pr__nfet_01v8 w=0.98u l=0.15u
M21 a_4067_42536# a_4115_42624# VDD VDD sky130_fd_pr__pfet_01v8 w=0.42u l=0.15u
M22 a_14465_42624# wl_driver_2.WL write_driver_4.BL VSS sky130_fd_pr__nfet_01v8 w=0.6u l=0.15u
M23 VDD PRECH write_driver_7.BL VDD sky130_fd_pr__pfet_01v8 w=2.52u l=0.15u
M24 VDD PRECH write_driver_5.BLB VDD sky130_fd_pr__pfet_01v8 w=2.52u l=0.15u
M25 a_14417_39736# a_14465_39824# VSS VSS sky130_fd_pr__nfet_01v8 w=1.26u l=0.15u
M26 a_24767_39736# wl_driver_1.WL write_driver_7.BLB VSS sky130_fd_pr__nfet_01v8 w=0.6u l=0.15u
M27 a_26627_13496# DIN4 write_driver_4.BLB VDD sky130_fd_pr__pfet_01v8 w=5.04u l=0.15u
M28 VDD a_36227_13916# a_38627_13496# VDD sky130_fd_pr__pfet_01v8 w=5.04u l=0.15u
M29 VDD row_decoder_0.A0B row_decoder_0.A0T VDD sky130_fd_pr__pfet_01v8 w=2u l=0.15u
M30 VDD WE a_12227_13916# VDD sky130_fd_pr__pfet_01v8 w=0.84u l=0.15u
M31 VSS WE a_15015_9496# VSS sky130_fd_pr__nfet_01v8 w=5.04u l=0.15u
M32 a_17915_39824# a_17867_39736# VSS VSS sky130_fd_pr__nfet_01v8 w=1.26u l=0.15u
M33 a_21317_36936# a_21365_37024# VSS VSS sky130_fd_pr__nfet_01v8 w=1.26u l=0.15u
M34 VDD sense_amp_0.SA_OUTB DOUT0 VDD sky130_fd_pr__pfet_01v8 w=1.89u l=0.15u
M35 a_21365_39824# a_21317_39736# VSS VSS sky130_fd_pr__nfet_01v8 w=1.26u l=0.15u
M36 VDD sense_amp_4.SA_OUTB DOUT4 VDD sky130_fd_pr__pfet_01v8 w=1.89u l=0.15u
M37 a_21317_45336# a_21365_45424# VSS VSS sky130_fd_pr__nfet_01v8 w=1.26u l=0.15u
M38 VDD DOUT2 sense_amp_2.SA_OUTB VDD sky130_fd_pr__pfet_01v8 w=1.89u l=0.15u
M39 VSS a_n6773_34432# wl_driver_0.WL VSS sky130_fd_pr__nfet_01v8 w=5.04u l=0.15u
M40 VSS a_n6773_49432# bitcell_6t_24.WL VSS sky130_fd_pr__nfet_01v8 w=5.04u l=0.15u
M41 write_driver_7.BLB SCLK sense_amp_7.SA_OUTB VDD sky130_fd_pr__pfet_01v8 w=2u l=0.15u
M42 a_14417_42536# a_14465_42624# VSS VSS sky130_fd_pr__nfet_01v8 w=1.26u l=0.15u
M43 a_17867_42536# a_17915_42624# VDD VDD sky130_fd_pr__pfet_01v8 w=0.42u l=0.15u
M44 a_24767_42536# wl_driver_2.WL write_driver_7.BLB VSS sky130_fd_pr__nfet_01v8 w=0.6u l=0.15u
M45 a_36615_19902# DOUT6 sense_amp_6.SA_OUTB VSS sky130_fd_pr__nfet_01v8 w=0.98u l=0.15u
M46 a_7517_39736# a_7565_39824# VDD VDD sky130_fd_pr__pfet_01v8 w=0.42u l=0.15u
M47 a_17915_42624# a_17867_42536# VSS VSS sky130_fd_pr__nfet_01v8 w=1.26u l=0.15u
M48 a_21317_42536# a_21365_42624# VDD VDD sky130_fd_pr__pfet_01v8 w=0.42u l=0.15u
M49 a_7517_36936# a_7565_37024# VDD VDD sky130_fd_pr__pfet_01v8 w=0.42u l=0.15u
M50 a_21365_42624# a_21317_42536# VSS VSS sky130_fd_pr__nfet_01v8 w=1.26u l=0.15u
M51 a_7565_37024# a_7517_36936# VSS VSS sky130_fd_pr__nfet_01v8 w=1.26u l=0.15u
M52 a_7517_45336# a_7565_45424# VDD VDD sky130_fd_pr__pfet_01v8 w=0.42u l=0.15u
M53 a_11015_39824# a_10967_39736# VSS VSS sky130_fd_pr__nfet_01v8 w=1.26u l=0.15u
M54 VSS ROW3 a_n6773_49432# VSS sky130_fd_pr__nfet_01v8 w=1.68u l=0.15u
M55 VSS ROW0 a_n6773_34432# VSS sky130_fd_pr__nfet_01v8 w=1.68u l=0.15u
M56 a_7565_45424# a_7517_45336# VSS VSS sky130_fd_pr__nfet_01v8 w=1.26u l=0.15u
M57 row_decoder_0.net3 row_decoder_0.A1T row_decoder_0.N2 VSS sky130_fd_pr__nfet_01v8 w=2u l=0.15u
M58 VSS SCLK a_18615_19902# VSS sky130_fd_pr__nfet_01v8 w=0.98u l=0.15u
M59 a_43415_9496# DIN_B7 write_driver_7.BL VSS sky130_fd_pr__nfet_01v8 w=5.04u l=0.15u
M60 VDD DOUT0 sense_amp_0.SA_OUTB VDD sky130_fd_pr__pfet_01v8 w=1.89u l=0.15u
M61 a_4115_39824# a_4067_39736# VDD VDD sky130_fd_pr__pfet_01v8 w=0.42u l=0.15u
M62 a_10967_42536# a_11015_42624# VDD VDD sky130_fd_pr__pfet_01v8 w=0.42u l=0.15u
M63 a_4115_37024# a_4067_36936# VDD VDD sky130_fd_pr__pfet_01v8 w=0.42u l=0.15u
M64 a_30615_19902# sense_amp_5.SA_OUTB DOUT5 VSS sky130_fd_pr__nfet_01v8 w=0.98u l=0.15u
M65 a_4067_36936# wl_driver_0.WL write_driver_1.BLB VSS sky130_fd_pr__nfet_01v8 w=0.6u l=0.15u
M66 VSS SCLK a_36615_19902# VSS sky130_fd_pr__nfet_01v8 w=0.98u l=0.15u
M67 a_617_39736# a_665_39824# VDD VDD sky130_fd_pr__pfet_01v8 w=0.42u l=0.15u
M68 VDD a_18227_13916# a_19027_13496# VDD sky130_fd_pr__pfet_01v8 w=5.04u l=0.15u
M69 a_11015_42624# a_10967_42536# VSS VSS sky130_fd_pr__nfet_01v8 w=1.26u l=0.15u
M70 a_4115_39824# wl_driver_1.WL write_driver_1.BL VSS sky130_fd_pr__nfet_01v8 w=0.6u l=0.15u
M71 a_617_36936# a_665_37024# VDD VDD sky130_fd_pr__pfet_01v8 w=0.42u l=0.15u
M72 a_4115_45424# a_4067_45336# VDD VDD sky130_fd_pr__pfet_01v8 w=0.42u l=0.15u
M73 VSS WE a_18227_13916# VSS sky130_fd_pr__nfet_01v8 w=0.84u l=0.15u
M74 DOUT3 SCLK write_driver_3.BL VDD sky130_fd_pr__pfet_01v8 w=2u l=0.15u
M75 write_driver_6.BLB PRECH write_driver_6.BL VDD sky130_fd_pr__pfet_01v8 w=2.52u l=0.15u
M76 a_4067_45336# bitcell_6t_24.WL write_driver_1.BLB VSS sky130_fd_pr__nfet_01v8 w=0.6u l=0.15u
M77 row_decoder_0.EVAL_GND row_decoder_0.A0T row_decoder_0.net4 VSS sky130_fd_pr__nfet_01v8 w=2u l=0.15u
M78 a_43027_13496# DIN_B7 write_driver_7.BL VDD sky130_fd_pr__pfet_01v8 w=5.04u l=0.15u
M79 a_617_45336# a_665_45424# VDD VDD sky130_fd_pr__pfet_01v8 w=0.42u l=0.15u
M80 a_20627_13496# DIN3 write_driver_3.BLB VDD sky130_fd_pr__pfet_01v8 w=5.04u l=0.15u
M81 VDD a_30227_13916# a_32627_13496# VDD sky130_fd_pr__pfet_01v8 w=5.04u l=0.15u
M82 VSS WE a_33015_9496# VSS sky130_fd_pr__nfet_01v8 w=5.04u l=0.15u
M83 VSS WE a_37415_9496# VSS sky130_fd_pr__nfet_01v8 w=5.04u l=0.15u
M84 VDD PRECH write_driver_7.BLB VDD sky130_fd_pr__pfet_01v8 w=2.52u l=0.15u
M85 VDD WE a_227_13916# VDD sky130_fd_pr__pfet_01v8 w=0.84u l=0.15u
M86 a_7517_39736# wl_driver_1.WL write_driver_2.BLB VSS sky130_fd_pr__nfet_01v8 w=0.6u l=0.15u
M87 a_24815_42624# a_24767_42536# VDD VDD sky130_fd_pr__pfet_01v8 w=0.42u l=0.15u
M88 a_13415_9496# DIN_B2 write_driver_2.BL VSS sky130_fd_pr__nfet_01v8 w=5.04u l=0.15u
M89 a_38627_13496# DIN6 write_driver_6.BLB VDD sky130_fd_pr__pfet_01v8 w=5.04u l=0.15u
M90 VDD WE a_24227_13916# VDD sky130_fd_pr__pfet_01v8 w=0.84u l=0.15u
M91 a_4115_42624# wl_driver_2.WL write_driver_1.BL VSS sky130_fd_pr__nfet_01v8 w=0.6u l=0.15u
M92 a_17867_36936# wl_driver_0.WL write_driver_5.BLB VSS sky130_fd_pr__nfet_01v8 w=0.6u l=0.15u
M93 a_14417_39736# a_14465_39824# VDD VDD sky130_fd_pr__pfet_01v8 w=0.42u l=0.15u
M94 a_30615_19902# DOUT5 sense_amp_5.SA_OUTB VSS sky130_fd_pr__nfet_01v8 w=0.98u l=0.15u
M95 VDD sense_amp_6.SA_OUTB DOUT6 VDD sky130_fd_pr__pfet_01v8 w=1.89u l=0.15u
M96 VDD DOUT4 sense_amp_4.SA_OUTB VDD sky130_fd_pr__pfet_01v8 w=1.89u l=0.15u
M97 a_17915_39824# wl_driver_1.WL write_driver_5.BL VSS sky130_fd_pr__nfet_01v8 w=0.6u l=0.15u
M98 a_21317_36936# wl_driver_0.WL write_driver_6.BLB VSS sky130_fd_pr__nfet_01v8 w=0.6u l=0.15u
M99 a_14417_36936# a_14465_37024# VDD VDD sky130_fd_pr__pfet_01v8 w=0.42u l=0.15u
M100 VDD a_6227_13916# a_7027_13496# VDD sky130_fd_pr__pfet_01v8 w=5.04u l=0.15u
M101 a_14465_37024# a_14417_36936# VSS VSS sky130_fd_pr__nfet_01v8 w=1.26u l=0.15u
M102 a_17867_45336# bitcell_6t_24.WL write_driver_5.BLB VSS sky130_fd_pr__nfet_01v8 w=0.6u l=0.15u
M103 a_24815_37024# wl_driver_0.WL write_driver_7.BL VSS sky130_fd_pr__nfet_01v8 w=0.6u l=0.15u
M104 a_7517_42536# wl_driver_2.WL write_driver_2.BLB VSS sky130_fd_pr__nfet_01v8 w=0.6u l=0.15u
M105 a_14417_45336# a_14465_45424# VDD VDD sky130_fd_pr__pfet_01v8 w=0.42u l=0.15u
M106 a_39015_9496# DIN6 write_driver_6.BLB VSS sky130_fd_pr__nfet_01v8 w=5.04u l=0.15u
M107 row_decoder_0.EVAL_GND row_decoder_0.A0B row_decoder_0.net3 VSS sky130_fd_pr__nfet_01v8 w=2u l=0.15u
M108 a_21317_45336# bitcell_6t_24.WL write_driver_6.BLB VSS sky130_fd_pr__nfet_01v8 w=0.6u l=0.15u
M109 DOUT1 SCLK write_driver_1.BL VDD sky130_fd_pr__pfet_01v8 w=2u l=0.15u
M110 a_665_37024# a_617_36936# VSS VSS sky130_fd_pr__nfet_01v8 w=1.26u l=0.15u
M111 a_14465_45424# a_14417_45336# VSS VSS sky130_fd_pr__nfet_01v8 w=1.26u l=0.15u
M112 VSS a_n6773_44432# wl_driver_2.WL VSS sky130_fd_pr__nfet_01v8 w=5.04u l=0.15u
M113 a_24815_45424# bitcell_6t_24.WL write_driver_7.BL VSS sky130_fd_pr__nfet_01v8 w=0.6u l=0.15u
M114 a_617_39736# wl_driver_1.WL write_driver_0.BLB VSS sky130_fd_pr__nfet_01v8 w=0.6u l=0.15u
M115 a_665_45424# a_617_45336# VSS VSS sky130_fd_pr__nfet_01v8 w=1.26u l=0.15u
M116 VDD row_decoder_0.A1B row_decoder_0.A1T VDD sky130_fd_pr__pfet_01v8 w=2u l=0.15u
M117 a_17915_42624# wl_driver_2.WL write_driver_5.BL VSS sky130_fd_pr__nfet_01v8 w=0.6u l=0.15u
M118 a_10967_36936# wl_driver_0.WL write_driver_3.BLB VSS sky130_fd_pr__nfet_01v8 w=0.6u l=0.15u
M119 VDD PRECH write_driver_3.BL VDD sky130_fd_pr__pfet_01v8 w=2.52u l=0.15u
M120 VSS SCLK a_30615_19902# VSS sky130_fd_pr__nfet_01v8 w=0.98u l=0.15u
M121 a_24767_36936# a_24815_37024# VSS VSS sky130_fd_pr__nfet_01v8 w=1.26u l=0.15u
M122 a_11015_39824# wl_driver_1.WL write_driver_3.BL VSS sky130_fd_pr__nfet_01v8 w=0.6u l=0.15u
M123 VDD a_12227_13916# a_13027_13496# VDD sky130_fd_pr__pfet_01v8 w=5.04u l=0.15u
M124 VSS ROW2 a_n6773_44432# VSS sky130_fd_pr__nfet_01v8 w=1.68u l=0.15u
M125 a_10967_45336# bitcell_6t_24.WL write_driver_3.BLB VSS sky130_fd_pr__nfet_01v8 w=0.6u l=0.15u
M126 DOUT2 SCLK write_driver_2.BL VDD sky130_fd_pr__pfet_01v8 w=2u l=0.15u
M127 write_driver_5.BLB PRECH write_driver_5.BL VDD sky130_fd_pr__pfet_01v8 w=2.52u l=0.15u
M128 a_617_42536# wl_driver_2.WL write_driver_0.BLB VSS sky130_fd_pr__nfet_01v8 w=0.6u l=0.15u
M129 VSS WE a_36227_13916# VSS sky130_fd_pr__nfet_01v8 w=0.84u l=0.15u
M130 a_24767_45336# a_24815_45424# VSS VSS sky130_fd_pr__nfet_01v8 w=1.26u l=0.15u
M131 VSS row_decoder_0.A0B row_decoder_0.A0T VSS sky130_fd_pr__nfet_01v8 w=2u l=0.15u
M132 a_42615_19902# sense_amp_7.SA_OUTB DOUT7 VSS sky130_fd_pr__nfet_01v8 w=0.98u l=0.15u
M133 a_14417_39736# wl_driver_1.WL write_driver_4.BLB VSS sky130_fd_pr__nfet_01v8 w=0.6u l=0.15u
M134 a_4067_39736# a_4115_39824# VSS VSS sky130_fd_pr__nfet_01v8 w=1.26u l=0.15u
M135 a_17915_39824# a_17867_39736# VDD VDD sky130_fd_pr__pfet_01v8 w=0.42u l=0.15u
M136 VSS WE a_3015_9496# VSS sky130_fd_pr__nfet_01v8 w=5.04u l=0.15u
M137 VDD DEC3 row_decoder_0.N3 VDD sky130_fd_pr__pfet_01v8 w=0.84u l=0.15u
M138 VSS WE a_7415_9496# VSS sky130_fd_pr__nfet_01v8 w=5.04u l=0.15u
M139 a_17915_37024# a_17867_36936# VDD VDD sky130_fd_pr__pfet_01v8 w=0.42u l=0.15u
M140 a_21365_39824# a_21317_39736# VDD VDD sky130_fd_pr__pfet_01v8 w=0.42u l=0.15u
M141 a_32627_13496# DIN5 write_driver_5.BLB VDD sky130_fd_pr__pfet_01v8 w=5.04u l=0.15u
M142 VDD a_42227_13916# a_44627_13496# VDD sky130_fd_pr__pfet_01v8 w=5.04u l=0.15u
M143 a_31415_9496# DIN_B5 write_driver_5.BL VSS sky130_fd_pr__nfet_01v8 w=5.04u l=0.15u
M144 a_11015_42624# wl_driver_2.WL write_driver_3.BL VSS sky130_fd_pr__nfet_01v8 w=0.6u l=0.15u
M145 a_21365_37024# a_21317_36936# VDD VDD sky130_fd_pr__pfet_01v8 w=0.42u l=0.15u
M146 a_17915_45424# a_17867_45336# VDD VDD sky130_fd_pr__pfet_01v8 w=0.42u l=0.15u
M147 a_21365_39824# wl_driver_1.WL write_driver_6.BL VSS sky130_fd_pr__nfet_01v8 w=0.6u l=0.15u
M148 VDD A0 row_decoder_0.A0B VDD sky130_fd_pr__pfet_01v8 w=0.84u l=0.15u
M149 a_7565_42624# a_7517_42536# VDD VDD sky130_fd_pr__pfet_01v8 w=0.42u l=0.15u
M150 a_21365_45424# a_21317_45336# VDD VDD sky130_fd_pr__pfet_01v8 w=0.42u l=0.15u
M151 VSS row_decoder_0.N2 DEC2 VSS sky130_fd_pr__nfet_01v8 w=2u l=0.15u
M152 VDD sense_amp_5.SA_OUTB DOUT5 VDD sky130_fd_pr__pfet_01v8 w=1.89u l=0.15u
M153 VDD a_n6773_39432# wl_driver_1.WL VDD sky130_fd_pr__pfet_01v8 w=5.04u l=0.15u
M154 VDD PRECH write_driver_1.BL VDD sky130_fd_pr__pfet_01v8 w=2.52u l=0.15u
M155 VDD WE a_36227_13916# VDD sky130_fd_pr__pfet_01v8 w=0.84u l=0.15u
M156 VSS WE a_227_13916# VSS sky130_fd_pr__nfet_01v8 w=0.84u l=0.15u
M157 VDD a_227_13916# a_1027_13496# VDD sky130_fd_pr__pfet_01v8 w=5.04u l=0.15u
M158 a_14417_42536# wl_driver_2.WL write_driver_4.BLB VSS sky130_fd_pr__nfet_01v8 w=0.6u l=0.15u
M159 a_4067_42536# a_4115_42624# VSS VSS sky130_fd_pr__nfet_01v8 w=1.26u l=0.15u
M160 DOUT0 SCLK write_driver_0.BL VDD sky130_fd_pr__pfet_01v8 w=2u l=0.15u
M161 a_42615_19902# DOUT7 sense_amp_7.SA_OUTB VSS sky130_fd_pr__nfet_01v8 w=0.98u l=0.15u
M162 VDD DOUT6 sense_amp_6.SA_OUTB VDD sky130_fd_pr__pfet_01v8 w=1.89u l=0.15u
M163 a_9015_9496# DIN1 write_driver_1.BLB VSS sky130_fd_pr__nfet_01v8 w=5.04u l=0.15u
M164 VSS WE a_21015_9496# VSS sky130_fd_pr__nfet_01v8 w=5.04u l=0.15u
M165 a_17867_39736# a_17915_39824# VSS VSS sky130_fd_pr__nfet_01v8 w=1.26u l=0.15u
M166 VSS WE a_25415_9496# VSS sky130_fd_pr__nfet_01v8 w=5.04u l=0.15u
M167 a_11015_39824# a_10967_39736# VDD VDD sky130_fd_pr__pfet_01v8 w=0.42u l=0.15u
M168 a_21365_42624# wl_driver_2.WL write_driver_6.BL VSS sky130_fd_pr__nfet_01v8 w=0.6u l=0.15u
M169 a_7565_37024# wl_driver_0.WL write_driver_2.BL VSS sky130_fd_pr__nfet_01v8 w=0.6u l=0.15u
M170 a_11015_37024# a_10967_36936# VDD VDD sky130_fd_pr__pfet_01v8 w=0.42u l=0.15u
M171 VSS row_decoder_0.N3 DEC3 VSS sky130_fd_pr__nfet_01v8 w=2u l=0.15u
M172 VDD row_decoder_0.N2 DEC2 VDD sky130_fd_pr__pfet_01v8 w=3u l=0.15u
M173 VDD DEC2 row_decoder_0.N2 VDD sky130_fd_pr__pfet_01v8 w=0.84u l=0.15u
M174 write_driver_1.BLB SCLK sense_amp_1.SA_OUTB VDD sky130_fd_pr__pfet_01v8 w=2u l=0.15u
M175 VDD ROW1 a_n6773_39432# VDD sky130_fd_pr__pfet_01v8 w=1.68u l=0.15u
M176 a_7565_45424# bitcell_6t_24.WL write_driver_2.BL VSS sky130_fd_pr__nfet_01v8 w=0.6u l=0.15u
M177 a_11015_45424# a_10967_45336# VDD VDD sky130_fd_pr__pfet_01v8 w=0.42u l=0.15u
M178 a_4115_37024# a_4067_36936# VSS VSS sky130_fd_pr__nfet_01v8 w=1.26u l=0.15u
M179 a_24815_39824# a_24767_39736# VSS VSS sky130_fd_pr__nfet_01v8 w=1.26u l=0.15u
M180 VDD PCLK row_decoder_0.N2 VDD sky130_fd_pr__pfet_01v8 w=1.25u l=0.15u
M181 VDD PRECH write_driver_2.BL VDD sky130_fd_pr__pfet_01v8 w=2.52u l=0.15u
M182 a_4115_45424# a_4067_45336# VSS VSS sky130_fd_pr__nfet_01v8 w=1.26u l=0.15u
M183 a_19027_13496# DIN_B3 write_driver_3.BL VDD sky130_fd_pr__pfet_01v8 w=5.04u l=0.15u
M184 a_17867_42536# a_17915_42624# VSS VSS sky130_fd_pr__nfet_01v8 w=1.26u l=0.15u
M185 VDD row_decoder_0.N3 DEC3 VDD sky130_fd_pr__pfet_01v8 w=3u l=0.15u
M186 a_27015_9496# DIN4 write_driver_4.BLB VSS sky130_fd_pr__nfet_01v8 w=5.04u l=0.15u
M187 a_7517_36936# a_7565_37024# VSS VSS sky130_fd_pr__nfet_01v8 w=1.26u l=0.15u
M188 VDD PRECH write_driver_3.BLB VDD sky130_fd_pr__pfet_01v8 w=2.52u l=0.15u
M189 a_24767_42536# a_24815_42624# VDD VDD sky130_fd_pr__pfet_01v8 w=0.42u l=0.15u
M190 VSS SCLK a_42615_19902# VSS sky130_fd_pr__nfet_01v8 w=0.98u l=0.15u
M191 VDD a_24227_13916# a_25027_13496# VDD sky130_fd_pr__pfet_01v8 w=5.04u l=0.15u
M192 VSS WE a_6227_13916# VSS sky130_fd_pr__nfet_01v8 w=0.84u l=0.15u
M193 a_24815_42624# a_24767_42536# VSS VSS sky130_fd_pr__nfet_01v8 w=1.26u l=0.15u
M194 a_10967_39736# a_11015_39824# VSS VSS sky130_fd_pr__nfet_01v8 w=1.26u l=0.15u
M195 a_665_37024# wl_driver_0.WL write_driver_0.BL VSS sky130_fd_pr__nfet_01v8 w=0.6u l=0.15u
M196 a_7517_45336# a_7565_45424# VSS VSS sky130_fd_pr__nfet_01v8 w=1.26u l=0.15u
M197 DOUT4 SCLK write_driver_4.BL VDD sky130_fd_pr__pfet_01v8 w=2u l=0.15u
M198 write_driver_2.BLB SCLK sense_amp_2.SA_OUTB VDD sky130_fd_pr__pfet_01v8 w=2u l=0.15u
M199 write_driver_7.BLB PRECH write_driver_7.BL VDD sky130_fd_pr__pfet_01v8 w=2.52u l=0.15u
M200 row_decoder_0.net4 row_decoder_0.A1T row_decoder_0.N3 VSS sky130_fd_pr__nfet_01v8 w=2u l=0.15u
M201 a_665_45424# bitcell_6t_24.WL write_driver_0.BL VSS sky130_fd_pr__nfet_01v8 w=0.6u l=0.15u
M202 a_1415_9496# DIN_B0 write_driver_0.BL VSS sky130_fd_pr__nfet_01v8 w=5.04u l=0.15u
M203 VSS PCLK row_decoder_0.EVAL_GND VSS sky130_fd_pr__nfet_01v8 w=1.5u l=0.15u
M204 a_14465_42624# a_14417_42536# VDD VDD sky130_fd_pr__pfet_01v8 w=0.42u l=0.15u
M205 a_665_42624# a_617_42536# VDD VDD sky130_fd_pr__pfet_01v8 w=0.42u l=0.15u
M206 a_44627_13496# DIN7 write_driver_7.BLB VDD sky130_fd_pr__pfet_01v8 w=5.04u l=0.15u
M207 VDD WE a_30227_13916# VDD sky130_fd_pr__pfet_01v8 w=0.84u l=0.15u
M208 a_10967_42536# a_11015_42624# VSS VSS sky130_fd_pr__nfet_01v8 w=1.26u l=0.15u
M209 a_7027_13496# DIN_B1 write_driver_1.BL VDD sky130_fd_pr__pfet_01v8 w=5.04u l=0.15u
M210 a_21317_39736# a_21365_39824# VSS VSS sky130_fd_pr__nfet_01v8 w=1.26u l=0.15u
M211 a_4067_39736# a_4115_39824# VDD VDD sky130_fd_pr__pfet_01v8 w=0.42u l=0.15u
M212 VSS WE a_24227_13916# VSS sky130_fd_pr__nfet_01v8 w=0.84u l=0.15u
M213 a_617_36936# a_665_37024# VSS VSS sky130_fd_pr__nfet_01v8 w=1.26u l=0.15u
M214 VDD sense_amp_7.SA_OUTB DOUT7 VDD sky130_fd_pr__pfet_01v8 w=1.89u l=0.15u
M215 a_4067_36936# a_4115_37024# VDD VDD sky130_fd_pr__pfet_01v8 w=0.42u l=0.15u
M216 VDD DOUT5 sense_amp_5.SA_OUTB VDD sky130_fd_pr__pfet_01v8 w=1.89u l=0.15u
M217 VDD PRECH write_driver_1.BLB VDD sky130_fd_pr__pfet_01v8 w=2.52u l=0.15u
M218 a_14465_37024# wl_driver_0.WL write_driver_4.BL VSS sky130_fd_pr__nfet_01v8 w=0.6u l=0.15u
M219 a_617_45336# a_665_45424# VSS VSS sky130_fd_pr__nfet_01v8 w=1.26u l=0.15u
M220 VSS WE a_43415_9496# VSS sky130_fd_pr__nfet_01v8 w=5.04u l=0.15u
M221 a_4067_45336# a_4115_45424# VDD VDD sky130_fd_pr__pfet_01v8 w=0.42u l=0.15u
M222 VDD a_n6773_49432# bitcell_6t_24.WL VDD sky130_fd_pr__pfet_01v8 w=5.04u l=0.15u
M223 VSS row_decoder_0.A1B row_decoder_0.A1T VSS sky130_fd_pr__nfet_01v8 w=2u l=0.15u
M224 VDD a_n6773_34432# wl_driver_0.WL VDD sky130_fd_pr__pfet_01v8 w=5.04u l=0.15u
M225 write_driver_0.BLB SCLK sense_amp_0.SA_OUTB VDD sky130_fd_pr__pfet_01v8 w=2u l=0.15u
M226 a_14465_45424# bitcell_6t_24.WL write_driver_4.BL VSS sky130_fd_pr__nfet_01v8 w=0.6u l=0.15u
M227 a_21317_42536# a_21365_42624# VSS VSS sky130_fd_pr__nfet_01v8 w=1.26u l=0.15u
M228 VSS row_decoder_0.N0 DEC0 VSS sky130_fd_pr__nfet_01v8 w=2u l=0.15u
M229 a_7565_39824# a_7517_39736# VSS VSS sky130_fd_pr__nfet_01v8 w=1.26u l=0.15u
M230 a_18615_19902# sense_amp_3.SA_OUTB DOUT3 VSS sky130_fd_pr__nfet_01v8 w=0.98u l=0.15u
M231 a_13027_13496# DIN_B2 write_driver_2.BL VDD sky130_fd_pr__pfet_01v8 w=5.04u l=0.15u
M232 VDD PRECH write_driver_0.BL VDD sky130_fd_pr__pfet_01v8 w=2.52u l=0.15u
M233 a_14417_36936# a_14465_37024# VSS VSS sky130_fd_pr__nfet_01v8 w=1.26u l=0.15u
M234 a_17867_39736# a_17915_39824# VDD VDD sky130_fd_pr__pfet_01v8 w=0.42u l=0.15u
M235 VDD A1 row_decoder_0.A1B VDD sky130_fd_pr__pfet_01v8 w=0.84u l=0.15u
M236 VDD ROW3 a_n6773_49432# VDD sky130_fd_pr__pfet_01v8 w=1.68u l=0.15u
M237 VDD PRECH write_driver_4.BL VDD sky130_fd_pr__pfet_01v8 w=2.52u l=0.15u
M238 VDD ROW0 a_n6773_34432# VDD sky130_fd_pr__pfet_01v8 w=1.68u l=0.15u
M239 a_24767_36936# wl_driver_0.WL write_driver_7.BLB VSS sky130_fd_pr__nfet_01v8 w=0.6u l=0.15u
M240 a_17867_36936# a_17915_37024# VDD VDD sky130_fd_pr__pfet_01v8 w=0.42u l=0.15u
M241 VDD PRECH write_driver_2.BLB VDD sky130_fd_pr__pfet_01v8 w=2.52u l=0.15u
M242 a_21317_39736# a_21365_39824# VDD VDD sky130_fd_pr__pfet_01v8 w=0.42u l=0.15u
M243 a_45015_9496# DIN7 write_driver_7.BLB VSS sky130_fd_pr__nfet_01v8 w=5.04u l=0.15u
M244 a_17915_37024# a_17867_36936# VSS VSS sky130_fd_pr__nfet_01v8 w=1.26u l=0.15u
M245 a_21317_36936# a_21365_37024# VDD VDD sky130_fd_pr__pfet_01v8 w=0.42u l=0.15u
M246 a_14417_45336# a_14465_45424# VSS VSS sky130_fd_pr__nfet_01v8 w=1.26u l=0.15u
M247 VSS WE a_13415_9496# VSS sky130_fd_pr__nfet_01v8 w=5.04u l=0.15u
M248 a_17867_45336# a_17915_45424# VDD VDD sky130_fd_pr__pfet_01v8 w=0.42u l=0.15u
M249 a_21365_37024# a_21317_36936# VSS VSS sky130_fd_pr__nfet_01v8 w=1.26u l=0.15u
M250 a_24767_45336# bitcell_6t_24.WL write_driver_7.BLB VSS sky130_fd_pr__nfet_01v8 w=0.6u l=0.15u
M251 a_7517_42536# a_7565_42624# VDD VDD sky130_fd_pr__pfet_01v8 w=0.42u l=0.15u
M252 VDD row_decoder_0.N0 DEC0 VDD sky130_fd_pr__pfet_01v8 w=3u l=0.15u
M253 a_17915_45424# a_17867_45336# VSS VSS sky130_fd_pr__nfet_01v8 w=1.26u l=0.15u
M254 a_21317_45336# a_21365_45424# VDD VDD sky130_fd_pr__pfet_01v8 w=0.42u l=0.15u
M255 a_7565_42624# a_7517_42536# VSS VSS sky130_fd_pr__nfet_01v8 w=1.26u l=0.15u
M256 VDD a_36227_13916# a_37027_13496# VDD sky130_fd_pr__pfet_01v8 w=5.04u l=0.15u
M257 a_21365_45424# a_21317_45336# VSS VSS sky130_fd_pr__nfet_01v8 w=1.26u l=0.15u
M258 a_4067_39736# wl_driver_1.WL write_driver_1.BLB VSS sky130_fd_pr__nfet_01v8 w=0.6u l=0.15u
M259 VSS A0 row_decoder_0.A0B VSS sky130_fd_pr__nfet_01v8 w=0.84u l=0.15u
M260 DOUT6 SCLK write_driver_6.BL VDD sky130_fd_pr__pfet_01v8 w=2u l=0.15u
M261 write_driver_4.BLB SCLK sense_amp_4.SA_OUTB VDD sky130_fd_pr__pfet_01v8 w=2u l=0.15u
M262 a_18615_19902# DOUT3 sense_amp_3.SA_OUTB VSS sky130_fd_pr__nfet_01v8 w=0.98u l=0.15u
M263 VSS WE a_39015_9496# VSS sky130_fd_pr__nfet_01v8 w=5.04u l=0.15u
M264 a_1027_13496# DIN_B0 write_driver_0.BL VDD sky130_fd_pr__pfet_01v8 w=5.04u l=0.15u
M265 a_6615_19902# sense_amp_1.SA_OUTB DOUT1 VSS sky130_fd_pr__nfet_01v8 w=0.98u l=0.15u
M266 a_10967_39736# a_11015_39824# VDD VDD sky130_fd_pr__pfet_01v8 w=0.42u l=0.15u
M267 a_10967_36936# a_11015_37024# VDD VDD sky130_fd_pr__pfet_01v8 w=0.42u l=0.15u
M268 VSS WE a_42227_13916# VSS sky130_fd_pr__nfet_01v8 w=0.84u l=0.15u
M269 row_decoder_0.net1 row_decoder_0.A1B row_decoder_0.N0 VSS sky130_fd_pr__nfet_01v8 w=2u l=0.15u
M270 a_15015_9496# DIN2 write_driver_2.BLB VSS sky130_fd_pr__nfet_01v8 w=5.04u l=0.15u
M271 a_11015_37024# a_10967_36936# VSS VSS sky130_fd_pr__nfet_01v8 w=1.26u l=0.15u
M272 a_19415_9496# DIN_B3 write_driver_3.BL VSS sky130_fd_pr__nfet_01v8 w=5.04u l=0.15u
M273 VDD PRECH write_driver_0.BLB VDD sky130_fd_pr__pfet_01v8 w=2.52u l=0.15u
M274 VDD WE a_42227_13916# VDD sky130_fd_pr__pfet_01v8 w=0.84u l=0.15u
M275 a_4115_42624# a_4067_42536# VDD VDD sky130_fd_pr__pfet_01v8 w=0.42u l=0.15u
M276 a_4067_42536# wl_driver_2.WL write_driver_1.BLB VSS sky130_fd_pr__nfet_01v8 w=0.6u l=0.15u
M277 a_10967_45336# a_11015_45424# VDD VDD sky130_fd_pr__pfet_01v8 w=0.42u l=0.15u
M278 VDD a_6227_13916# a_8627_13496# VDD sky130_fd_pr__pfet_01v8 w=5.04u l=0.15u
M279 a_617_42536# a_665_42624# VDD VDD sky130_fd_pr__pfet_01v8 w=0.42u l=0.15u
M280 a_11015_45424# a_10967_45336# VSS VSS sky130_fd_pr__nfet_01v8 w=1.26u l=0.15u
M281 row_decoder_0.net2 row_decoder_0.A1B row_decoder_0.N1 VSS sky130_fd_pr__nfet_01v8 w=2u l=0.15u
M282 VDD DOUT7 sense_amp_7.SA_OUTB VDD sky130_fd_pr__pfet_01v8 w=1.89u l=0.15u
M283 a_17867_39736# wl_driver_1.WL write_driver_5.BLB VSS sky130_fd_pr__nfet_01v8 w=0.6u l=0.15u
M284 a_21317_39736# wl_driver_1.WL write_driver_6.BLB VSS sky130_fd_pr__nfet_01v8 w=0.6u l=0.15u
M285 a_24815_39824# a_24767_39736# VDD VDD sky130_fd_pr__pfet_01v8 w=0.42u l=0.15u
M286 a_24815_37024# a_24767_36936# VDD VDD sky130_fd_pr__pfet_01v8 w=0.42u l=0.15u
M287 a_14465_39824# a_14417_39736# VSS VSS sky130_fd_pr__nfet_01v8 w=1.26u l=0.15u
M288 a_4115_37024# wl_driver_0.WL write_driver_1.BL VSS sky130_fd_pr__nfet_01v8 w=0.6u l=0.15u
M289 a_24815_39824# wl_driver_1.WL write_driver_7.BL VSS sky130_fd_pr__nfet_01v8 w=0.6u l=0.15u
M290 a_12615_19902# sense_amp_2.SA_OUTB DOUT2 VSS sky130_fd_pr__nfet_01v8 w=0.98u l=0.15u
M291 a_665_39824# a_617_39736# VSS VSS sky130_fd_pr__nfet_01v8 w=1.26u l=0.15u
M292 a_24815_45424# a_24767_45336# VDD VDD sky130_fd_pr__pfet_01v8 w=0.42u l=0.15u
M293 a_6615_19902# DOUT1 sense_amp_1.SA_OUTB VSS sky130_fd_pr__nfet_01v8 w=0.98u l=0.15u
M294 VDD a_n6773_44432# wl_driver_2.WL VDD sky130_fd_pr__pfet_01v8 w=5.04u l=0.15u
M295 a_4115_45424# bitcell_6t_24.WL write_driver_1.BL VSS sky130_fd_pr__nfet_01v8 w=0.6u l=0.15u
M296 VSS WE a_12227_13916# VSS sky130_fd_pr__nfet_01v8 w=0.84u l=0.15u
M297 write_driver_3.BLB PRECH write_driver_3.BL VDD sky130_fd_pr__pfet_01v8 w=2.52u l=0.15u
M298 a_17867_42536# wl_driver_2.WL write_driver_5.BLB VSS sky130_fd_pr__nfet_01v8 w=0.6u l=0.15u
M299 VDD a_12227_13916# a_14627_13496# VDD sky130_fd_pr__pfet_01v8 w=5.04u l=0.15u
M300 a_25027_13496# DIN_B4 write_driver_4.BL VDD sky130_fd_pr__pfet_01v8 w=5.04u l=0.15u
M301 VSS WE a_31415_9496# VSS sky130_fd_pr__nfet_01v8 w=5.04u l=0.15u
M302 a_21317_42536# wl_driver_2.WL write_driver_6.BLB VSS sky130_fd_pr__nfet_01v8 w=0.6u l=0.15u
M303 a_14417_42536# a_14465_42624# VDD VDD sky130_fd_pr__pfet_01v8 w=0.42u l=0.15u
M304 a_7517_36936# wl_driver_0.WL write_driver_2.BLB VSS sky130_fd_pr__nfet_01v8 w=0.6u l=0.15u
M305 VDD PRECH write_driver_6.BL VDD sky130_fd_pr__pfet_01v8 w=2.52u l=0.15u
M306 a_14465_42624# a_14417_42536# VSS VSS sky130_fd_pr__nfet_01v8 w=1.26u l=0.15u
M307 VDD PRECH write_driver_4.BLB VDD sky130_fd_pr__pfet_01v8 w=2.52u l=0.15u
M308 VDD a_30227_13916# a_31027_13496# VDD sky130_fd_pr__pfet_01v8 w=5.04u l=0.15u
M309 a_10967_39736# wl_driver_1.WL write_driver_3.BLB VSS sky130_fd_pr__nfet_01v8 w=0.6u l=0.15u
M310 a_24815_42624# wl_driver_2.WL write_driver_7.BL VSS sky130_fd_pr__nfet_01v8 w=0.6u l=0.15u
M311 a_24767_39736# a_24815_39824# VSS VSS sky130_fd_pr__nfet_01v8 w=1.26u l=0.15u
M312 a_665_42624# a_617_42536# VSS VSS sky130_fd_pr__nfet_01v8 w=1.26u l=0.15u
M313 a_7517_45336# bitcell_6t_24.WL write_driver_2.BLB VSS sky130_fd_pr__nfet_01v8 w=0.6u l=0.15u
M314 VDD PCLK row_decoder_0.N3 VDD sky130_fd_pr__pfet_01v8 w=1.25u l=0.15u
M315 DOUT5 SCLK write_driver_5.BL VDD sky130_fd_pr__pfet_01v8 w=2u l=0.15u
M316 write_driver_3.BLB SCLK sense_amp_3.SA_OUTB VDD sky130_fd_pr__pfet_01v8 w=2u l=0.15u
M317 VDD ROW2 a_n6773_44432# VDD sky130_fd_pr__pfet_01v8 w=1.68u l=0.15u
M318 row_decoder_0.EVAL_GND row_decoder_0.A0B row_decoder_0.net1 VSS sky130_fd_pr__nfet_01v8 w=2u l=0.15u
M319 a_17915_37024# wl_driver_0.WL write_driver_5.BL VSS sky130_fd_pr__nfet_01v8 w=0.6u l=0.15u
M320 a_12615_19902# DOUT2 sense_amp_2.SA_OUTB VSS sky130_fd_pr__nfet_01v8 w=0.98u l=0.15u
M321 VDD sense_amp_3.SA_OUTB DOUT3 VDD sky130_fd_pr__pfet_01v8 w=1.89u l=0.15u
M322 VSS SCLK a_6615_19902# VSS sky130_fd_pr__nfet_01v8 w=0.98u l=0.15u
M323 VSS WE a_9015_9496# VSS sky130_fd_pr__nfet_01v8 w=5.04u l=0.15u
M324 a_17915_45424# bitcell_6t_24.WL write_driver_5.BL VSS sky130_fd_pr__nfet_01v8 w=0.6u l=0.15u
M325 write_driver_6.BLB SCLK sense_amp_6.SA_OUTB VDD sky130_fd_pr__pfet_01v8 w=2u l=0.15u
M326 a_33015_9496# DIN5 write_driver_5.BLB VSS sky130_fd_pr__nfet_01v8 w=5.04u l=0.15u
M327 row_decoder_0.EVAL_GND row_decoder_0.A0T row_decoder_0.net2 VSS sky130_fd_pr__nfet_01v8 w=2u l=0.15u
M328 a_10967_42536# wl_driver_2.WL write_driver_3.BLB VSS sky130_fd_pr__nfet_01v8 w=0.6u l=0.15u
M329 a_37415_9496# DIN_B6 write_driver_6.BL VSS sky130_fd_pr__nfet_01v8 w=5.04u l=0.15u
M330 write_driver_1.BLB PRECH write_driver_1.BL VDD sky130_fd_pr__pfet_01v8 w=2.52u l=0.15u
M331 a_24767_42536# a_24815_42624# VSS VSS sky130_fd_pr__nfet_01v8 w=1.26u l=0.15u
M332 VDD a_227_13916# a_2627_13496# VDD sky130_fd_pr__pfet_01v8 w=5.04u l=0.15u
M333 a_617_36936# wl_driver_0.WL write_driver_0.BLB VSS sky130_fd_pr__nfet_01v8 w=0.6u l=0.15u
M334 a_617_45336# bitcell_6t_24.WL write_driver_0.BLB VSS sky130_fd_pr__nfet_01v8 w=0.6u l=0.15u
M335 a_8627_13496# DIN1 write_driver_1.BLB VDD sky130_fd_pr__pfet_01v8 w=5.04u l=0.15u
M336 a_11015_37024# wl_driver_0.WL write_driver_3.BL VSS sky130_fd_pr__nfet_01v8 w=0.6u l=0.15u
M337 a_17915_42624# a_17867_42536# VDD VDD sky130_fd_pr__pfet_01v8 w=0.42u l=0.15u
M338 VSS SCLK a_12615_19902# VSS sky130_fd_pr__nfet_01v8 w=0.98u l=0.15u
M339 a_7565_39824# a_7517_39736# VDD VDD sky130_fd_pr__pfet_01v8 w=0.42u l=0.15u
M340 VSS WE a_27015_9496# VSS sky130_fd_pr__nfet_01v8 w=5.04u l=0.15u
M341 a_21365_42624# a_21317_42536# VDD VDD sky130_fd_pr__pfet_01v8 w=0.42u l=0.15u
M342 a_615_19902# DOUT0 sense_amp_0.SA_OUTB VSS sky130_fd_pr__nfet_01v8 w=0.98u l=0.15u
M343 VDD sense_amp_1.SA_OUTB DOUT1 VDD sky130_fd_pr__pfet_01v8 w=1.89u l=0.15u
M344 VSS A1 row_decoder_0.A1B VSS sky130_fd_pr__nfet_01v8 w=0.84u l=0.15u
M345 a_7565_37024# a_7517_36936# VDD VDD sky130_fd_pr__pfet_01v8 w=0.42u l=0.15u
M346 a_11015_45424# bitcell_6t_24.WL write_driver_3.BL VSS sky130_fd_pr__nfet_01v8 w=0.6u l=0.15u
M347 a_615_19902# sense_amp_0.SA_OUTB DOUT0 VSS sky130_fd_pr__nfet_01v8 w=0.98u l=0.15u
M348 VSS WE a_30227_13916# VSS sky130_fd_pr__nfet_01v8 w=0.84u l=0.15u
M349 write_driver_2.BLB PRECH write_driver_2.BL VDD sky130_fd_pr__pfet_01v8 w=2.52u l=0.15u
M350 a_7565_39824# wl_driver_1.WL write_driver_2.BL VSS sky130_fd_pr__nfet_01v8 w=0.6u l=0.15u
M351 a_7565_45424# a_7517_45336# VDD VDD sky130_fd_pr__pfet_01v8 w=0.42u l=0.15u
M352 a_24615_19902# sense_amp_4.SA_OUTB DOUT4 VSS sky130_fd_pr__nfet_01v8 w=0.98u l=0.15u
M353 a_14417_36936# wl_driver_0.WL write_driver_4.BLB VSS sky130_fd_pr__nfet_01v8 w=0.6u l=0.15u
M354 a_4067_36936# a_4115_37024# VSS VSS sky130_fd_pr__nfet_01v8 w=1.26u l=0.15u
M355 a_4115_39824# a_4067_39736# VSS VSS sky130_fd_pr__nfet_01v8 w=1.26u l=0.15u
M356 VDD PRECH write_driver_5.BL VDD sky130_fd_pr__pfet_01v8 w=2.52u l=0.15u
M357 VSS WE a_1415_9496# VSS sky130_fd_pr__nfet_01v8 w=5.04u l=0.15u
M358 a_14417_45336# bitcell_6t_24.WL write_driver_4.BLB VSS sky130_fd_pr__nfet_01v8 w=0.6u l=0.15u
M359 a_4067_45336# a_4115_45424# VSS VSS sky130_fd_pr__nfet_01v8 w=1.26u l=0.15u
M360 VDD a_24227_13916# a_26627_13496# VDD sky130_fd_pr__pfet_01v8 w=5.04u l=0.15u
M361 a_37027_13496# DIN_B6 write_driver_6.BL VDD sky130_fd_pr__pfet_01v8 w=5.04u l=0.15u
M362 a_14627_13496# DIN2 write_driver_2.BLB VDD sky130_fd_pr__pfet_01v8 w=5.04u l=0.15u
M363 a_21365_37024# wl_driver_0.WL write_driver_6.BL VSS sky130_fd_pr__nfet_01v8 w=0.6u l=0.15u
M364 VSS a_n6773_39432# wl_driver_1.WL VSS sky130_fd_pr__nfet_01v8 w=5.04u l=0.15u
M365 VDD PRECH write_driver_6.BLB VDD sky130_fd_pr__pfet_01v8 w=2.52u l=0.15u
M366 a_7565_42624# wl_driver_2.WL write_driver_2.BL VSS sky130_fd_pr__nfet_01v8 w=0.6u l=0.15u
M367 VSS row_decoder_0.N1 DEC1 VSS sky130_fd_pr__nfet_01v8 w=2u l=0.15u
M368 a_11015_42624# a_10967_42536# VDD VDD sky130_fd_pr__pfet_01v8 w=0.42u l=0.15u
M369 a_21365_45424# bitcell_6t_24.WL write_driver_6.BL VSS sky130_fd_pr__nfet_01v8 w=0.6u l=0.15u
M370 VDD a_42227_13916# a_43027_13496# VDD sky130_fd_pr__pfet_01v8 w=5.04u l=0.15u
M371 a_7517_39736# a_7565_39824# VSS VSS sky130_fd_pr__nfet_01v8 w=1.26u l=0.15u
M372 VDD sense_amp_2.SA_OUTB DOUT2 VDD sky130_fd_pr__pfet_01v8 w=1.89u l=0.15u
M373 VDD WE a_18227_13916# VDD sky130_fd_pr__pfet_01v8 w=0.84u l=0.15u
M374 VSS SCLK a_615_19902# VSS sky130_fd_pr__nfet_01v8 w=0.98u l=0.15u
M375 DOUT7 SCLK write_driver_7.BL VDD sky130_fd_pr__pfet_01v8 w=2u l=0.15u
M376 write_driver_5.BLB SCLK sense_amp_5.SA_OUTB VDD sky130_fd_pr__pfet_01v8 w=2u l=0.15u
M377 a_4115_42624# a_4067_42536# VSS VSS sky130_fd_pr__nfet_01v8 w=1.26u l=0.15u
M378 VDD DEC0 row_decoder_0.N0 VDD sky130_fd_pr__pfet_01v8 w=0.84u l=0.15u
M379 a_665_39824# wl_driver_1.WL write_driver_0.BL VSS sky130_fd_pr__nfet_01v8 w=0.6u l=0.15u
M380 write_driver_0.BLB PRECH write_driver_0.BL VDD sky130_fd_pr__pfet_01v8 w=2.52u l=0.15u
M381 a_17867_36936# a_17915_37024# VSS VSS sky130_fd_pr__nfet_01v8 w=1.26u l=0.15u
M382 a_24615_19902# DOUT4 sense_amp_4.SA_OUTB VSS sky130_fd_pr__nfet_01v8 w=0.98u l=0.15u
M383 a_3015_9496# DIN0 write_driver_0.BLB VSS sky130_fd_pr__nfet_01v8 w=5.04u l=0.15u
M384 VDD DOUT3 sense_amp_3.SA_OUTB VDD sky130_fd_pr__pfet_01v8 w=1.89u l=0.15u
M385 a_7415_9496# DIN_B1 write_driver_1.BL VSS sky130_fd_pr__nfet_01v8 w=5.04u l=0.15u
M386 VDD PCLK row_decoder_0.N0 VDD sky130_fd_pr__pfet_01v8 w=1.25u l=0.15u
M387 VSS WE a_19415_9496# VSS sky130_fd_pr__nfet_01v8 w=5.04u l=0.15u
M388 a_24767_39736# a_24815_39824# VDD VDD sky130_fd_pr__pfet_01v8 w=0.42u l=0.15u
M389 VSS ROW1 a_n6773_39432# VSS sky130_fd_pr__nfet_01v8 w=1.68u l=0.15u
M390 a_24767_36936# a_24815_37024# VDD VDD sky130_fd_pr__pfet_01v8 w=0.42u l=0.15u
M391 a_17867_45336# a_17915_45424# VSS VSS sky130_fd_pr__nfet_01v8 w=1.26u l=0.15u
M392 VDD row_decoder_0.N1 DEC1 VDD sky130_fd_pr__pfet_01v8 w=3u l=0.15u
M393 VDD DEC1 row_decoder_0.N1 VDD sky130_fd_pr__pfet_01v8 w=0.84u l=0.15u
M394 a_24815_37024# a_24767_36936# VSS VSS sky130_fd_pr__nfet_01v8 w=1.26u l=0.15u
M395 a_7517_42536# a_7565_42624# VSS VSS sky130_fd_pr__nfet_01v8 w=1.26u l=0.15u
M396 a_2627_13496# DIN0 write_driver_0.BLB VDD sky130_fd_pr__pfet_01v8 w=5.04u l=0.15u
M397 a_24767_45336# a_24815_45424# VDD VDD sky130_fd_pr__pfet_01v8 w=0.42u l=0.15u
M398 VDD PCLK row_decoder_0.N1 VDD sky130_fd_pr__pfet_01v8 w=1.25u l=0.15u
M399 a_665_42624# wl_driver_2.WL write_driver_0.BL VSS sky130_fd_pr__nfet_01v8 w=0.6u l=0.15u
M400 a_24815_45424# a_24767_45336# VSS VSS sky130_fd_pr__nfet_01v8 w=1.26u l=0.15u
.ends leaf_fabric
