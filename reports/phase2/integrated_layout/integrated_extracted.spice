* NGSPICE file created from integrated_flat.ext - technology: sky130A

.subckt integrated_flat ADDR[0] ADDR[1] CLK CSb DATA[0] DATA[1] DATA[2] DATA[3] DATA[4]
+ DATA[5] DATA[6] DATA[7] OEb VDD VSS WEb
X0 VDD macro_core.array_and_peripherals.row_decoder_0.DEC0 macro_core.array_and_peripherals.row_decoder_0.N0 VDD sky130_fd_pr__pfet_01v8 ad=0.2436 pd=2.26 as=0.2436 ps=2.26 w=0.84 l=0.15
X1 a_43167_45886# a_43215_45974# VDD VDD sky130_fd_pr__pfet_01v8 ad=0.1218 pd=1.42 as=0.1218 ps=1.42 w=0.42 l=0.15
X2 a_79167_40886# a_79215_40974# VSS VSS sky130_fd_pr__nfet_01v8 ad=0.3654 pd=3.1 as=0.3654 ps=3.1 w=1.26 l=0.15
X3 a_79167_55886# a_79215_55974# VSS VSS sky130_fd_pr__nfet_01v8 ad=0.3654 pd=3.1 as=0.3654 ps=3.1 w=1.26 l=0.15
X4 a_50415_16496# macro_core.array_and_peripherals.write_driver_1.DATA_B macro_core.array_and_peripherals.write_driver_1.BL VSS sky130_fd_pr__nfet_01v8 ad=1.4616 pd=10.66 as=1.4616 ps=10.66 w=5.04 l=0.15
X5 a_85215_50974# a_85167_50886# VSS VSS sky130_fd_pr__nfet_01v8 ad=0.3654 pd=3.1 as=0.3654 ps=3.1 w=1.26 l=0.15
X6 a_67167_50886# a_67215_50974# VSS VSS sky130_fd_pr__nfet_01v8 ad=0.3654 pd=3.1 as=0.3654 ps=3.1 w=1.26 l=0.15
X7 macro_core.array_and_peripherals.row_decoder_0.EVAL_GND macro_core.array_and_peripherals.row_decoder_0.A0T macro_core.array_and_peripherals.row_decoder_0.net4 VSS sky130_fd_pr__nfet_01v8 ad=0.58 pd=4.58 as=0.58 ps=4.58 w=2 l=0.15
X8 VSS macro_core.array_and_peripherals.wl_driver_0.WL_IN a_36227_41432# VSS sky130_fd_pr__nfet_01v8 ad=0.4872 pd=3.94 as=0.4872 ps=3.94 w=1.68 l=0.15
X9 VSS macro_core.array_and_peripherals.sense_amp_0.SCLK a_49615_26902# VSS sky130_fd_pr__nfet_01v8 ad=0.2842 pd=2.54 as=0.2842 ps=2.54 w=0.98 l=0.15
X10 a_49167_55886# a_49215_55974# VDD VDD sky130_fd_pr__pfet_01v8 ad=0.1218 pd=1.42 as=0.1218 ps=1.42 w=0.42 l=0.15
X11 a_49167_40886# a_49215_40974# VDD VDD sky130_fd_pr__pfet_01v8 ad=0.1218 pd=1.42 as=0.1218 ps=1.42 w=0.42 l=0.15
X12 VSS macro_core.array_and_peripherals.write_driver_0.WE a_56415_16496# VSS sky130_fd_pr__nfet_01v8 ad=1.4616 pd=10.66 as=1.4616 ps=10.66 w=5.04 l=0.15
X13 a_68415_16496# macro_core.array_and_peripherals.write_driver_4.DATA_B macro_core.array_and_peripherals.write_driver_4.BL VSS sky130_fd_pr__nfet_01v8 ad=1.4616 pd=10.66 as=1.4616 ps=10.66 w=5.04 l=0.15
X14 VDD macro_core.array_and_peripherals.sense_amp_7.SA_OUTB macro_core.array_and_peripherals.sense_amp_7.SA_OUT VDD sky130_fd_pr__pfet_01v8 ad=0.5481 pd=4.36 as=0.5481 ps=4.36 w=1.89 l=0.15
X15 VDD macro_core.array_and_peripherals.sense_amp_5.SA_OUT macro_core.array_and_peripherals.sense_amp_5.SA_OUTB VDD sky130_fd_pr__pfet_01v8 ad=0.5481 pd=4.36 as=0.5481 ps=4.36 w=1.89 l=0.15
X16 macro_core.array_and_peripherals.row_decoder_0.net3 macro_core.array_and_peripherals.row_decoder_0.A1T macro_core.array_and_peripherals.row_decoder_0.N2 VSS sky130_fd_pr__nfet_01v8 ad=0.58 pd=4.58 as=0.58 ps=4.58 w=2 l=0.15
X17 macro_core.array_and_peripherals.write_driver_1.BLB macro_core.array_and_peripherals.precharge_0.PRECH macro_core.array_and_peripherals.write_driver_1.BL VDD sky130_fd_pr__pfet_01v8 ad=0.7308 pd=5.62 as=0.7308 ps=5.62 w=2.52 l=0.15
X18 a_55215_45974# a_55167_45886# VSS VSS sky130_fd_pr__nfet_01v8 ad=0.3654 pd=3.1 as=0.3654 ps=3.1 w=1.26 l=0.15
X19 a_61615_26902# macro_core.array_and_peripherals.sense_amp_3.SA_OUTB macro_core.array_and_peripherals.sense_amp_3.SA_OUT VSS sky130_fd_pr__nfet_01v8 ad=0.2842 pd=2.54 as=0.2842 ps=2.54 w=0.98 l=0.15
X20 a_73167_45886# macro_core.array_and_peripherals.wl_driver_1.WL macro_core.array_and_peripherals.write_driver_5.BLB VSS sky130_fd_pr__nfet_01v8 ad=0.174 pd=1.78 as=0.174 ps=1.78 w=0.6 l=0.15
X21 VSS macro_core.array_and_peripherals.sense_amp_0.SCLK a_67615_26902# VSS sky130_fd_pr__nfet_01v8 ad=0.2842 pd=2.54 as=0.2842 ps=2.54 w=0.98 l=0.15
X22 VSS macro_core.array_and_peripherals.write_driver_0.WE a_70015_16496# VSS sky130_fd_pr__nfet_01v8 ad=1.4616 pd=10.66 as=1.4616 ps=10.66 w=5.04 l=0.15
X23 a_82015_16496# macro_core.array_and_peripherals.write_driver_6.DATA macro_core.array_and_peripherals.write_driver_6.BLB VSS sky130_fd_pr__nfet_01v8 ad=1.4616 pd=10.66 as=1.4616 ps=10.66 w=5.04 l=0.15
X24 VSS macro_core.array_and_peripherals.row_decoder_0.A1B macro_core.array_and_peripherals.row_decoder_0.A1T VSS sky130_fd_pr__nfet_01v8 ad=0.58 pd=4.58 as=0.58 ps=4.58 w=2 l=0.15
X25 a_43215_40974# a_43167_40886# VSS VSS sky130_fd_pr__nfet_01v8 ad=0.3654 pd=3.1 as=0.3654 ps=3.1 w=1.26 l=0.15
X26 a_43215_55974# a_43167_55886# VSS VSS sky130_fd_pr__nfet_01v8 ad=0.3654 pd=3.1 as=0.3654 ps=3.1 w=1.26 l=0.15
X27 a_79215_40974# macro_core.array_and_peripherals.wl_driver_0.WL macro_core.array_and_peripherals.write_driver_6.BL VSS sky130_fd_pr__nfet_01v8 ad=0.174 pd=1.78 as=0.174 ps=1.78 w=0.6 l=0.15
X28 macro_core.array_and_peripherals.write_driver_4.BLB macro_core.array_and_peripherals.precharge_0.PRECH macro_core.array_and_peripherals.write_driver_4.BL VDD sky130_fd_pr__pfet_01v8 ad=0.7308 pd=5.62 as=0.7308 ps=5.62 w=2.52 l=0.15
X29 a_79215_55974# macro_core.array_and_peripherals.wl_driver_3.WL macro_core.array_and_peripherals.write_driver_6.BL VSS sky130_fd_pr__nfet_01v8 ad=0.174 pd=1.78 as=0.174 ps=1.78 w=0.6 l=0.15
X30 a_61167_40886# macro_core.array_and_peripherals.wl_driver_0.WL macro_core.array_and_peripherals.write_driver_3.BLB VSS sky130_fd_pr__nfet_01v8 ad=0.174 pd=1.78 as=0.174 ps=1.78 w=0.6 l=0.15
X31 a_61167_55886# macro_core.array_and_peripherals.wl_driver_3.WL macro_core.array_and_peripherals.write_driver_3.BLB VSS sky130_fd_pr__nfet_01v8 ad=0.174 pd=1.78 as=0.174 ps=1.78 w=0.6 l=0.15
X32 a_74027_20496# macro_core.array_and_peripherals.write_driver_5.DATA_B macro_core.array_and_peripherals.write_driver_5.BL VDD sky130_fd_pr__pfet_01v8 ad=1.4616 pd=10.66 as=1.4616 ps=10.66 w=5.04 l=0.15
X33 a_79615_26902# macro_core.array_and_peripherals.sense_amp_6.SA_OUTB macro_core.array_and_peripherals.sense_amp_6.SA_OUT VSS sky130_fd_pr__nfet_01v8 ad=0.2842 pd=2.54 as=0.2842 ps=2.54 w=0.98 l=0.15
X34 a_51627_20496# macro_core.array_and_peripherals.write_driver_1.DATA macro_core.array_and_peripherals.write_driver_1.BLB VDD sky130_fd_pr__pfet_01v8 ad=1.4616 pd=10.66 as=1.4616 ps=10.66 w=5.04 l=0.15
X35 VDD a_61227_20916# a_63627_20496# VDD sky130_fd_pr__pfet_01v8 ad=1.4616 pd=10.66 as=1.4616 ps=10.66 w=5.04 l=0.15
X36 VSS macro_core.array_and_peripherals.write_driver_0.WE a_88015_16496# VSS sky130_fd_pr__nfet_01v8 ad=1.4616 pd=10.66 as=1.4616 ps=10.66 w=5.04 l=0.15
X37 a_61215_45974# a_61167_45886# VDD VDD sky130_fd_pr__pfet_01v8 ad=0.1218 pd=1.42 as=0.1218 ps=1.42 w=0.42 l=0.15
X38 VSS macro_core.array_and_peripherals.write_driver_0.WE a_73227_20916# VSS sky130_fd_pr__nfet_01v8 ad=0.2436 pd=2.26 as=0.2436 ps=2.26 w=0.84 l=0.15
X39 VDD macro_core.array_and_peripherals.precharge_0.PRECH macro_core.array_and_peripherals.write_driver_7.BL VDD sky130_fd_pr__pfet_01v8 ad=0.7308 pd=5.62 as=0.7308 ps=5.62 w=2.52 l=0.15
X40 VDD macro_core.array_and_peripherals.precharge_0.PRECH macro_core.array_and_peripherals.write_driver_5.BLB VDD sky130_fd_pr__pfet_01v8 ad=0.7308 pd=5.62 as=0.7308 ps=5.62 w=2.52 l=0.15
X41 a_49167_50886# macro_core.array_and_peripherals.wl_driver_2.WL macro_core.array_and_peripherals.write_driver_1.BLB VSS sky130_fd_pr__nfet_01v8 ad=0.174 pd=1.78 as=0.174 ps=1.78 w=0.6 l=0.15
X42 VDD a_79227_20916# a_80027_20496# VDD sky130_fd_pr__pfet_01v8 ad=1.4616 pd=10.66 as=1.4616 ps=10.66 w=5.04 l=0.15
X43 VDD macro_core.array_and_peripherals.write_driver_0.WE a_55227_20916# VDD sky130_fd_pr__pfet_01v8 ad=0.2436 pd=2.26 as=0.2436 ps=2.26 w=0.84 l=0.15
X44 a_79215_45974# a_79167_45886# VDD VDD sky130_fd_pr__pfet_01v8 ad=0.1218 pd=1.42 as=0.1218 ps=1.42 w=0.42 l=0.15
X45 VSS a_36227_56432# macro_core.array_and_peripherals.wl_driver_3.WL VSS sky130_fd_pr__nfet_01v8 ad=1.4616 pd=10.66 as=1.4616 ps=10.66 w=5.04 l=0.15
X46 a_49215_50974# a_49167_50886# VSS VSS sky130_fd_pr__nfet_01v8 ad=0.3654 pd=3.1 as=0.3654 ps=3.1 w=1.26 l=0.15
X47 a_85167_45886# a_85215_45974# VSS VSS sky130_fd_pr__nfet_01v8 ad=0.3654 pd=3.1 as=0.3654 ps=3.1 w=1.26 l=0.15
X48 VDD a_36227_56432# macro_core.array_and_peripherals.wl_driver_3.WL VDD sky130_fd_pr__pfet_01v8 ad=1.4616 pd=10.66 as=1.4616 ps=10.66 w=5.04 l=0.15
X49 VDD a_36227_41432# macro_core.array_and_peripherals.wl_driver_0.WL VDD sky130_fd_pr__pfet_01v8 ad=1.4616 pd=10.66 as=1.4616 ps=10.66 w=5.04 l=0.15
X50 a_85215_50974# macro_core.array_and_peripherals.wl_driver_2.WL macro_core.array_and_peripherals.write_driver_7.BL VSS sky130_fd_pr__nfet_01v8 ad=0.174 pd=1.78 as=0.174 ps=1.78 w=0.6 l=0.15
X51 a_67167_50886# macro_core.array_and_peripherals.wl_driver_2.WL macro_core.array_and_peripherals.write_driver_4.BLB VSS sky130_fd_pr__nfet_01v8 ad=0.174 pd=1.78 as=0.174 ps=1.78 w=0.6 l=0.15
X52 a_85167_50886# a_85215_50974# VDD VDD sky130_fd_pr__pfet_01v8 ad=0.1218 pd=1.42 as=0.1218 ps=1.42 w=0.42 l=0.15
X53 a_61615_26902# macro_core.array_and_peripherals.sense_amp_3.SA_OUT macro_core.array_and_peripherals.sense_amp_3.SA_OUTB VSS sky130_fd_pr__nfet_01v8 ad=0.2842 pd=2.54 as=0.2842 ps=2.54 w=0.98 l=0.15
X54 macro_core.array_and_peripherals.sense_amp_3.SA_OUT macro_core.array_and_peripherals.sense_amp_0.SCLK macro_core.array_and_peripherals.write_driver_3.BL VDD sky130_fd_pr__pfet_01v8 ad=0.58 pd=4.58 as=0.58 ps=4.58 w=2 l=0.15
X55 macro_core.array_and_peripherals.write_driver_1.BLB macro_core.array_and_peripherals.sense_amp_0.SCLK macro_core.array_and_peripherals.sense_amp_1.SA_OUTB VDD sky130_fd_pr__pfet_01v8 ad=0.58 pd=4.58 as=0.58 ps=4.58 w=2 l=0.15
X56 a_67215_55974# a_67167_55886# VDD VDD sky130_fd_pr__pfet_01v8 ad=0.1218 pd=1.42 as=0.1218 ps=1.42 w=0.42 l=0.15
X57 a_67215_40974# a_67167_40886# VDD VDD sky130_fd_pr__pfet_01v8 ad=0.1218 pd=1.42 as=0.1218 ps=1.42 w=0.42 l=0.15
X58 a_73167_40886# a_73215_40974# VSS VSS sky130_fd_pr__nfet_01v8 ad=0.3654 pd=3.1 as=0.3654 ps=3.1 w=1.26 l=0.15
X59 a_73167_55886# a_73215_55974# VSS VSS sky130_fd_pr__nfet_01v8 ad=0.3654 pd=3.1 as=0.3654 ps=3.1 w=1.26 l=0.15
X60 macro_core.array_and_peripherals.row_decoder_0.net4 macro_core.array_and_peripherals.row_decoder_0.A1T macro_core.array_and_peripherals.row_decoder_0.N3 VSS sky130_fd_pr__nfet_01v8 ad=0.58 pd=4.58 as=0.58 ps=4.58 w=2 l=0.15
X61 VDD macro_core.array_and_peripherals.row_decoder_0.A0 macro_core.array_and_peripherals.row_decoder_0.A0B VDD sky130_fd_pr__pfet_01v8 ad=0.2436 pd=2.26 as=0.2436 ps=2.26 w=0.84 l=0.15
X62 VDD macro_core.array_and_peripherals.sense_amp_1.SA_OUTB macro_core.array_and_peripherals.sense_amp_1.SA_OUT VDD sky130_fd_pr__pfet_01v8 ad=0.5481 pd=4.36 as=0.5481 ps=4.36 w=1.89 l=0.15
X63 a_55215_50974# a_55167_50886# VDD VDD sky130_fd_pr__pfet_01v8 ad=0.1218 pd=1.42 as=0.1218 ps=1.42 w=0.42 l=0.15
X64 macro_core.array_and_peripherals.write_driver_4.BLB macro_core.array_and_peripherals.sense_amp_0.SCLK macro_core.array_and_peripherals.sense_amp_4.SA_OUTB VDD sky130_fd_pr__pfet_01v8 ad=0.58 pd=4.58 as=0.58 ps=4.58 w=2 l=0.15
X65 a_55215_45974# macro_core.array_and_peripherals.wl_driver_1.WL macro_core.array_and_peripherals.write_driver_2.BL VSS sky130_fd_pr__nfet_01v8 ad=0.174 pd=1.78 as=0.174 ps=1.78 w=0.6 l=0.15
X66 a_61167_50886# a_61215_50974# VSS VSS sky130_fd_pr__nfet_01v8 ad=0.3654 pd=3.1 as=0.3654 ps=3.1 w=1.26 l=0.15
X67 a_46015_16496# macro_core.array_and_peripherals.write_driver_0.DATA macro_core.array_and_peripherals.write_driver_0.BLB VSS sky130_fd_pr__nfet_01v8 ad=1.4616 pd=10.66 as=1.4616 ps=10.66 w=5.04 l=0.15
X68 a_55167_45886# a_55215_45974# VDD VDD sky130_fd_pr__pfet_01v8 ad=0.1218 pd=1.42 as=0.1218 ps=1.42 w=0.42 l=0.15
X69 a_43215_40974# macro_core.array_and_peripherals.wl_driver_0.WL macro_core.array_and_peripherals.write_driver_0.BL VSS sky130_fd_pr__nfet_01v8 ad=0.174 pd=1.78 as=0.174 ps=1.78 w=0.6 l=0.15
X70 a_43215_55974# macro_core.array_and_peripherals.wl_driver_3.WL macro_core.array_and_peripherals.write_driver_0.BL VSS sky130_fd_pr__nfet_01v8 ad=0.174 pd=1.78 as=0.174 ps=1.78 w=0.6 l=0.15
X71 a_43167_55886# a_43215_55974# VDD VDD sky130_fd_pr__pfet_01v8 ad=0.1218 pd=1.42 as=0.1218 ps=1.42 w=0.42 l=0.15
X72 VSS macro_core.array_and_peripherals.row_decoder_0.A1 macro_core.array_and_peripherals.row_decoder_0.A1B VSS sky130_fd_pr__nfet_01v8 ad=0.2436 pd=2.26 as=0.2436 ps=2.26 w=0.84 l=0.15
X73 a_43167_40886# a_43215_40974# VDD VDD sky130_fd_pr__pfet_01v8 ad=0.1218 pd=1.42 as=0.1218 ps=1.42 w=0.42 l=0.15
X74 VSS macro_core.array_and_peripherals.write_driver_0.WE a_50415_16496# VSS sky130_fd_pr__nfet_01v8 ad=1.4616 pd=10.66 as=1.4616 ps=10.66 w=5.04 l=0.15
X75 a_62415_16496# macro_core.array_and_peripherals.write_driver_3.DATA_B macro_core.array_and_peripherals.write_driver_3.BL VSS sky130_fd_pr__nfet_01v8 ad=1.4616 pd=10.66 as=1.4616 ps=10.66 w=5.04 l=0.15
X76 a_79167_50886# a_79215_50974# VSS VSS sky130_fd_pr__nfet_01v8 ad=0.3654 pd=3.1 as=0.3654 ps=3.1 w=1.26 l=0.15
X77 VDD macro_core.array_and_peripherals.row_decoder_0.DEC3 macro_core.array_and_peripherals.row_decoder_0.N3 VDD sky130_fd_pr__pfet_01v8 ad=0.2436 pd=2.26 as=0.2436 ps=2.26 w=0.84 l=0.15
X78 VDD macro_core.array_and_peripherals.precharge_0.PRECH macro_core.array_and_peripherals.write_driver_1.BL VDD sky130_fd_pr__pfet_01v8 ad=0.7308 pd=5.62 as=0.7308 ps=5.62 w=2.52 l=0.15
X79 VSS macro_core.array_and_peripherals.sense_amp_0.SCLK a_61615_26902# VSS sky130_fd_pr__nfet_01v8 ad=0.2842 pd=2.54 as=0.2842 ps=2.54 w=0.98 l=0.15
X80 VDD a_43227_20916# a_44027_20496# VDD sky130_fd_pr__pfet_01v8 ad=1.4616 pd=10.66 as=1.4616 ps=10.66 w=5.04 l=0.15
X81 VSS macro_core.array_and_peripherals.write_driver_0.WE a_68415_16496# VSS sky130_fd_pr__nfet_01v8 ad=1.4616 pd=10.66 as=1.4616 ps=10.66 w=5.04 l=0.15
X82 VDD macro_core.array_and_peripherals.sense_amp_7.SA_OUT macro_core.array_and_peripherals.sense_amp_7.SA_OUTB VDD sky130_fd_pr__pfet_01v8 ad=0.5481 pd=4.36 as=0.5481 ps=4.36 w=1.89 l=0.15
X83 VSS macro_core.array_and_peripherals.wl_driver_2.WL_IN a_36227_51432# VSS sky130_fd_pr__nfet_01v8 ad=0.4872 pd=3.94 as=0.4872 ps=3.94 w=1.68 l=0.15
X84 macro_core.array_and_peripherals.write_driver_3.BLB macro_core.array_and_peripherals.precharge_0.PRECH macro_core.array_and_peripherals.write_driver_3.BL VDD sky130_fd_pr__pfet_01v8 ad=0.7308 pd=5.62 as=0.7308 ps=5.62 w=2.52 l=0.15
X85 a_67215_45974# a_67167_45886# VSS VSS sky130_fd_pr__nfet_01v8 ad=0.3654 pd=3.1 as=0.3654 ps=3.1 w=1.26 l=0.15
X86 a_49167_45886# a_49215_45974# VSS VSS sky130_fd_pr__nfet_01v8 ad=0.3654 pd=3.1 as=0.3654 ps=3.1 w=1.26 l=0.15
X87 a_73615_26902# macro_core.array_and_peripherals.sense_amp_5.SA_OUTB macro_core.array_and_peripherals.sense_amp_5.SA_OUT VSS sky130_fd_pr__nfet_01v8 ad=0.2842 pd=2.54 as=0.2842 ps=2.54 w=0.98 l=0.15
X88 a_85167_45886# macro_core.array_and_peripherals.wl_driver_1.WL macro_core.array_and_peripherals.write_driver_7.BLB VSS sky130_fd_pr__nfet_01v8 ad=0.174 pd=1.78 as=0.174 ps=1.78 w=0.6 l=0.15
X89 a_49167_50886# a_49215_50974# VDD VDD sky130_fd_pr__pfet_01v8 ad=0.1218 pd=1.42 as=0.1218 ps=1.42 w=0.42 l=0.15
X90 VSS macro_core.array_and_peripherals.write_driver_0.WE a_82015_16496# VSS sky130_fd_pr__nfet_01v8 ad=1.4616 pd=10.66 as=1.4616 ps=10.66 w=5.04 l=0.15
X91 a_55215_40974# a_55167_40886# VSS VSS sky130_fd_pr__nfet_01v8 ad=0.3654 pd=3.1 as=0.3654 ps=3.1 w=1.26 l=0.15
X92 a_55215_55974# a_55167_55886# VSS VSS sky130_fd_pr__nfet_01v8 ad=0.3654 pd=3.1 as=0.3654 ps=3.1 w=1.26 l=0.15
X93 a_73167_40886# macro_core.array_and_peripherals.wl_driver_0.WL macro_core.array_and_peripherals.write_driver_5.BLB VSS sky130_fd_pr__nfet_01v8 ad=0.174 pd=1.78 as=0.174 ps=1.78 w=0.6 l=0.15
X94 a_73167_55886# macro_core.array_and_peripherals.wl_driver_3.WL macro_core.array_and_peripherals.write_driver_5.BLB VSS sky130_fd_pr__nfet_01v8 ad=0.174 pd=1.78 as=0.174 ps=1.78 w=0.6 l=0.15
X95 a_86027_20496# macro_core.array_and_peripherals.write_driver_7.DATA_B macro_core.array_and_peripherals.write_driver_7.BL VDD sky130_fd_pr__pfet_01v8 ad=1.4616 pd=10.66 as=1.4616 ps=10.66 w=5.04 l=0.15
X96 a_63627_20496# macro_core.array_and_peripherals.write_driver_3.DATA macro_core.array_and_peripherals.write_driver_3.BLB VDD sky130_fd_pr__pfet_01v8 ad=1.4616 pd=10.66 as=1.4616 ps=10.66 w=5.04 l=0.15
X97 VDD a_73227_20916# a_75627_20496# VDD sky130_fd_pr__pfet_01v8 ad=1.4616 pd=10.66 as=1.4616 ps=10.66 w=5.04 l=0.15
X98 VDD macro_core.array_and_peripherals.row_decoder_0.PCLK macro_core.array_and_peripherals.row_decoder_0.N0 VDD sky130_fd_pr__pfet_01v8 ad=0.3625 pd=3.08 as=0.3625 ps=3.08 w=1.25 l=0.15
X99 a_73215_45974# a_73167_45886# VDD VDD sky130_fd_pr__pfet_01v8 ad=0.1218 pd=1.42 as=0.1218 ps=1.42 w=0.42 l=0.15
X100 VSS macro_core.array_and_peripherals.write_driver_0.WE a_85227_20916# VSS sky130_fd_pr__nfet_01v8 ad=0.2436 pd=2.26 as=0.2436 ps=2.26 w=0.84 l=0.15
X101 a_43215_50974# a_43167_50886# VSS VSS sky130_fd_pr__nfet_01v8 ad=0.3654 pd=3.1 as=0.3654 ps=3.1 w=1.26 l=0.15
X102 VSS macro_core.array_and_peripherals.row_decoder_0.N2 macro_core.array_and_peripherals.row_decoder_0.DEC2 VSS sky130_fd_pr__nfet_01v8 ad=0.58 pd=4.58 as=0.58 ps=4.58 w=2 l=0.15
X103 VDD macro_core.array_and_peripherals.precharge_0.PRECH macro_core.array_and_peripherals.write_driver_7.BLB VDD sky130_fd_pr__pfet_01v8 ad=0.7308 pd=5.62 as=0.7308 ps=5.62 w=2.52 l=0.15
X104 a_79215_50974# macro_core.array_and_peripherals.wl_driver_2.WL macro_core.array_and_peripherals.write_driver_6.BL VSS sky130_fd_pr__nfet_01v8 ad=0.174 pd=1.78 as=0.174 ps=1.78 w=0.6 l=0.15
X105 a_61167_50886# macro_core.array_and_peripherals.wl_driver_2.WL macro_core.array_and_peripherals.write_driver_3.BLB VSS sky130_fd_pr__nfet_01v8 ad=0.174 pd=1.78 as=0.174 ps=1.78 w=0.6 l=0.15
X106 a_61215_55974# a_61167_55886# VDD VDD sky130_fd_pr__pfet_01v8 ad=0.1218 pd=1.42 as=0.1218 ps=1.42 w=0.42 l=0.15
X107 a_61215_40974# a_61167_40886# VDD VDD sky130_fd_pr__pfet_01v8 ad=0.1218 pd=1.42 as=0.1218 ps=1.42 w=0.42 l=0.15
X108 VDD macro_core.array_and_peripherals.write_driver_0.WE a_67227_20916# VDD sky130_fd_pr__pfet_01v8 ad=0.2436 pd=2.26 as=0.2436 ps=2.26 w=0.84 l=0.15
X109 VDD macro_core.array_and_peripherals.sense_amp_0.SA_OUTB macro_core.array_and_peripherals.sense_amp_0.SA_OUT VDD sky130_fd_pr__pfet_01v8 ad=0.5481 pd=4.36 as=0.5481 ps=4.36 w=1.89 l=0.15
X110 VSS macro_core.array_and_peripherals.row_decoder_0.N1 macro_core.array_and_peripherals.row_decoder_0.DEC1 VSS sky130_fd_pr__nfet_01v8 ad=0.58 pd=4.58 as=0.58 ps=4.58 w=2 l=0.15
X111 a_73615_26902# macro_core.array_and_peripherals.sense_amp_5.SA_OUT macro_core.array_and_peripherals.sense_amp_5.SA_OUTB VSS sky130_fd_pr__nfet_01v8 ad=0.2842 pd=2.54 as=0.2842 ps=2.54 w=0.98 l=0.15
X112 macro_core.array_and_peripherals.sense_amp_5.SA_OUT macro_core.array_and_peripherals.sense_amp_0.SCLK macro_core.array_and_peripherals.write_driver_5.BL VDD sky130_fd_pr__pfet_01v8 ad=0.58 pd=4.58 as=0.58 ps=4.58 w=2 l=0.15
X113 macro_core.array_and_peripherals.write_driver_3.BLB macro_core.array_and_peripherals.sense_amp_0.SCLK macro_core.array_and_peripherals.sense_amp_3.SA_OUTB VDD sky130_fd_pr__pfet_01v8 ad=0.58 pd=4.58 as=0.58 ps=4.58 w=2 l=0.15
X114 a_49215_45974# macro_core.array_and_peripherals.wl_driver_1.WL macro_core.array_and_peripherals.write_driver_1.BL VSS sky130_fd_pr__nfet_01v8 ad=0.174 pd=1.78 as=0.174 ps=1.78 w=0.6 l=0.15
X115 a_79215_40974# a_79167_40886# VDD VDD sky130_fd_pr__pfet_01v8 ad=0.1218 pd=1.42 as=0.1218 ps=1.42 w=0.42 l=0.15
X116 a_79215_55974# a_79167_55886# VDD VDD sky130_fd_pr__pfet_01v8 ad=0.1218 pd=1.42 as=0.1218 ps=1.42 w=0.42 l=0.15
X117 VDD macro_core.array_and_peripherals.row_decoder_0.N2 macro_core.array_and_peripherals.row_decoder_0.DEC2 VDD sky130_fd_pr__pfet_01v8 ad=0.87 pd=6.58 as=0.87 ps=6.58 w=3 l=0.15
X118 a_85167_40886# a_85215_40974# VSS VSS sky130_fd_pr__nfet_01v8 ad=0.3654 pd=3.1 as=0.3654 ps=3.1 w=1.26 l=0.15
X119 a_85167_55886# a_85215_55974# VSS VSS sky130_fd_pr__nfet_01v8 ad=0.3654 pd=3.1 as=0.3654 ps=3.1 w=1.26 l=0.15
X120 VDD a_36227_51432# macro_core.array_and_peripherals.wl_driver_2.WL VDD sky130_fd_pr__pfet_01v8 ad=1.4616 pd=10.66 as=1.4616 ps=10.66 w=5.04 l=0.15
X121 a_67215_45974# macro_core.array_and_peripherals.wl_driver_1.WL macro_core.array_and_peripherals.write_driver_4.BL VSS sky130_fd_pr__nfet_01v8 ad=0.174 pd=1.78 as=0.174 ps=1.78 w=0.6 l=0.15
X122 a_67215_50974# a_67167_50886# VDD VDD sky130_fd_pr__pfet_01v8 ad=0.1218 pd=1.42 as=0.1218 ps=1.42 w=0.42 l=0.15
X123 a_73167_50886# a_73215_50974# VSS VSS sky130_fd_pr__nfet_01v8 ad=0.3654 pd=3.1 as=0.3654 ps=3.1 w=1.26 l=0.15
X124 a_58015_16496# macro_core.array_and_peripherals.write_driver_2.DATA macro_core.array_and_peripherals.write_driver_2.BLB VSS sky130_fd_pr__nfet_01v8 ad=1.4616 pd=10.66 as=1.4616 ps=10.66 w=5.04 l=0.15
X125 a_67167_45886# a_67215_45974# VDD VDD sky130_fd_pr__pfet_01v8 ad=0.1218 pd=1.42 as=0.1218 ps=1.42 w=0.42 l=0.15
X126 VSS macro_core.array_and_peripherals.write_driver_0.WE a_46015_16496# VSS sky130_fd_pr__nfet_01v8 ad=1.4616 pd=10.66 as=1.4616 ps=10.66 w=5.04 l=0.15
X127 VDD macro_core.array_and_peripherals.row_decoder_0.N1 macro_core.array_and_peripherals.row_decoder_0.DEC1 VDD sky130_fd_pr__pfet_01v8 ad=0.87 pd=6.58 as=0.87 ps=6.58 w=3 l=0.15
X128 VDD macro_core.array_and_peripherals.precharge_0.PRECH macro_core.array_and_peripherals.write_driver_0.BL VDD sky130_fd_pr__pfet_01v8 ad=0.7308 pd=5.62 as=0.7308 ps=5.62 w=2.52 l=0.15
X129 a_55215_40974# macro_core.array_and_peripherals.wl_driver_0.WL macro_core.array_and_peripherals.write_driver_2.BL VSS sky130_fd_pr__nfet_01v8 ad=0.174 pd=1.78 as=0.174 ps=1.78 w=0.6 l=0.15
X130 a_55215_55974# macro_core.array_and_peripherals.wl_driver_3.WL macro_core.array_and_peripherals.write_driver_2.BL VSS sky130_fd_pr__nfet_01v8 ad=0.174 pd=1.78 as=0.174 ps=1.78 w=0.6 l=0.15
X131 a_55167_55886# a_55215_55974# VDD VDD sky130_fd_pr__pfet_01v8 ad=0.1218 pd=1.42 as=0.1218 ps=1.42 w=0.42 l=0.15
X132 VDD macro_core.array_and_peripherals.row_decoder_0.PCLK macro_core.array_and_peripherals.row_decoder_0.N2 VDD sky130_fd_pr__pfet_01v8 ad=0.3625 pd=3.08 as=0.3625 ps=3.08 w=1.25 l=0.15
X133 a_55167_40886# a_55215_40974# VDD VDD sky130_fd_pr__pfet_01v8 ad=0.1218 pd=1.42 as=0.1218 ps=1.42 w=0.42 l=0.15
X134 VSS macro_core.array_and_peripherals.write_driver_0.WE a_62415_16496# VSS sky130_fd_pr__nfet_01v8 ad=1.4616 pd=10.66 as=1.4616 ps=10.66 w=5.04 l=0.15
X135 a_74415_16496# macro_core.array_and_peripherals.write_driver_5.DATA_B macro_core.array_and_peripherals.write_driver_5.BL VSS sky130_fd_pr__nfet_01v8 ad=1.4616 pd=10.66 as=1.4616 ps=10.66 w=5.04 l=0.15
X136 VDD macro_core.array_and_peripherals.sense_amp_6.SA_OUT macro_core.array_and_peripherals.sense_amp_6.SA_OUTB VDD sky130_fd_pr__pfet_01v8 ad=0.5481 pd=4.36 as=0.5481 ps=4.36 w=1.89 l=0.15
X137 VSS macro_core.array_and_peripherals.write_driver_0.WE a_49227_20916# VSS sky130_fd_pr__nfet_01v8 ad=0.2436 pd=2.26 as=0.2436 ps=2.26 w=0.84 l=0.15
X138 a_61215_45974# a_61167_45886# VSS VSS sky130_fd_pr__nfet_01v8 ad=0.3654 pd=3.1 as=0.3654 ps=3.1 w=1.26 l=0.15
X139 a_43167_45886# a_43215_45974# VSS VSS sky130_fd_pr__nfet_01v8 ad=0.3654 pd=3.1 as=0.3654 ps=3.1 w=1.26 l=0.15
X140 a_43215_50974# macro_core.array_and_peripherals.wl_driver_2.WL macro_core.array_and_peripherals.write_driver_0.BL VSS sky130_fd_pr__nfet_01v8 ad=0.174 pd=1.78 as=0.174 ps=1.78 w=0.6 l=0.15
X141 a_79167_45886# macro_core.array_and_peripherals.wl_driver_1.WL macro_core.array_and_peripherals.write_driver_6.BLB VSS sky130_fd_pr__nfet_01v8 ad=0.174 pd=1.78 as=0.174 ps=1.78 w=0.6 l=0.15
X142 VSS macro_core.array_and_peripherals.sense_amp_0.SCLK a_73615_26902# VSS sky130_fd_pr__nfet_01v8 ad=0.2842 pd=2.54 as=0.2842 ps=2.54 w=0.98 l=0.15
X143 VDD a_55227_20916# a_56027_20496# VDD sky130_fd_pr__pfet_01v8 ad=1.4616 pd=10.66 as=1.4616 ps=10.66 w=5.04 l=0.15
X144 a_43167_50886# a_43215_50974# VDD VDD sky130_fd_pr__pfet_01v8 ad=0.1218 pd=1.42 as=0.1218 ps=1.42 w=0.42 l=0.15
X145 macro_core.array_and_peripherals.row_decoder_0.EVAL_GND macro_core.array_and_peripherals.row_decoder_0.A0B macro_core.array_and_peripherals.row_decoder_0.net3 VSS sky130_fd_pr__nfet_01v8 ad=0.58 pd=4.58 as=0.58 ps=4.58 w=2 l=0.15
X146 macro_core.array_and_peripherals.write_driver_5.BLB macro_core.array_and_peripherals.precharge_0.PRECH macro_core.array_and_peripherals.write_driver_5.BL VDD sky130_fd_pr__pfet_01v8 ad=0.7308 pd=5.62 as=0.7308 ps=5.62 w=2.52 l=0.15
X147 a_79215_45974# a_79167_45886# VSS VSS sky130_fd_pr__nfet_01v8 ad=0.3654 pd=3.1 as=0.3654 ps=3.1 w=1.26 l=0.15
X148 a_80027_20496# macro_core.array_and_peripherals.write_driver_6.DATA_B macro_core.array_and_peripherals.write_driver_6.BL VDD sky130_fd_pr__pfet_01v8 ad=1.4616 pd=10.66 as=1.4616 ps=10.66 w=5.04 l=0.15
X149 a_85615_26902# macro_core.array_and_peripherals.sense_amp_7.SA_OUTB macro_core.array_and_peripherals.sense_amp_7.SA_OUT VSS sky130_fd_pr__nfet_01v8 ad=0.2842 pd=2.54 as=0.2842 ps=2.54 w=0.98 l=0.15
X150 VSS macro_core.array_and_peripherals.wl_driver_1.WL_IN a_36227_46432# VSS sky130_fd_pr__nfet_01v8 ad=0.4872 pd=3.94 as=0.4872 ps=3.94 w=1.68 l=0.15
X151 VDD macro_core.array_and_peripherals.precharge_0.PRECH macro_core.array_and_peripherals.write_driver_6.BLB VDD sky130_fd_pr__pfet_01v8 ad=0.7308 pd=5.62 as=0.7308 ps=5.62 w=2.52 l=0.15
X152 a_67215_40974# a_67167_40886# VSS VSS sky130_fd_pr__nfet_01v8 ad=0.3654 pd=3.1 as=0.3654 ps=3.1 w=1.26 l=0.15
X153 a_67215_55974# a_67167_55886# VSS VSS sky130_fd_pr__nfet_01v8 ad=0.3654 pd=3.1 as=0.3654 ps=3.1 w=1.26 l=0.15
X154 macro_core.array_and_peripherals.row_decoder_0.EVAL_GND macro_core.array_and_peripherals.row_decoder_0.A0T macro_core.array_and_peripherals.row_decoder_0.net2 VSS sky130_fd_pr__nfet_01v8 ad=0.58 pd=4.58 as=0.58 ps=4.58 w=2 l=0.15
X155 a_49167_40886# a_49215_40974# VSS VSS sky130_fd_pr__nfet_01v8 ad=0.3654 pd=3.1 as=0.3654 ps=3.1 w=1.26 l=0.15
X156 VDD macro_core.array_and_peripherals.wl_driver_1.WL_IN a_36227_46432# VDD sky130_fd_pr__pfet_01v8 ad=0.4872 pd=3.94 as=0.4872 ps=3.94 w=1.68 l=0.15
X157 a_49167_55886# a_49215_55974# VSS VSS sky130_fd_pr__nfet_01v8 ad=0.3654 pd=3.1 as=0.3654 ps=3.1 w=1.26 l=0.15
X158 a_85167_40886# macro_core.array_and_peripherals.wl_driver_0.WL macro_core.array_and_peripherals.write_driver_7.BLB VSS sky130_fd_pr__nfet_01v8 ad=0.174 pd=1.78 as=0.174 ps=1.78 w=0.6 l=0.15
X159 a_85167_55886# macro_core.array_and_peripherals.wl_driver_3.WL macro_core.array_and_peripherals.write_driver_7.BLB VSS sky130_fd_pr__nfet_01v8 ad=0.174 pd=1.78 as=0.174 ps=1.78 w=0.6 l=0.15
X160 VDD a_85227_20916# a_87627_20496# VDD sky130_fd_pr__pfet_01v8 ad=1.4616 pd=10.66 as=1.4616 ps=10.66 w=5.04 l=0.15
X161 a_75627_20496# macro_core.array_and_peripherals.write_driver_5.DATA macro_core.array_and_peripherals.write_driver_5.BLB VDD sky130_fd_pr__pfet_01v8 ad=1.4616 pd=10.66 as=1.4616 ps=10.66 w=5.04 l=0.15
X162 VDD macro_core.array_and_peripherals.write_driver_0.WE a_61227_20916# VDD sky130_fd_pr__pfet_01v8 ad=0.2436 pd=2.26 as=0.2436 ps=2.26 w=0.84 l=0.15
X163 VSS macro_core.array_and_peripherals.row_decoder_0.A0 macro_core.array_and_peripherals.row_decoder_0.A0B VSS sky130_fd_pr__nfet_01v8 ad=0.2436 pd=2.26 as=0.2436 ps=2.26 w=0.84 l=0.15
X164 a_85215_45974# a_85167_45886# VDD VDD sky130_fd_pr__pfet_01v8 ad=0.1218 pd=1.42 as=0.1218 ps=1.42 w=0.42 l=0.15
X165 a_55215_50974# a_55167_50886# VSS VSS sky130_fd_pr__nfet_01v8 ad=0.3654 pd=3.1 as=0.3654 ps=3.1 w=1.26 l=0.15
X166 a_73167_50886# macro_core.array_and_peripherals.wl_driver_2.WL macro_core.array_and_peripherals.write_driver_5.BLB VSS sky130_fd_pr__nfet_01v8 ad=0.174 pd=1.78 as=0.174 ps=1.78 w=0.6 l=0.15
X167 VDD macro_core.array_and_peripherals.row_decoder_0.PCLK macro_core.array_and_peripherals.row_decoder_0.N3 VDD sky130_fd_pr__pfet_01v8 ad=0.3625 pd=3.08 as=0.3625 ps=3.08 w=1.25 l=0.15
X168 a_73215_40974# a_73167_40886# VDD VDD sky130_fd_pr__pfet_01v8 ad=0.1218 pd=1.42 as=0.1218 ps=1.42 w=0.42 l=0.15
X169 a_73215_55974# a_73167_55886# VDD VDD sky130_fd_pr__pfet_01v8 ad=0.1218 pd=1.42 as=0.1218 ps=1.42 w=0.42 l=0.15
X170 VDD macro_core.array_and_peripherals.write_driver_0.WE a_79227_20916# VDD sky130_fd_pr__pfet_01v8 ad=0.2436 pd=2.26 as=0.2436 ps=2.26 w=0.84 l=0.15
X171 VDD macro_core.array_and_peripherals.sense_amp_2.SA_OUTB macro_core.array_and_peripherals.sense_amp_2.SA_OUT VDD sky130_fd_pr__pfet_01v8 ad=0.5481 pd=4.36 as=0.5481 ps=4.36 w=1.89 l=0.15
X172 VDD macro_core.array_and_peripherals.sense_amp_0.SA_OUT macro_core.array_and_peripherals.sense_amp_0.SA_OUTB VDD sky130_fd_pr__pfet_01v8 ad=0.5481 pd=4.36 as=0.5481 ps=4.36 w=1.89 l=0.15
X173 a_85615_26902# macro_core.array_and_peripherals.sense_amp_7.SA_OUT macro_core.array_and_peripherals.sense_amp_7.SA_OUTB VSS sky130_fd_pr__nfet_01v8 ad=0.2842 pd=2.54 as=0.2842 ps=2.54 w=0.98 l=0.15
X174 a_61215_50974# a_61167_50886# VDD VDD sky130_fd_pr__pfet_01v8 ad=0.1218 pd=1.42 as=0.1218 ps=1.42 w=0.42 l=0.15
X175 macro_core.array_and_peripherals.sense_amp_7.SA_OUT macro_core.array_and_peripherals.sense_amp_0.SCLK macro_core.array_and_peripherals.write_driver_7.BL VDD sky130_fd_pr__pfet_01v8 ad=0.58 pd=4.58 as=0.58 ps=4.58 w=2 l=0.15
X176 macro_core.array_and_peripherals.write_driver_5.BLB macro_core.array_and_peripherals.sense_amp_0.SCLK macro_core.array_and_peripherals.sense_amp_5.SA_OUTB VDD sky130_fd_pr__pfet_01v8 ad=0.58 pd=4.58 as=0.58 ps=4.58 w=2 l=0.15
X177 a_61215_45974# macro_core.array_and_peripherals.wl_driver_1.WL macro_core.array_and_peripherals.write_driver_3.BL VSS sky130_fd_pr__nfet_01v8 ad=0.174 pd=1.78 as=0.174 ps=1.78 w=0.6 l=0.15
X178 a_43167_45886# macro_core.array_and_peripherals.wl_driver_1.WL macro_core.array_and_peripherals.write_driver_0.BLB VSS sky130_fd_pr__nfet_01v8 ad=0.174 pd=1.78 as=0.174 ps=1.78 w=0.6 l=0.15
X179 a_52015_16496# macro_core.array_and_peripherals.write_driver_1.DATA macro_core.array_and_peripherals.write_driver_1.BLB VSS sky130_fd_pr__nfet_01v8 ad=1.4616 pd=10.66 as=1.4616 ps=10.66 w=5.04 l=0.15
X180 a_61167_45886# a_61215_45974# VDD VDD sky130_fd_pr__pfet_01v8 ad=0.1218 pd=1.42 as=0.1218 ps=1.42 w=0.42 l=0.15
X181 a_49215_40974# macro_core.array_and_peripherals.wl_driver_0.WL macro_core.array_and_peripherals.write_driver_1.BL VSS sky130_fd_pr__nfet_01v8 ad=0.174 pd=1.78 as=0.174 ps=1.78 w=0.6 l=0.15
X182 a_49215_55974# macro_core.array_and_peripherals.wl_driver_3.WL macro_core.array_and_peripherals.write_driver_1.BL VSS sky130_fd_pr__nfet_01v8 ad=0.174 pd=1.78 as=0.174 ps=1.78 w=0.6 l=0.15
X183 a_79215_50974# a_79167_50886# VDD VDD sky130_fd_pr__pfet_01v8 ad=0.1218 pd=1.42 as=0.1218 ps=1.42 w=0.42 l=0.15
X184 a_44027_20496# macro_core.array_and_peripherals.write_driver_0.DATA_B macro_core.array_and_peripherals.write_driver_0.BL VDD sky130_fd_pr__pfet_01v8 ad=1.4616 pd=10.66 as=1.4616 ps=10.66 w=5.04 l=0.15
X185 a_49615_26902# macro_core.array_and_peripherals.sense_amp_1.SA_OUTB macro_core.array_and_peripherals.sense_amp_1.SA_OUT VSS sky130_fd_pr__nfet_01v8 ad=0.2842 pd=2.54 as=0.2842 ps=2.54 w=0.98 l=0.15
X186 a_85167_50886# a_85215_50974# VSS VSS sky130_fd_pr__nfet_01v8 ad=0.3654 pd=3.1 as=0.3654 ps=3.1 w=1.26 l=0.15
X187 a_79167_45886# a_79215_45974# VDD VDD sky130_fd_pr__pfet_01v8 ad=0.1218 pd=1.42 as=0.1218 ps=1.42 w=0.42 l=0.15
X188 VSS macro_core.array_and_peripherals.write_driver_0.WE a_58015_16496# VSS sky130_fd_pr__nfet_01v8 ad=1.4616 pd=10.66 as=1.4616 ps=10.66 w=5.04 l=0.15
X189 a_70015_16496# macro_core.array_and_peripherals.write_driver_4.DATA macro_core.array_and_peripherals.write_driver_4.BLB VSS sky130_fd_pr__nfet_01v8 ad=1.4616 pd=10.66 as=1.4616 ps=10.66 w=5.04 l=0.15
X190 VSS macro_core.array_and_peripherals.write_driver_0.WE a_43227_20916# VSS sky130_fd_pr__nfet_01v8 ad=0.2436 pd=2.26 as=0.2436 ps=2.26 w=0.84 l=0.15
X191 VDD macro_core.array_and_peripherals.precharge_0.PRECH macro_core.array_and_peripherals.write_driver_2.BL VDD sky130_fd_pr__pfet_01v8 ad=0.7308 pd=5.62 as=0.7308 ps=5.62 w=2.52 l=0.15
X192 VDD macro_core.array_and_peripherals.precharge_0.PRECH macro_core.array_and_peripherals.write_driver_0.BLB VDD sky130_fd_pr__pfet_01v8 ad=0.7308 pd=5.62 as=0.7308 ps=5.62 w=2.52 l=0.15
X193 a_67215_40974# macro_core.array_and_peripherals.wl_driver_0.WL macro_core.array_and_peripherals.write_driver_4.BL VSS sky130_fd_pr__nfet_01v8 ad=0.174 pd=1.78 as=0.174 ps=1.78 w=0.6 l=0.15
X194 a_67215_55974# macro_core.array_and_peripherals.wl_driver_3.WL macro_core.array_and_peripherals.write_driver_4.BL VSS sky130_fd_pr__nfet_01v8 ad=0.174 pd=1.78 as=0.174 ps=1.78 w=0.6 l=0.15
X195 VDD a_49227_20916# a_50027_20496# VDD sky130_fd_pr__pfet_01v8 ad=1.4616 pd=10.66 as=1.4616 ps=10.66 w=5.04 l=0.15
X196 a_67167_55886# a_67215_55974# VDD VDD sky130_fd_pr__pfet_01v8 ad=0.1218 pd=1.42 as=0.1218 ps=1.42 w=0.42 l=0.15
X197 a_67167_40886# a_67215_40974# VDD VDD sky130_fd_pr__pfet_01v8 ad=0.1218 pd=1.42 as=0.1218 ps=1.42 w=0.42 l=0.15
X198 VSS macro_core.array_and_peripherals.write_driver_0.WE a_74415_16496# VSS sky130_fd_pr__nfet_01v8 ad=1.4616 pd=10.66 as=1.4616 ps=10.66 w=5.04 l=0.15
X199 a_86415_16496# macro_core.array_and_peripherals.write_driver_7.DATA_B macro_core.array_and_peripherals.write_driver_7.BL VSS sky130_fd_pr__nfet_01v8 ad=1.4616 pd=10.66 as=1.4616 ps=10.66 w=5.04 l=0.15
X200 a_49215_45974# a_49167_45886# VDD VDD sky130_fd_pr__pfet_01v8 ad=0.1218 pd=1.42 as=0.1218 ps=1.42 w=0.42 l=0.15
X201 macro_core.array_and_peripherals.row_decoder_0.net2 macro_core.array_and_peripherals.row_decoder_0.A1B macro_core.array_and_peripherals.row_decoder_0.N1 VSS sky130_fd_pr__nfet_01v8 ad=0.58 pd=4.58 as=0.58 ps=4.58 w=2 l=0.15
X202 a_73215_45974# a_73167_45886# VSS VSS sky130_fd_pr__nfet_01v8 ad=0.3654 pd=3.1 as=0.3654 ps=3.1 w=1.26 l=0.15
X203 a_55167_45886# a_55215_45974# VSS VSS sky130_fd_pr__nfet_01v8 ad=0.3654 pd=3.1 as=0.3654 ps=3.1 w=1.26 l=0.15
X204 a_55215_50974# macro_core.array_and_peripherals.wl_driver_2.WL macro_core.array_and_peripherals.write_driver_2.BL VSS sky130_fd_pr__nfet_01v8 ad=0.174 pd=1.78 as=0.174 ps=1.78 w=0.6 l=0.15
X205 VSS macro_core.array_and_peripherals.sense_amp_0.SCLK a_85615_26902# VSS sky130_fd_pr__nfet_01v8 ad=0.2842 pd=2.54 as=0.2842 ps=2.54 w=0.98 l=0.15
X206 a_55167_50886# a_55215_50974# VDD VDD sky130_fd_pr__pfet_01v8 ad=0.1218 pd=1.42 as=0.1218 ps=1.42 w=0.42 l=0.15
X207 VDD a_67227_20916# a_68027_20496# VDD sky130_fd_pr__pfet_01v8 ad=1.4616 pd=10.66 as=1.4616 ps=10.66 w=5.04 l=0.15
X208 VDD macro_core.array_and_peripherals.row_decoder_0.DEC2 macro_core.array_and_peripherals.row_decoder_0.N2 VDD sky130_fd_pr__pfet_01v8 ad=0.2436 pd=2.26 as=0.2436 ps=2.26 w=0.84 l=0.15
X209 a_61215_40974# a_61167_40886# VSS VSS sky130_fd_pr__nfet_01v8 ad=0.3654 pd=3.1 as=0.3654 ps=3.1 w=1.26 l=0.15
X210 a_61215_55974# a_61167_55886# VSS VSS sky130_fd_pr__nfet_01v8 ad=0.3654 pd=3.1 as=0.3654 ps=3.1 w=1.26 l=0.15
X211 a_43167_40886# a_43215_40974# VSS VSS sky130_fd_pr__nfet_01v8 ad=0.3654 pd=3.1 as=0.3654 ps=3.1 w=1.26 l=0.15
X212 macro_core.array_and_peripherals.write_driver_7.BLB macro_core.array_and_peripherals.precharge_0.PRECH macro_core.array_and_peripherals.write_driver_7.BL VDD sky130_fd_pr__pfet_01v8 ad=0.7308 pd=5.62 as=0.7308 ps=5.62 w=2.52 l=0.15
X213 a_43167_55886# a_43215_55974# VSS VSS sky130_fd_pr__nfet_01v8 ad=0.3654 pd=3.1 as=0.3654 ps=3.1 w=1.26 l=0.15
X214 a_79167_40886# macro_core.array_and_peripherals.wl_driver_0.WL macro_core.array_and_peripherals.write_driver_6.BLB VSS sky130_fd_pr__nfet_01v8 ad=0.174 pd=1.78 as=0.174 ps=1.78 w=0.6 l=0.15
X215 a_79167_55886# macro_core.array_and_peripherals.wl_driver_3.WL macro_core.array_and_peripherals.write_driver_6.BLB VSS sky130_fd_pr__nfet_01v8 ad=0.174 pd=1.78 as=0.174 ps=1.78 w=0.6 l=0.15
X216 a_69627_20496# macro_core.array_and_peripherals.write_driver_4.DATA macro_core.array_and_peripherals.write_driver_4.BLB VDD sky130_fd_pr__pfet_01v8 ad=1.4616 pd=10.66 as=1.4616 ps=10.66 w=5.04 l=0.15
X217 VDD a_79227_20916# a_81627_20496# VDD sky130_fd_pr__pfet_01v8 ad=1.4616 pd=10.66 as=1.4616 ps=10.66 w=5.04 l=0.15
X218 VDD macro_core.array_and_peripherals.row_decoder_0.DEC1 macro_core.array_and_peripherals.row_decoder_0.N1 VDD sky130_fd_pr__pfet_01v8 ad=0.2436 pd=2.26 as=0.2436 ps=2.26 w=0.84 l=0.15
X219 a_79215_40974# a_79167_40886# VSS VSS sky130_fd_pr__nfet_01v8 ad=0.3654 pd=3.1 as=0.3654 ps=3.1 w=1.26 l=0.15
X220 a_79215_55974# a_79167_55886# VSS VSS sky130_fd_pr__nfet_01v8 ad=0.3654 pd=3.1 as=0.3654 ps=3.1 w=1.26 l=0.15
X221 a_87627_20496# macro_core.array_and_peripherals.write_driver_7.DATA macro_core.array_and_peripherals.write_driver_7.BLB VDD sky130_fd_pr__pfet_01v8 ad=1.4616 pd=10.66 as=1.4616 ps=10.66 w=5.04 l=0.15
X222 VDD macro_core.array_and_peripherals.write_driver_0.WE a_73227_20916# VDD sky130_fd_pr__pfet_01v8 ad=0.2436 pd=2.26 as=0.2436 ps=2.26 w=0.84 l=0.15
X223 VSS macro_core.array_and_peripherals.wl_driver_3.WL_IN a_36227_56432# VSS sky130_fd_pr__nfet_01v8 ad=0.4872 pd=3.94 as=0.4872 ps=3.94 w=1.68 l=0.15
X224 a_67215_50974# a_67167_50886# VSS VSS sky130_fd_pr__nfet_01v8 ad=0.3654 pd=3.1 as=0.3654 ps=3.1 w=1.26 l=0.15
X225 a_49167_50886# a_49215_50974# VSS VSS sky130_fd_pr__nfet_01v8 ad=0.3654 pd=3.1 as=0.3654 ps=3.1 w=1.26 l=0.15
X226 VDD macro_core.array_and_peripherals.wl_driver_3.WL_IN a_36227_56432# VDD sky130_fd_pr__pfet_01v8 ad=0.4872 pd=3.94 as=0.4872 ps=3.94 w=1.68 l=0.15
X227 VDD macro_core.array_and_peripherals.wl_driver_0.WL_IN a_36227_41432# VDD sky130_fd_pr__pfet_01v8 ad=0.4872 pd=3.94 as=0.4872 ps=3.94 w=1.68 l=0.15
X228 a_85167_50886# macro_core.array_and_peripherals.wl_driver_2.WL macro_core.array_and_peripherals.write_driver_7.BLB VSS sky130_fd_pr__nfet_01v8 ad=0.174 pd=1.78 as=0.174 ps=1.78 w=0.6 l=0.15
X229 VSS a_36227_41432# macro_core.array_and_peripherals.wl_driver_0.WL VSS sky130_fd_pr__nfet_01v8 ad=1.4616 pd=10.66 as=1.4616 ps=10.66 w=5.04 l=0.15
X230 a_79615_26902# macro_core.array_and_peripherals.sense_amp_6.SA_OUT macro_core.array_and_peripherals.sense_amp_6.SA_OUTB VSS sky130_fd_pr__nfet_01v8 ad=0.2842 pd=2.54 as=0.2842 ps=2.54 w=0.98 l=0.15
X231 macro_core.array_and_peripherals.sense_amp_6.SA_OUT macro_core.array_and_peripherals.sense_amp_0.SCLK macro_core.array_and_peripherals.write_driver_6.BL VDD sky130_fd_pr__pfet_01v8 ad=0.58 pd=4.58 as=0.58 ps=4.58 w=2 l=0.15
X232 a_85215_55974# a_85167_55886# VDD VDD sky130_fd_pr__pfet_01v8 ad=0.1218 pd=1.42 as=0.1218 ps=1.42 w=0.42 l=0.15
X233 a_85215_40974# a_85167_40886# VDD VDD sky130_fd_pr__pfet_01v8 ad=0.1218 pd=1.42 as=0.1218 ps=1.42 w=0.42 l=0.15
X234 VDD macro_core.array_and_peripherals.sense_amp_4.SA_OUTB macro_core.array_and_peripherals.sense_amp_4.SA_OUT VDD sky130_fd_pr__pfet_01v8 ad=0.5481 pd=4.36 as=0.5481 ps=4.36 w=1.89 l=0.15
X235 VDD macro_core.array_and_peripherals.sense_amp_2.SA_OUT macro_core.array_and_peripherals.sense_amp_2.SA_OUTB VDD sky130_fd_pr__pfet_01v8 ad=0.5481 pd=4.36 as=0.5481 ps=4.36 w=1.89 l=0.15
X236 macro_core.array_and_peripherals.write_driver_7.BLB macro_core.array_and_peripherals.sense_amp_0.SCLK macro_core.array_and_peripherals.sense_amp_7.SA_OUTB VDD sky130_fd_pr__pfet_01v8 ad=0.58 pd=4.58 as=0.58 ps=4.58 w=2 l=0.15
X237 VDD macro_core.array_and_peripherals.row_decoder_0.A0B macro_core.array_and_peripherals.row_decoder_0.A0T VDD sky130_fd_pr__pfet_01v8 ad=0.58 pd=4.58 as=0.58 ps=4.58 w=2 l=0.15
X238 a_73215_45974# macro_core.array_and_peripherals.wl_driver_1.WL macro_core.array_and_peripherals.write_driver_5.BL VSS sky130_fd_pr__nfet_01v8 ad=0.174 pd=1.78 as=0.174 ps=1.78 w=0.6 l=0.15
X239 a_73215_50974# a_73167_50886# VDD VDD sky130_fd_pr__pfet_01v8 ad=0.1218 pd=1.42 as=0.1218 ps=1.42 w=0.42 l=0.15
X240 a_43615_26902# macro_core.array_and_peripherals.sense_amp_0.SA_OUTB macro_core.array_and_peripherals.sense_amp_0.SA_OUT VSS sky130_fd_pr__nfet_01v8 ad=0.2842 pd=2.54 as=0.2842 ps=2.54 w=0.98 l=0.15
X241 a_55167_45886# macro_core.array_and_peripherals.wl_driver_1.WL macro_core.array_and_peripherals.write_driver_2.BLB VSS sky130_fd_pr__nfet_01v8 ad=0.174 pd=1.78 as=0.174 ps=1.78 w=0.6 l=0.15
X242 a_73167_45886# a_73215_45974# VDD VDD sky130_fd_pr__pfet_01v8 ad=0.1218 pd=1.42 as=0.1218 ps=1.42 w=0.42 l=0.15
X243 VSS macro_core.array_and_peripherals.write_driver_0.WE a_52015_16496# VSS sky130_fd_pr__nfet_01v8 ad=1.4616 pd=10.66 as=1.4616 ps=10.66 w=5.04 l=0.15
X244 a_64015_16496# macro_core.array_and_peripherals.write_driver_3.DATA macro_core.array_and_peripherals.write_driver_3.BLB VSS sky130_fd_pr__nfet_01v8 ad=1.4616 pd=10.66 as=1.4616 ps=10.66 w=5.04 l=0.15
X245 VSS macro_core.array_and_peripherals.row_decoder_0.N0 macro_core.array_and_peripherals.row_decoder_0.DEC0 VSS sky130_fd_pr__nfet_01v8 ad=0.58 pd=4.58 as=0.58 ps=4.58 w=2 l=0.15
X246 a_61215_40974# macro_core.array_and_peripherals.wl_driver_0.WL macro_core.array_and_peripherals.write_driver_3.BL VSS sky130_fd_pr__nfet_01v8 ad=0.174 pd=1.78 as=0.174 ps=1.78 w=0.6 l=0.15
X247 a_61215_55974# macro_core.array_and_peripherals.wl_driver_3.WL macro_core.array_and_peripherals.write_driver_3.BL VSS sky130_fd_pr__nfet_01v8 ad=0.174 pd=1.78 as=0.174 ps=1.78 w=0.6 l=0.15
X248 a_43167_40886# macro_core.array_and_peripherals.wl_driver_0.WL macro_core.array_and_peripherals.write_driver_0.BLB VSS sky130_fd_pr__nfet_01v8 ad=0.174 pd=1.78 as=0.174 ps=1.78 w=0.6 l=0.15
X249 a_43167_55886# macro_core.array_and_peripherals.wl_driver_3.WL macro_core.array_and_peripherals.write_driver_0.BLB VSS sky130_fd_pr__nfet_01v8 ad=0.174 pd=1.78 as=0.174 ps=1.78 w=0.6 l=0.15
X250 a_61167_55886# a_61215_55974# VDD VDD sky130_fd_pr__pfet_01v8 ad=0.1218 pd=1.42 as=0.1218 ps=1.42 w=0.42 l=0.15
X251 VDD a_43227_20916# a_45627_20496# VDD sky130_fd_pr__pfet_01v8 ad=1.4616 pd=10.66 as=1.4616 ps=10.66 w=5.04 l=0.15
X252 a_56027_20496# macro_core.array_and_peripherals.write_driver_2.DATA_B macro_core.array_and_peripherals.write_driver_2.BL VDD sky130_fd_pr__pfet_01v8 ad=1.4616 pd=10.66 as=1.4616 ps=10.66 w=5.04 l=0.15
X253 VSS macro_core.array_and_peripherals.row_decoder_0.PCLK macro_core.array_and_peripherals.row_decoder_0.EVAL_GND VSS sky130_fd_pr__nfet_01v8 ad=0.435 pd=3.58 as=0.435 ps=3.58 w=1.5 l=0.15
X254 a_61167_40886# a_61215_40974# VDD VDD sky130_fd_pr__pfet_01v8 ad=0.1218 pd=1.42 as=0.1218 ps=1.42 w=0.42 l=0.15
X255 a_80415_16496# macro_core.array_and_peripherals.write_driver_6.DATA_B macro_core.array_and_peripherals.write_driver_6.BL VSS sky130_fd_pr__nfet_01v8 ad=1.4616 pd=10.66 as=1.4616 ps=10.66 w=5.04 l=0.15
X256 a_43215_45974# a_43167_45886# VDD VDD sky130_fd_pr__pfet_01v8 ad=0.1218 pd=1.42 as=0.1218 ps=1.42 w=0.42 l=0.15
X257 VSS macro_core.array_and_peripherals.write_driver_0.WE a_55227_20916# VSS sky130_fd_pr__nfet_01v8 ad=0.2436 pd=2.26 as=0.2436 ps=2.26 w=0.84 l=0.15
X258 VDD macro_core.array_and_peripherals.precharge_0.PRECH macro_core.array_and_peripherals.write_driver_4.BL VDD sky130_fd_pr__pfet_01v8 ad=0.7308 pd=5.62 as=0.7308 ps=5.62 w=2.52 l=0.15
X259 a_49215_50974# macro_core.array_and_peripherals.wl_driver_2.WL macro_core.array_and_peripherals.write_driver_1.BL VSS sky130_fd_pr__nfet_01v8 ad=0.174 pd=1.78 as=0.174 ps=1.78 w=0.6 l=0.15
X260 VDD macro_core.array_and_peripherals.precharge_0.PRECH macro_core.array_and_peripherals.write_driver_2.BLB VDD sky130_fd_pr__pfet_01v8 ad=0.7308 pd=5.62 as=0.7308 ps=5.62 w=2.52 l=0.15
X261 VSS macro_core.array_and_peripherals.sense_amp_0.SCLK a_79615_26902# VSS sky130_fd_pr__nfet_01v8 ad=0.2842 pd=2.54 as=0.2842 ps=2.54 w=0.98 l=0.15
X262 VDD a_61227_20916# a_62027_20496# VDD sky130_fd_pr__pfet_01v8 ad=1.4616 pd=10.66 as=1.4616 ps=10.66 w=5.04 l=0.15
X263 a_79167_40886# a_79215_40974# VDD VDD sky130_fd_pr__pfet_01v8 ad=0.1218 pd=1.42 as=0.1218 ps=1.42 w=0.42 l=0.15
X264 a_79167_55886# a_79215_55974# VDD VDD sky130_fd_pr__pfet_01v8 ad=0.1218 pd=1.42 as=0.1218 ps=1.42 w=0.42 l=0.15
X265 VSS macro_core.array_and_peripherals.write_driver_0.WE a_86415_16496# VSS sky130_fd_pr__nfet_01v8 ad=1.4616 pd=10.66 as=1.4616 ps=10.66 w=5.04 l=0.15
X266 VDD macro_core.array_and_peripherals.row_decoder_0.N0 macro_core.array_and_peripherals.row_decoder_0.DEC0 VDD sky130_fd_pr__pfet_01v8 ad=0.87 pd=6.58 as=0.87 ps=6.58 w=3 l=0.15
X267 macro_core.array_and_peripherals.write_driver_6.BLB macro_core.array_and_peripherals.precharge_0.PRECH macro_core.array_and_peripherals.write_driver_6.BL VDD sky130_fd_pr__pfet_01v8 ad=0.7308 pd=5.62 as=0.7308 ps=5.62 w=2.52 l=0.15
X268 a_85215_45974# a_85167_45886# VSS VSS sky130_fd_pr__nfet_01v8 ad=0.3654 pd=3.1 as=0.3654 ps=3.1 w=1.26 l=0.15
X269 a_67167_45886# a_67215_45974# VSS VSS sky130_fd_pr__nfet_01v8 ad=0.3654 pd=3.1 as=0.3654 ps=3.1 w=1.26 l=0.15
X270 a_67215_50974# macro_core.array_and_peripherals.wl_driver_2.WL macro_core.array_and_peripherals.write_driver_4.BL VSS sky130_fd_pr__nfet_01v8 ad=0.174 pd=1.78 as=0.174 ps=1.78 w=0.6 l=0.15
X271 a_67167_50886# a_67215_50974# VDD VDD sky130_fd_pr__pfet_01v8 ad=0.1218 pd=1.42 as=0.1218 ps=1.42 w=0.42 l=0.15
X272 a_43615_26902# macro_core.array_and_peripherals.sense_amp_0.SA_OUT macro_core.array_and_peripherals.sense_amp_0.SA_OUTB VSS sky130_fd_pr__nfet_01v8 ad=0.2842 pd=2.54 as=0.2842 ps=2.54 w=0.98 l=0.15
X273 macro_core.array_and_peripherals.sense_amp_0.SA_OUT macro_core.array_and_peripherals.sense_amp_0.SCLK macro_core.array_and_peripherals.write_driver_0.BL VDD sky130_fd_pr__pfet_01v8 ad=0.58 pd=4.58 as=0.58 ps=4.58 w=2 l=0.15
X274 a_49215_55974# a_49167_55886# VDD VDD sky130_fd_pr__pfet_01v8 ad=0.1218 pd=1.42 as=0.1218 ps=1.42 w=0.42 l=0.15
X275 a_49215_40974# a_49167_40886# VDD VDD sky130_fd_pr__pfet_01v8 ad=0.1218 pd=1.42 as=0.1218 ps=1.42 w=0.42 l=0.15
X276 a_73215_40974# a_73167_40886# VSS VSS sky130_fd_pr__nfet_01v8 ad=0.3654 pd=3.1 as=0.3654 ps=3.1 w=1.26 l=0.15
X277 a_73215_55974# a_73167_55886# VSS VSS sky130_fd_pr__nfet_01v8 ad=0.3654 pd=3.1 as=0.3654 ps=3.1 w=1.26 l=0.15
X278 a_55167_40886# a_55215_40974# VSS VSS sky130_fd_pr__nfet_01v8 ad=0.3654 pd=3.1 as=0.3654 ps=3.1 w=1.26 l=0.15
X279 a_55167_55886# a_55215_55974# VSS VSS sky130_fd_pr__nfet_01v8 ad=0.3654 pd=3.1 as=0.3654 ps=3.1 w=1.26 l=0.15
X280 a_81627_20496# macro_core.array_and_peripherals.write_driver_6.DATA macro_core.array_and_peripherals.write_driver_6.BLB VDD sky130_fd_pr__pfet_01v8 ad=1.4616 pd=10.66 as=1.4616 ps=10.66 w=5.04 l=0.15
X281 a_61215_50974# a_61167_50886# VSS VSS sky130_fd_pr__nfet_01v8 ad=0.3654 pd=3.1 as=0.3654 ps=3.1 w=1.26 l=0.15
X282 a_43167_50886# a_43215_50974# VSS VSS sky130_fd_pr__nfet_01v8 ad=0.3654 pd=3.1 as=0.3654 ps=3.1 w=1.26 l=0.15
X283 a_79167_50886# macro_core.array_and_peripherals.wl_driver_2.WL macro_core.array_and_peripherals.write_driver_6.BLB VSS sky130_fd_pr__nfet_01v8 ad=0.174 pd=1.78 as=0.174 ps=1.78 w=0.6 l=0.15
X284 VDD macro_core.array_and_peripherals.write_driver_0.WE a_85227_20916# VDD sky130_fd_pr__pfet_01v8 ad=0.2436 pd=2.26 as=0.2436 ps=2.26 w=0.84 l=0.15
X285 a_44415_16496# macro_core.array_and_peripherals.write_driver_0.DATA_B macro_core.array_and_peripherals.write_driver_0.BL VSS sky130_fd_pr__nfet_01v8 ad=1.4616 pd=10.66 as=1.4616 ps=10.66 w=5.04 l=0.15
X286 a_79215_50974# a_79167_50886# VSS VSS sky130_fd_pr__nfet_01v8 ad=0.3654 pd=3.1 as=0.3654 ps=3.1 w=1.26 l=0.15
X287 VDD macro_core.array_and_peripherals.sense_amp_3.SA_OUTB macro_core.array_and_peripherals.sense_amp_3.SA_OUT VDD sky130_fd_pr__pfet_01v8 ad=0.5481 pd=4.36 as=0.5481 ps=4.36 w=1.89 l=0.15
X288 VDD macro_core.array_and_peripherals.sense_amp_1.SA_OUT macro_core.array_and_peripherals.sense_amp_1.SA_OUTB VDD sky130_fd_pr__pfet_01v8 ad=0.5481 pd=4.36 as=0.5481 ps=4.36 w=1.89 l=0.15
X289 macro_core.array_and_peripherals.write_driver_6.BLB macro_core.array_and_peripherals.sense_amp_0.SCLK macro_core.array_and_peripherals.sense_amp_6.SA_OUTB VDD sky130_fd_pr__pfet_01v8 ad=0.58 pd=4.58 as=0.58 ps=4.58 w=2 l=0.15
X290 a_49167_45886# macro_core.array_and_peripherals.wl_driver_1.WL macro_core.array_and_peripherals.write_driver_1.BLB VSS sky130_fd_pr__nfet_01v8 ad=0.174 pd=1.78 as=0.174 ps=1.78 w=0.6 l=0.15
X291 VSS macro_core.array_and_peripherals.sense_amp_0.SCLK a_43615_26902# VSS sky130_fd_pr__nfet_01v8 ad=0.2842 pd=2.54 as=0.2842 ps=2.54 w=0.98 l=0.15
X292 VDD macro_core.array_and_peripherals.wl_driver_2.WL_IN a_36227_51432# VDD sky130_fd_pr__pfet_01v8 ad=0.4872 pd=3.94 as=0.4872 ps=3.94 w=1.68 l=0.15
X293 VDD macro_core.array_and_peripherals.sense_amp_6.SA_OUTB macro_core.array_and_peripherals.sense_amp_6.SA_OUT VDD sky130_fd_pr__pfet_01v8 ad=0.5481 pd=4.36 as=0.5481 ps=4.36 w=1.89 l=0.15
X294 VDD macro_core.array_and_peripherals.sense_amp_4.SA_OUT macro_core.array_and_peripherals.sense_amp_4.SA_OUTB VDD sky130_fd_pr__pfet_01v8 ad=0.5481 pd=4.36 as=0.5481 ps=4.36 w=1.89 l=0.15
X295 VSS a_36227_51432# macro_core.array_and_peripherals.wl_driver_2.WL VSS sky130_fd_pr__nfet_01v8 ad=1.4616 pd=10.66 as=1.4616 ps=10.66 w=5.04 l=0.15
X296 macro_core.array_and_peripherals.write_driver_0.BLB macro_core.array_and_peripherals.precharge_0.PRECH macro_core.array_and_peripherals.write_driver_0.BL VDD sky130_fd_pr__pfet_01v8 ad=0.7308 pd=5.62 as=0.7308 ps=5.62 w=2.52 l=0.15
X297 a_49215_45974# a_49167_45886# VSS VSS sky130_fd_pr__nfet_01v8 ad=0.3654 pd=3.1 as=0.3654 ps=3.1 w=1.26 l=0.15
X298 a_85215_45974# macro_core.array_and_peripherals.wl_driver_1.WL macro_core.array_and_peripherals.write_driver_7.BL VSS sky130_fd_pr__nfet_01v8 ad=0.174 pd=1.78 as=0.174 ps=1.78 w=0.6 l=0.15
X299 a_85215_50974# a_85167_50886# VDD VDD sky130_fd_pr__pfet_01v8 ad=0.1218 pd=1.42 as=0.1218 ps=1.42 w=0.42 l=0.15
X300 a_50027_20496# macro_core.array_and_peripherals.write_driver_1.DATA_B macro_core.array_and_peripherals.write_driver_1.BL VDD sky130_fd_pr__pfet_01v8 ad=1.4616 pd=10.66 as=1.4616 ps=10.66 w=5.04 l=0.15
X301 a_55615_26902# macro_core.array_and_peripherals.sense_amp_2.SA_OUTB macro_core.array_and_peripherals.sense_amp_2.SA_OUT VSS sky130_fd_pr__nfet_01v8 ad=0.2842 pd=2.54 as=0.2842 ps=2.54 w=0.98 l=0.15
X302 a_67167_45886# macro_core.array_and_peripherals.wl_driver_1.WL macro_core.array_and_peripherals.write_driver_4.BLB VSS sky130_fd_pr__nfet_01v8 ad=0.174 pd=1.78 as=0.174 ps=1.78 w=0.6 l=0.15
X303 a_85167_45886# a_85215_45974# VDD VDD sky130_fd_pr__pfet_01v8 ad=0.1218 pd=1.42 as=0.1218 ps=1.42 w=0.42 l=0.15
X304 VSS macro_core.array_and_peripherals.write_driver_0.WE a_64015_16496# VSS sky130_fd_pr__nfet_01v8 ad=1.4616 pd=10.66 as=1.4616 ps=10.66 w=5.04 l=0.15
X305 a_76015_16496# macro_core.array_and_peripherals.write_driver_5.DATA macro_core.array_and_peripherals.write_driver_5.BLB VSS sky130_fd_pr__nfet_01v8 ad=1.4616 pd=10.66 as=1.4616 ps=10.66 w=5.04 l=0.15
X306 VDD macro_core.array_and_peripherals.precharge_0.PRECH macro_core.array_and_peripherals.write_driver_3.BL VDD sky130_fd_pr__pfet_01v8 ad=0.7308 pd=5.62 as=0.7308 ps=5.62 w=2.52 l=0.15
X307 VDD macro_core.array_and_peripherals.precharge_0.PRECH macro_core.array_and_peripherals.write_driver_1.BLB VDD sky130_fd_pr__pfet_01v8 ad=0.7308 pd=5.62 as=0.7308 ps=5.62 w=2.52 l=0.15
X308 a_73215_40974# macro_core.array_and_peripherals.wl_driver_0.WL macro_core.array_and_peripherals.write_driver_5.BL VSS sky130_fd_pr__nfet_01v8 ad=0.174 pd=1.78 as=0.174 ps=1.78 w=0.6 l=0.15
X309 a_73215_55974# macro_core.array_and_peripherals.wl_driver_3.WL macro_core.array_and_peripherals.write_driver_5.BL VSS sky130_fd_pr__nfet_01v8 ad=0.174 pd=1.78 as=0.174 ps=1.78 w=0.6 l=0.15
X310 a_55167_40886# macro_core.array_and_peripherals.wl_driver_0.WL macro_core.array_and_peripherals.write_driver_2.BLB VSS sky130_fd_pr__nfet_01v8 ad=0.174 pd=1.78 as=0.174 ps=1.78 w=0.6 l=0.15
X311 a_55167_55886# macro_core.array_and_peripherals.wl_driver_3.WL macro_core.array_and_peripherals.write_driver_2.BLB VSS sky130_fd_pr__nfet_01v8 ad=0.174 pd=1.78 as=0.174 ps=1.78 w=0.6 l=0.15
X312 a_68027_20496# macro_core.array_and_peripherals.write_driver_4.DATA_B macro_core.array_and_peripherals.write_driver_4.BL VDD sky130_fd_pr__pfet_01v8 ad=1.4616 pd=10.66 as=1.4616 ps=10.66 w=5.04 l=0.15
X313 a_73167_40886# a_73215_40974# VDD VDD sky130_fd_pr__pfet_01v8 ad=0.1218 pd=1.42 as=0.1218 ps=1.42 w=0.42 l=0.15
X314 a_73167_55886# a_73215_55974# VDD VDD sky130_fd_pr__pfet_01v8 ad=0.1218 pd=1.42 as=0.1218 ps=1.42 w=0.42 l=0.15
X315 a_45627_20496# macro_core.array_and_peripherals.write_driver_0.DATA macro_core.array_and_peripherals.write_driver_0.BLB VDD sky130_fd_pr__pfet_01v8 ad=1.4616 pd=10.66 as=1.4616 ps=10.66 w=5.04 l=0.15
X316 VDD a_55227_20916# a_57627_20496# VDD sky130_fd_pr__pfet_01v8 ad=1.4616 pd=10.66 as=1.4616 ps=10.66 w=5.04 l=0.15
X317 VDD macro_core.array_and_peripherals.row_decoder_0.PCLK macro_core.array_and_peripherals.row_decoder_0.N1 VDD sky130_fd_pr__pfet_01v8 ad=0.3625 pd=3.08 as=0.3625 ps=3.08 w=1.25 l=0.15
X318 VSS macro_core.array_and_peripherals.write_driver_0.WE a_80415_16496# VSS sky130_fd_pr__nfet_01v8 ad=1.4616 pd=10.66 as=1.4616 ps=10.66 w=5.04 l=0.15
X319 a_55215_45974# a_55167_45886# VDD VDD sky130_fd_pr__pfet_01v8 ad=0.1218 pd=1.42 as=0.1218 ps=1.42 w=0.42 l=0.15
X320 VSS macro_core.array_and_peripherals.write_driver_0.WE a_67227_20916# VSS sky130_fd_pr__nfet_01v8 ad=0.2436 pd=2.26 as=0.2436 ps=2.26 w=0.84 l=0.15
X321 VSS macro_core.array_and_peripherals.row_decoder_0.N3 macro_core.array_and_peripherals.row_decoder_0.DEC3 VSS sky130_fd_pr__nfet_01v8 ad=0.58 pd=4.58 as=0.58 ps=4.58 w=2 l=0.15
X322 a_61167_45886# a_61215_45974# VSS VSS sky130_fd_pr__nfet_01v8 ad=0.3654 pd=3.1 as=0.3654 ps=3.1 w=1.26 l=0.15
X323 a_61215_50974# macro_core.array_and_peripherals.wl_driver_2.WL macro_core.array_and_peripherals.write_driver_3.BL VSS sky130_fd_pr__nfet_01v8 ad=0.174 pd=1.78 as=0.174 ps=1.78 w=0.6 l=0.15
X324 VDD macro_core.array_and_peripherals.precharge_0.PRECH macro_core.array_and_peripherals.write_driver_6.BL VDD sky130_fd_pr__pfet_01v8 ad=0.7308 pd=5.62 as=0.7308 ps=5.62 w=2.52 l=0.15
X325 VDD macro_core.array_and_peripherals.precharge_0.PRECH macro_core.array_and_peripherals.write_driver_4.BLB VDD sky130_fd_pr__pfet_01v8 ad=0.7308 pd=5.62 as=0.7308 ps=5.62 w=2.52 l=0.15
X326 VDD macro_core.array_and_peripherals.row_decoder_0.A1B macro_core.array_and_peripherals.row_decoder_0.A1T VDD sky130_fd_pr__pfet_01v8 ad=0.58 pd=4.58 as=0.58 ps=4.58 w=2 l=0.15
X327 a_43167_50886# macro_core.array_and_peripherals.wl_driver_2.WL macro_core.array_and_peripherals.write_driver_0.BLB VSS sky130_fd_pr__nfet_01v8 ad=0.174 pd=1.78 as=0.174 ps=1.78 w=0.6 l=0.15
X328 a_61167_50886# a_61215_50974# VDD VDD sky130_fd_pr__pfet_01v8 ad=0.1218 pd=1.42 as=0.1218 ps=1.42 w=0.42 l=0.15
X329 VDD a_73227_20916# a_74027_20496# VDD sky130_fd_pr__pfet_01v8 ad=1.4616 pd=10.66 as=1.4616 ps=10.66 w=5.04 l=0.15
X330 a_43215_55974# a_43167_55886# VDD VDD sky130_fd_pr__pfet_01v8 ad=0.1218 pd=1.42 as=0.1218 ps=1.42 w=0.42 l=0.15
X331 a_43215_40974# a_43167_40886# VDD VDD sky130_fd_pr__pfet_01v8 ad=0.1218 pd=1.42 as=0.1218 ps=1.42 w=0.42 l=0.15
X332 VDD macro_core.array_and_peripherals.write_driver_0.WE a_49227_20916# VDD sky130_fd_pr__pfet_01v8 ad=0.2436 pd=2.26 as=0.2436 ps=2.26 w=0.84 l=0.15
X333 a_79167_45886# a_79215_45974# VSS VSS sky130_fd_pr__nfet_01v8 ad=0.3654 pd=3.1 as=0.3654 ps=3.1 w=1.26 l=0.15
X334 a_79167_50886# a_79215_50974# VDD VDD sky130_fd_pr__pfet_01v8 ad=0.1218 pd=1.42 as=0.1218 ps=1.42 w=0.42 l=0.15
X335 a_55615_26902# macro_core.array_and_peripherals.sense_amp_2.SA_OUT macro_core.array_and_peripherals.sense_amp_2.SA_OUTB VSS sky130_fd_pr__nfet_01v8 ad=0.2842 pd=2.54 as=0.2842 ps=2.54 w=0.98 l=0.15
X336 macro_core.array_and_peripherals.sense_amp_2.SA_OUT macro_core.array_and_peripherals.sense_amp_0.SCLK macro_core.array_and_peripherals.write_driver_2.BL VDD sky130_fd_pr__pfet_01v8 ad=0.58 pd=4.58 as=0.58 ps=4.58 w=2 l=0.15
X337 macro_core.array_and_peripherals.write_driver_0.BLB macro_core.array_and_peripherals.sense_amp_0.SCLK macro_core.array_and_peripherals.sense_amp_0.SA_OUTB VDD sky130_fd_pr__pfet_01v8 ad=0.58 pd=4.58 as=0.58 ps=4.58 w=2 l=0.15
X338 VDD macro_core.array_and_peripherals.row_decoder_0.N3 macro_core.array_and_peripherals.row_decoder_0.DEC3 VDD sky130_fd_pr__pfet_01v8 ad=0.87 pd=6.58 as=0.87 ps=6.58 w=3 l=0.15
X339 a_85215_40974# a_85167_40886# VSS VSS sky130_fd_pr__nfet_01v8 ad=0.3654 pd=3.1 as=0.3654 ps=3.1 w=1.26 l=0.15
X340 a_85215_55974# a_85167_55886# VSS VSS sky130_fd_pr__nfet_01v8 ad=0.3654 pd=3.1 as=0.3654 ps=3.1 w=1.26 l=0.15
X341 macro_core.array_and_peripherals.row_decoder_0.EVAL_GND macro_core.array_and_peripherals.row_decoder_0.A0B macro_core.array_and_peripherals.row_decoder_0.net1 VSS sky130_fd_pr__nfet_01v8 ad=0.58 pd=4.58 as=0.58 ps=4.58 w=2 l=0.15
X342 a_67167_40886# a_67215_40974# VSS VSS sky130_fd_pr__nfet_01v8 ad=0.3654 pd=3.1 as=0.3654 ps=3.1 w=1.26 l=0.15
X343 a_67167_55886# a_67215_55974# VSS VSS sky130_fd_pr__nfet_01v8 ad=0.3654 pd=3.1 as=0.3654 ps=3.1 w=1.26 l=0.15
X344 a_49215_50974# a_49167_50886# VDD VDD sky130_fd_pr__pfet_01v8 ad=0.1218 pd=1.42 as=0.1218 ps=1.42 w=0.42 l=0.15
X345 a_73215_50974# a_73167_50886# VSS VSS sky130_fd_pr__nfet_01v8 ad=0.3654 pd=3.1 as=0.3654 ps=3.1 w=1.26 l=0.15
X346 a_55167_50886# a_55215_50974# VSS VSS sky130_fd_pr__nfet_01v8 ad=0.3654 pd=3.1 as=0.3654 ps=3.1 w=1.26 l=0.15
X347 a_49167_45886# a_49215_45974# VDD VDD sky130_fd_pr__pfet_01v8 ad=0.1218 pd=1.42 as=0.1218 ps=1.42 w=0.42 l=0.15
X348 VSS macro_core.array_and_peripherals.row_decoder_0.A0B macro_core.array_and_peripherals.row_decoder_0.A0T VSS sky130_fd_pr__nfet_01v8 ad=0.58 pd=4.58 as=0.58 ps=4.58 w=2 l=0.15
X349 a_56415_16496# macro_core.array_and_peripherals.write_driver_2.DATA_B macro_core.array_and_peripherals.write_driver_2.BL VSS sky130_fd_pr__nfet_01v8 ad=1.4616 pd=10.66 as=1.4616 ps=10.66 w=5.04 l=0.15
X350 VSS macro_core.array_and_peripherals.write_driver_0.WE a_44415_16496# VSS sky130_fd_pr__nfet_01v8 ad=1.4616 pd=10.66 as=1.4616 ps=10.66 w=5.04 l=0.15
X351 VDD macro_core.array_and_peripherals.sense_amp_5.SA_OUTB macro_core.array_and_peripherals.sense_amp_5.SA_OUT VDD sky130_fd_pr__pfet_01v8 ad=0.5481 pd=4.36 as=0.5481 ps=4.36 w=1.89 l=0.15
X352 VDD macro_core.array_and_peripherals.sense_amp_3.SA_OUT macro_core.array_and_peripherals.sense_amp_3.SA_OUTB VDD sky130_fd_pr__pfet_01v8 ad=0.5481 pd=4.36 as=0.5481 ps=4.36 w=1.89 l=0.15
X353 a_43215_45974# a_43167_45886# VSS VSS sky130_fd_pr__nfet_01v8 ad=0.3654 pd=3.1 as=0.3654 ps=3.1 w=1.26 l=0.15
X354 a_79215_45974# macro_core.array_and_peripherals.wl_driver_1.WL macro_core.array_and_peripherals.write_driver_6.BL VSS sky130_fd_pr__nfet_01v8 ad=0.174 pd=1.78 as=0.174 ps=1.78 w=0.6 l=0.15
X355 a_61167_45886# macro_core.array_and_peripherals.wl_driver_1.WL macro_core.array_and_peripherals.write_driver_3.BLB VSS sky130_fd_pr__nfet_01v8 ad=0.174 pd=1.78 as=0.174 ps=1.78 w=0.6 l=0.15
X356 VSS macro_core.array_and_peripherals.sense_amp_0.SCLK a_55615_26902# VSS sky130_fd_pr__nfet_01v8 ad=0.2842 pd=2.54 as=0.2842 ps=2.54 w=0.98 l=0.15
X357 VDD macro_core.array_and_peripherals.row_decoder_0.A1 macro_core.array_and_peripherals.row_decoder_0.A1B VDD sky130_fd_pr__pfet_01v8 ad=0.2436 pd=2.26 as=0.2436 ps=2.26 w=0.84 l=0.15
X358 macro_core.array_and_peripherals.write_driver_2.BLB macro_core.array_and_peripherals.precharge_0.PRECH macro_core.array_and_peripherals.write_driver_2.BL VDD sky130_fd_pr__pfet_01v8 ad=0.7308 pd=5.62 as=0.7308 ps=5.62 w=2.52 l=0.15
X359 a_49167_40886# macro_core.array_and_peripherals.wl_driver_0.WL macro_core.array_and_peripherals.write_driver_1.BLB VSS sky130_fd_pr__nfet_01v8 ad=0.174 pd=1.78 as=0.174 ps=1.78 w=0.6 l=0.15
X360 a_49167_55886# macro_core.array_and_peripherals.wl_driver_3.WL macro_core.array_and_peripherals.write_driver_1.BLB VSS sky130_fd_pr__nfet_01v8 ad=0.174 pd=1.78 as=0.174 ps=1.78 w=0.6 l=0.15
X361 VDD a_49227_20916# a_51627_20496# VDD sky130_fd_pr__pfet_01v8 ad=1.4616 pd=10.66 as=1.4616 ps=10.66 w=5.04 l=0.15
X362 a_62027_20496# macro_core.array_and_peripherals.write_driver_3.DATA_B macro_core.array_and_peripherals.write_driver_3.BL VDD sky130_fd_pr__pfet_01v8 ad=1.4616 pd=10.66 as=1.4616 ps=10.66 w=5.04 l=0.15
X363 a_67615_26902# macro_core.array_and_peripherals.sense_amp_4.SA_OUTB macro_core.array_and_peripherals.sense_amp_4.SA_OUT VSS sky130_fd_pr__nfet_01v8 ad=0.2842 pd=2.54 as=0.2842 ps=2.54 w=0.98 l=0.15
X364 VSS macro_core.array_and_peripherals.write_driver_0.WE a_76015_16496# VSS sky130_fd_pr__nfet_01v8 ad=1.4616 pd=10.66 as=1.4616 ps=10.66 w=5.04 l=0.15
X365 a_88015_16496# macro_core.array_and_peripherals.write_driver_7.DATA macro_core.array_and_peripherals.write_driver_7.BLB VSS sky130_fd_pr__nfet_01v8 ad=1.4616 pd=10.66 as=1.4616 ps=10.66 w=5.04 l=0.15
X366 VSS macro_core.array_and_peripherals.write_driver_0.WE a_61227_20916# VSS sky130_fd_pr__nfet_01v8 ad=0.2436 pd=2.26 as=0.2436 ps=2.26 w=0.84 l=0.15
X367 VSS a_36227_46432# macro_core.array_and_peripherals.wl_driver_1.WL VSS sky130_fd_pr__nfet_01v8 ad=1.4616 pd=10.66 as=1.4616 ps=10.66 w=5.04 l=0.15
X368 VDD macro_core.array_and_peripherals.precharge_0.PRECH macro_core.array_and_peripherals.write_driver_5.BL VDD sky130_fd_pr__pfet_01v8 ad=0.7308 pd=5.62 as=0.7308 ps=5.62 w=2.52 l=0.15
X369 VDD macro_core.array_and_peripherals.precharge_0.PRECH macro_core.array_and_peripherals.write_driver_3.BLB VDD sky130_fd_pr__pfet_01v8 ad=0.7308 pd=5.62 as=0.7308 ps=5.62 w=2.52 l=0.15
X370 a_49215_40974# a_49167_40886# VSS VSS sky130_fd_pr__nfet_01v8 ad=0.3654 pd=3.1 as=0.3654 ps=3.1 w=1.26 l=0.15
X371 a_49215_55974# a_49167_55886# VSS VSS sky130_fd_pr__nfet_01v8 ad=0.3654 pd=3.1 as=0.3654 ps=3.1 w=1.26 l=0.15
X372 a_85215_40974# macro_core.array_and_peripherals.wl_driver_0.WL macro_core.array_and_peripherals.write_driver_7.BL VSS sky130_fd_pr__nfet_01v8 ad=0.174 pd=1.78 as=0.174 ps=1.78 w=0.6 l=0.15
X373 VDD a_36227_46432# macro_core.array_and_peripherals.wl_driver_1.WL VDD sky130_fd_pr__pfet_01v8 ad=1.4616 pd=10.66 as=1.4616 ps=10.66 w=5.04 l=0.15
X374 a_85215_55974# macro_core.array_and_peripherals.wl_driver_3.WL macro_core.array_and_peripherals.write_driver_7.BL VSS sky130_fd_pr__nfet_01v8 ad=0.174 pd=1.78 as=0.174 ps=1.78 w=0.6 l=0.15
X375 a_67167_40886# macro_core.array_and_peripherals.wl_driver_0.WL macro_core.array_and_peripherals.write_driver_4.BLB VSS sky130_fd_pr__nfet_01v8 ad=0.174 pd=1.78 as=0.174 ps=1.78 w=0.6 l=0.15
X376 a_67167_55886# macro_core.array_and_peripherals.wl_driver_3.WL macro_core.array_and_peripherals.write_driver_4.BLB VSS sky130_fd_pr__nfet_01v8 ad=0.174 pd=1.78 as=0.174 ps=1.78 w=0.6 l=0.15
X377 a_57627_20496# macro_core.array_and_peripherals.write_driver_2.DATA macro_core.array_and_peripherals.write_driver_2.BLB VDD sky130_fd_pr__pfet_01v8 ad=1.4616 pd=10.66 as=1.4616 ps=10.66 w=5.04 l=0.15
X378 VDD a_67227_20916# a_69627_20496# VDD sky130_fd_pr__pfet_01v8 ad=1.4616 pd=10.66 as=1.4616 ps=10.66 w=5.04 l=0.15
X379 a_85167_40886# a_85215_40974# VDD VDD sky130_fd_pr__pfet_01v8 ad=0.1218 pd=1.42 as=0.1218 ps=1.42 w=0.42 l=0.15
X380 a_85167_55886# a_85215_55974# VDD VDD sky130_fd_pr__pfet_01v8 ad=0.1218 pd=1.42 as=0.1218 ps=1.42 w=0.42 l=0.15
X381 VDD macro_core.array_and_peripherals.write_driver_0.WE a_43227_20916# VDD sky130_fd_pr__pfet_01v8 ad=0.2436 pd=2.26 as=0.2436 ps=2.26 w=0.84 l=0.15
X382 a_67215_45974# a_67167_45886# VDD VDD sky130_fd_pr__pfet_01v8 ad=0.1218 pd=1.42 as=0.1218 ps=1.42 w=0.42 l=0.15
X383 VSS macro_core.array_and_peripherals.write_driver_0.WE a_79227_20916# VSS sky130_fd_pr__nfet_01v8 ad=0.2436 pd=2.26 as=0.2436 ps=2.26 w=0.84 l=0.15
X384 macro_core.array_and_peripherals.row_decoder_0.net1 macro_core.array_and_peripherals.row_decoder_0.A1B macro_core.array_and_peripherals.row_decoder_0.N0 VSS sky130_fd_pr__nfet_01v8 ad=0.58 pd=4.58 as=0.58 ps=4.58 w=2 l=0.15
X385 a_73167_45886# a_73215_45974# VSS VSS sky130_fd_pr__nfet_01v8 ad=0.3654 pd=3.1 as=0.3654 ps=3.1 w=1.26 l=0.15
X386 a_73215_50974# macro_core.array_and_peripherals.wl_driver_2.WL macro_core.array_and_peripherals.write_driver_5.BL VSS sky130_fd_pr__nfet_01v8 ad=0.174 pd=1.78 as=0.174 ps=1.78 w=0.6 l=0.15
X387 a_55167_50886# macro_core.array_and_peripherals.wl_driver_2.WL macro_core.array_and_peripherals.write_driver_2.BLB VSS sky130_fd_pr__nfet_01v8 ad=0.174 pd=1.78 as=0.174 ps=1.78 w=0.6 l=0.15
X388 VDD a_85227_20916# a_86027_20496# VDD sky130_fd_pr__pfet_01v8 ad=1.4616 pd=10.66 as=1.4616 ps=10.66 w=5.04 l=0.15
X389 a_73167_50886# a_73215_50974# VDD VDD sky130_fd_pr__pfet_01v8 ad=0.1218 pd=1.42 as=0.1218 ps=1.42 w=0.42 l=0.15
X390 a_49615_26902# macro_core.array_and_peripherals.sense_amp_1.SA_OUT macro_core.array_and_peripherals.sense_amp_1.SA_OUTB VSS sky130_fd_pr__nfet_01v8 ad=0.2842 pd=2.54 as=0.2842 ps=2.54 w=0.98 l=0.15
X391 macro_core.array_and_peripherals.sense_amp_1.SA_OUT macro_core.array_and_peripherals.sense_amp_0.SCLK macro_core.array_and_peripherals.write_driver_1.BL VDD sky130_fd_pr__pfet_01v8 ad=0.58 pd=4.58 as=0.58 ps=4.58 w=2 l=0.15
X392 a_55215_55974# a_55167_55886# VDD VDD sky130_fd_pr__pfet_01v8 ad=0.1218 pd=1.42 as=0.1218 ps=1.42 w=0.42 l=0.15
X393 a_55215_40974# a_55167_40886# VDD VDD sky130_fd_pr__pfet_01v8 ad=0.1218 pd=1.42 as=0.1218 ps=1.42 w=0.42 l=0.15
X394 a_61167_40886# a_61215_40974# VSS VSS sky130_fd_pr__nfet_01v8 ad=0.3654 pd=3.1 as=0.3654 ps=3.1 w=1.26 l=0.15
X395 a_61167_55886# a_61215_55974# VSS VSS sky130_fd_pr__nfet_01v8 ad=0.3654 pd=3.1 as=0.3654 ps=3.1 w=1.26 l=0.15
X396 a_67615_26902# macro_core.array_and_peripherals.sense_amp_4.SA_OUT macro_core.array_and_peripherals.sense_amp_4.SA_OUTB VSS sky130_fd_pr__nfet_01v8 ad=0.2842 pd=2.54 as=0.2842 ps=2.54 w=0.98 l=0.15
X397 macro_core.array_and_peripherals.sense_amp_4.SA_OUT macro_core.array_and_peripherals.sense_amp_0.SCLK macro_core.array_and_peripherals.write_driver_4.BL VDD sky130_fd_pr__pfet_01v8 ad=0.58 pd=4.58 as=0.58 ps=4.58 w=2 l=0.15
X398 a_43215_50974# a_43167_50886# VDD VDD sky130_fd_pr__pfet_01v8 ad=0.1218 pd=1.42 as=0.1218 ps=1.42 w=0.42 l=0.15
X399 macro_core.array_and_peripherals.write_driver_2.BLB macro_core.array_and_peripherals.sense_amp_0.SCLK macro_core.array_and_peripherals.sense_amp_2.SA_OUTB VDD sky130_fd_pr__pfet_01v8 ad=0.58 pd=4.58 as=0.58 ps=4.58 w=2 l=0.15
X400 a_43215_45974# macro_core.array_and_peripherals.wl_driver_1.WL macro_core.array_and_peripherals.write_driver_0.BL VSS sky130_fd_pr__nfet_01v8 ad=0.174 pd=1.78 as=0.174 ps=1.78 w=0.6 l=0.15
.ends
