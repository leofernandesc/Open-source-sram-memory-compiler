.model sky130_fd_pr__nfet_01v8 nmos
.model sky130_fd_pr__pfet_01v8 pmos
.model sky130_fd_pr__pfet_01v8_hvt pmos
.subckt leaf_fabric VDD VSS A0 A1 PCLK PRECH SCLK WE DIN0 DIN1 DIN2 DIN3 DIN4 DIN5 DIN6 DIN7 DIN_B0 DIN_B1 DIN_B2 DIN_B3 DIN_B4 DIN_B5 DIN_B6 DIN_B7 DOUT0 DOUT1 DOUT2 DOUT3 DOUT4 DOUT5 DOUT6 DOUT7 ROW0 ROW1 ROW2 ROW3 DEC0 DEC1 DEC2 DEC3
M0 a_167_43886# wl_driver_2.WL write_driver_0.BLB VSS sky130_fd_pr__nfet_01v8 w=0.6u l=0.15u
M1 VSS WE a_45015_9496# VSS sky130_fd_pr__nfet_01v8 w=5.04u l=0.15u
M2 VDD WE a_6227_13916# VDD sky130_fd_pr__pfet_01v8 w=0.84u l=0.15u
M3 a_12215_38974# a_12167_38886# VSS VSS sky130_fd_pr__nfet_01v8 w=1.26u l=0.15u
M4 a_21015_9496# DIN3 write_driver_3.BLB VSS sky130_fd_pr__nfet_01v8 w=5.04u l=0.15u
M5 a_25415_9496# DIN_B4 write_driver_4.BL VSS sky130_fd_pr__nfet_01v8 w=5.04u l=0.15u
M6 a_30167_38886# wl_driver_1.WL write_driver_5.BLB VSS sky130_fd_pr__nfet_01v8 w=0.6u l=0.15u
M7 VSS SCLK a_24615_19902# VSS sky130_fd_pr__nfet_01v8 w=0.98u l=0.15u
M8 VDD DOUT1 sense_amp_1.SA_OUTB VDD sky130_fd_pr__pfet_01v8 w=1.89u l=0.15u
M9 write_driver_4.BLB PRECH write_driver_4.BL VDD sky130_fd_pr__pfet_01v8 w=2.52u l=0.15u
M10 VDD a_18227_13916# a_20627_13496# VDD sky130_fd_pr__pfet_01v8 w=5.04u l=0.15u
M11 a_31027_13496# DIN_B5 write_driver_5.BL VDD sky130_fd_pr__pfet_01v8 w=5.04u l=0.15u
M12 a_36615_19902# sense_amp_6.SA_OUTB DOUT6 VSS sky130_fd_pr__nfet_01v8 w=0.98u l=0.15u
M13 a_6215_38974# wl_driver_1.WL write_driver_1.BL VSS sky130_fd_pr__nfet_01v8 w=0.6u l=0.15u
M14 a_6215_43974# a_6167_43886# VDD VDD sky130_fd_pr__pfet_01v8 w=0.42u l=0.15u
M15 VDD PRECH write_driver_7.BL VDD sky130_fd_pr__pfet_01v8 w=2.52u l=0.15u
M16 VDD PRECH write_driver_5.BLB VDD sky130_fd_pr__pfet_01v8 w=2.52u l=0.15u
M17 a_18215_33974# a_18167_33886# VSS VSS sky130_fd_pr__nfet_01v8 w=1.26u l=0.15u
M18 a_6167_38886# a_6215_38974# VDD VDD sky130_fd_pr__pfet_01v8 w=0.42u l=0.15u
M19 a_18215_48974# a_18167_48886# VSS VSS sky130_fd_pr__nfet_01v8 w=1.26u l=0.15u
M20 a_36167_33886# wl_driver_0.WL write_driver_6.BLB VSS sky130_fd_pr__nfet_01v8 w=0.6u l=0.15u
M21 a_36167_48886# wl_driver_3.WL write_driver_6.BLB VSS sky130_fd_pr__nfet_01v8 w=0.6u l=0.15u
M22 a_26627_13496# DIN4 write_driver_4.BLB VDD sky130_fd_pr__pfet_01v8 w=5.04u l=0.15u
M23 VDD a_36227_13916# a_38627_13496# VDD sky130_fd_pr__pfet_01v8 w=5.04u l=0.15u
M24 VDD row_decoder_0.A0B row_decoder_0.A0T VDD sky130_fd_pr__pfet_01v8 w=2u l=0.15u
M25 VDD WE a_12227_13916# VDD sky130_fd_pr__pfet_01v8 w=0.84u l=0.15u
M26 VSS WE a_15015_9496# VSS sky130_fd_pr__nfet_01v8 w=5.04u l=0.15u
M27 a_36215_38974# a_36167_38886# VDD VDD sky130_fd_pr__pfet_01v8 w=0.42u l=0.15u
M28 VDD sense_amp_0.SA_OUTB DOUT0 VDD sky130_fd_pr__pfet_01v8 w=1.89u l=0.15u
M29 a_42167_38886# a_42215_38974# VSS VSS sky130_fd_pr__nfet_01v8 w=1.26u l=0.15u
M30 a_42215_43974# wl_driver_2.WL write_driver_7.BL VSS sky130_fd_pr__nfet_01v8 w=0.6u l=0.15u
M31 a_215_48974# a_167_48886# VDD VDD sky130_fd_pr__pfet_01v8 w=0.42u l=0.15u
M32 a_215_33974# a_167_33886# VDD VDD sky130_fd_pr__pfet_01v8 w=0.42u l=0.15u
M33 a_24167_43886# wl_driver_2.WL write_driver_4.BLB VSS sky130_fd_pr__nfet_01v8 w=0.6u l=0.15u
M34 a_42167_43886# a_42215_43974# VDD VDD sky130_fd_pr__pfet_01v8 w=0.42u l=0.15u
M35 VDD sense_amp_4.SA_OUTB DOUT4 VDD sky130_fd_pr__pfet_01v8 w=1.89u l=0.15u
M36 VDD DOUT2 sense_amp_2.SA_OUTB VDD sky130_fd_pr__pfet_01v8 w=1.89u l=0.15u
M37 a_24215_48974# a_24167_48886# VDD VDD sky130_fd_pr__pfet_01v8 w=0.42u l=0.15u
M38 a_24215_33974# a_24167_33886# VDD VDD sky130_fd_pr__pfet_01v8 w=0.42u l=0.15u
M39 VSS a_n6773_34432# wl_driver_0.WL VSS sky130_fd_pr__nfet_01v8 w=5.04u l=0.15u
M40 write_driver_7.BLB SCLK sense_amp_7.SA_OUTB VDD sky130_fd_pr__pfet_01v8 w=2u l=0.15u
M41 a_30167_33886# a_30215_33974# VSS VSS sky130_fd_pr__nfet_01v8 w=1.26u l=0.15u
M42 VSS a_n6773_49432# wl_driver_3.WL VSS sky130_fd_pr__nfet_01v8 w=5.04u l=0.15u
M43 a_30167_48886# a_30215_48974# VSS VSS sky130_fd_pr__nfet_01v8 w=1.26u l=0.15u
M44 a_36615_19902# DOUT6 sense_amp_6.SA_OUTB VSS sky130_fd_pr__nfet_01v8 w=0.98u l=0.15u
M45 a_12215_38974# wl_driver_1.WL write_driver_2.BL VSS sky130_fd_pr__nfet_01v8 w=0.6u l=0.15u
M46 a_12215_43974# a_12167_43886# VDD VDD sky130_fd_pr__pfet_01v8 w=0.42u l=0.15u
M47 a_12167_38886# a_12215_38974# VDD VDD sky130_fd_pr__pfet_01v8 w=0.42u l=0.15u
M48 a_6215_33974# a_6167_33886# VSS VSS sky130_fd_pr__nfet_01v8 w=1.26u l=0.15u
M49 a_6215_48974# a_6167_48886# VSS VSS sky130_fd_pr__nfet_01v8 w=1.26u l=0.15u
M50 VSS ROW0 a_n6773_34432# VSS sky130_fd_pr__nfet_01v8 w=1.68u l=0.15u
M51 a_36167_43886# a_36215_43974# VSS VSS sky130_fd_pr__nfet_01v8 w=1.26u l=0.15u
M52 VSS ROW3 a_n6773_49432# VSS sky130_fd_pr__nfet_01v8 w=1.68u l=0.15u
M53 row_decoder_0.net3 row_decoder_0.A1T row_decoder_0.N2 VSS sky130_fd_pr__nfet_01v8 w=2u l=0.15u
M54 VSS SCLK a_18615_19902# VSS sky130_fd_pr__nfet_01v8 w=0.98u l=0.15u
M55 a_43415_9496# DIN_B7 write_driver_7.BL VSS sky130_fd_pr__nfet_01v8 w=5.04u l=0.15u
M56 a_18215_33974# wl_driver_0.WL write_driver_3.BL VSS sky130_fd_pr__nfet_01v8 w=0.6u l=0.15u
M57 a_18215_48974# wl_driver_3.WL write_driver_3.BL VSS sky130_fd_pr__nfet_01v8 w=0.6u l=0.15u
M58 a_18167_48886# a_18215_48974# VDD VDD sky130_fd_pr__pfet_01v8 w=0.42u l=0.15u
M59 VDD DOUT0 sense_amp_0.SA_OUTB VDD sky130_fd_pr__pfet_01v8 w=1.89u l=0.15u
M60 a_18167_33886# a_18215_33974# VDD VDD sky130_fd_pr__pfet_01v8 w=0.42u l=0.15u
M61 a_215_38974# a_167_38886# VSS VSS sky130_fd_pr__nfet_01v8 w=1.26u l=0.15u
M62 a_24215_38974# a_24167_38886# VSS VSS sky130_fd_pr__nfet_01v8 w=1.26u l=0.15u
M63 a_30615_19902# sense_amp_5.SA_OUTB DOUT5 VSS sky130_fd_pr__nfet_01v8 w=0.98u l=0.15u
M64 a_42167_38886# wl_driver_1.WL write_driver_7.BLB VSS sky130_fd_pr__nfet_01v8 w=0.6u l=0.15u
M65 VSS SCLK a_36615_19902# VSS sky130_fd_pr__nfet_01v8 w=0.98u l=0.15u
M66 VDD a_18227_13916# a_19027_13496# VDD sky130_fd_pr__pfet_01v8 w=5.04u l=0.15u
M67 a_215_38974# wl_driver_1.WL write_driver_0.BL VSS sky130_fd_pr__nfet_01v8 w=0.6u l=0.15u
M68 a_12215_33974# a_12167_33886# VSS VSS sky130_fd_pr__nfet_01v8 w=1.26u l=0.15u
M69 a_12215_48974# a_12167_48886# VSS VSS sky130_fd_pr__nfet_01v8 w=1.26u l=0.15u
M70 VSS WE a_18227_13916# VSS sky130_fd_pr__nfet_01v8 w=0.84u l=0.15u
M71 DOUT3 SCLK write_driver_3.BL VDD sky130_fd_pr__pfet_01v8 w=2u l=0.15u
M72 write_driver_6.BLB PRECH write_driver_6.BL VDD sky130_fd_pr__pfet_01v8 w=2.52u l=0.15u
M73 row_decoder_0.EVAL_GND row_decoder_0.A0T row_decoder_0.net4 VSS sky130_fd_pr__nfet_01v8 w=2u l=0.15u
M74 a_30167_33886# wl_driver_0.WL write_driver_5.BLB VSS sky130_fd_pr__nfet_01v8 w=0.6u l=0.15u
M75 a_30167_48886# wl_driver_3.WL write_driver_5.BLB VSS sky130_fd_pr__nfet_01v8 w=0.6u l=0.15u
M76 a_43027_13496# DIN_B7 write_driver_7.BL VDD sky130_fd_pr__pfet_01v8 w=5.04u l=0.15u
M77 a_20627_13496# DIN3 write_driver_3.BLB VDD sky130_fd_pr__pfet_01v8 w=5.04u l=0.15u
M78 VDD a_30227_13916# a_32627_13496# VDD sky130_fd_pr__pfet_01v8 w=5.04u l=0.15u
M79 VSS WE a_33015_9496# VSS sky130_fd_pr__nfet_01v8 w=5.04u l=0.15u
M80 a_30215_38974# a_30167_38886# VDD VDD sky130_fd_pr__pfet_01v8 w=0.42u l=0.15u
M81 VSS WE a_37415_9496# VSS sky130_fd_pr__nfet_01v8 w=5.04u l=0.15u
M82 VDD PRECH write_driver_7.BLB VDD sky130_fd_pr__pfet_01v8 w=2.52u l=0.15u
M83 VDD WE a_227_13916# VDD sky130_fd_pr__pfet_01v8 w=0.84u l=0.15u
M84 a_13415_9496# DIN_B2 write_driver_2.BL VSS sky130_fd_pr__nfet_01v8 w=5.04u l=0.15u
M85 a_38627_13496# DIN6 write_driver_6.BLB VDD sky130_fd_pr__pfet_01v8 w=5.04u l=0.15u
M86 VDD WE a_24227_13916# VDD sky130_fd_pr__pfet_01v8 w=0.84u l=0.15u
M87 a_6215_33974# wl_driver_0.WL write_driver_1.BL VSS sky130_fd_pr__nfet_01v8 w=0.6u l=0.15u
M88 a_6215_48974# wl_driver_3.WL write_driver_1.BL VSS sky130_fd_pr__nfet_01v8 w=0.6u l=0.15u
M89 a_6167_48886# a_6215_48974# VDD VDD sky130_fd_pr__pfet_01v8 w=0.42u l=0.15u
M90 a_6167_33886# a_6215_33974# VDD VDD sky130_fd_pr__pfet_01v8 w=0.42u l=0.15u
M91 a_18215_43974# a_18167_43886# VSS VSS sky130_fd_pr__nfet_01v8 w=1.26u l=0.15u
M92 a_36167_43886# wl_driver_2.WL write_driver_6.BLB VSS sky130_fd_pr__nfet_01v8 w=0.6u l=0.15u
M93 a_30615_19902# DOUT5 sense_amp_5.SA_OUTB VSS sky130_fd_pr__nfet_01v8 w=0.98u l=0.15u
M94 VDD sense_amp_6.SA_OUTB DOUT6 VDD sky130_fd_pr__pfet_01v8 w=1.89u l=0.15u
M95 VDD DOUT4 sense_amp_4.SA_OUTB VDD sky130_fd_pr__pfet_01v8 w=1.89u l=0.15u
M96 a_36215_48974# a_36167_48886# VDD VDD sky130_fd_pr__pfet_01v8 w=0.42u l=0.15u
M97 a_36215_33974# a_36167_33886# VDD VDD sky130_fd_pr__pfet_01v8 w=0.42u l=0.15u
M98 VDD a_6227_13916# a_7027_13496# VDD sky130_fd_pr__pfet_01v8 w=5.04u l=0.15u
M99 a_42167_33886# a_42215_33974# VSS VSS sky130_fd_pr__nfet_01v8 w=1.26u l=0.15u
M100 a_42167_48886# a_42215_48974# VSS VSS sky130_fd_pr__nfet_01v8 w=1.26u l=0.15u
M101 a_215_43974# a_167_43886# VDD VDD sky130_fd_pr__pfet_01v8 w=0.42u l=0.15u
M102 a_39015_9496# DIN6 write_driver_6.BLB VSS sky130_fd_pr__nfet_01v8 w=5.04u l=0.15u
M103 row_decoder_0.EVAL_GND row_decoder_0.A0B row_decoder_0.net3 VSS sky130_fd_pr__nfet_01v8 w=2u l=0.15u
M104 DOUT1 SCLK write_driver_1.BL VDD sky130_fd_pr__pfet_01v8 w=2u l=0.15u
M105 a_167_38886# a_215_38974# VDD VDD sky130_fd_pr__pfet_01v8 w=0.42u l=0.15u
M106 a_24215_43974# a_24167_43886# VDD VDD sky130_fd_pr__pfet_01v8 w=0.42u l=0.15u
M107 a_24215_38974# wl_driver_1.WL write_driver_4.BL VSS sky130_fd_pr__nfet_01v8 w=0.6u l=0.15u
M108 VSS a_n6773_44432# wl_driver_2.WL VSS sky130_fd_pr__nfet_01v8 w=5.04u l=0.15u
M109 a_30167_43886# a_30215_43974# VSS VSS sky130_fd_pr__nfet_01v8 w=1.26u l=0.15u
M110 a_24167_38886# a_24215_38974# VDD VDD sky130_fd_pr__pfet_01v8 w=0.42u l=0.15u
M111 a_12215_33974# wl_driver_0.WL write_driver_2.BL VSS sky130_fd_pr__nfet_01v8 w=0.6u l=0.15u
M112 a_12215_48974# wl_driver_3.WL write_driver_2.BL VSS sky130_fd_pr__nfet_01v8 w=0.6u l=0.15u
M113 VDD row_decoder_0.A1B row_decoder_0.A1T VDD sky130_fd_pr__pfet_01v8 w=2u l=0.15u
M114 a_12167_48886# a_12215_48974# VDD VDD sky130_fd_pr__pfet_01v8 w=0.42u l=0.15u
M115 a_12167_33886# a_12215_33974# VDD VDD sky130_fd_pr__pfet_01v8 w=0.42u l=0.15u
M116 a_6215_43974# a_6167_43886# VSS VSS sky130_fd_pr__nfet_01v8 w=1.26u l=0.15u
M117 VDD PRECH write_driver_3.BL VDD sky130_fd_pr__pfet_01v8 w=2.52u l=0.15u
M118 VSS SCLK a_30615_19902# VSS sky130_fd_pr__nfet_01v8 w=0.98u l=0.15u
M119 VDD a_12227_13916# a_13027_13496# VDD sky130_fd_pr__pfet_01v8 w=5.04u l=0.15u
M120 VSS ROW2 a_n6773_44432# VSS sky130_fd_pr__nfet_01v8 w=1.68u l=0.15u
M121 DOUT2 SCLK write_driver_2.BL VDD sky130_fd_pr__pfet_01v8 w=2u l=0.15u
M122 write_driver_5.BLB PRECH write_driver_5.BL VDD sky130_fd_pr__pfet_01v8 w=2.52u l=0.15u
M123 VSS WE a_36227_13916# VSS sky130_fd_pr__nfet_01v8 w=0.84u l=0.15u
M124 a_36215_38974# a_36167_38886# VSS VSS sky130_fd_pr__nfet_01v8 w=1.26u l=0.15u
M125 VSS row_decoder_0.A0B row_decoder_0.A0T VSS sky130_fd_pr__nfet_01v8 w=2u l=0.15u
M126 a_18167_38886# a_18215_38974# VSS VSS sky130_fd_pr__nfet_01v8 w=1.26u l=0.15u
M127 a_18215_43974# wl_driver_2.WL write_driver_3.BL VSS sky130_fd_pr__nfet_01v8 w=0.6u l=0.15u
M128 a_42615_19902# sense_amp_7.SA_OUTB DOUT7 VSS sky130_fd_pr__nfet_01v8 w=0.98u l=0.15u
M129 a_215_33974# a_167_33886# VSS VSS sky130_fd_pr__nfet_01v8 w=1.26u l=0.15u
M130 a_18167_43886# a_18215_43974# VDD VDD sky130_fd_pr__pfet_01v8 w=0.42u l=0.15u
M131 a_215_48974# a_167_48886# VSS VSS sky130_fd_pr__nfet_01v8 w=1.26u l=0.15u
M132 VSS WE a_3015_9496# VSS sky130_fd_pr__nfet_01v8 w=5.04u l=0.15u
M133 a_24215_33974# a_24167_33886# VSS VSS sky130_fd_pr__nfet_01v8 w=1.26u l=0.15u
M134 a_24215_48974# a_24167_48886# VSS VSS sky130_fd_pr__nfet_01v8 w=1.26u l=0.15u
M135 VDD DEC3 row_decoder_0.N3 VDD sky130_fd_pr__pfet_01v8 w=0.84u l=0.15u
M136 VSS WE a_7415_9496# VSS sky130_fd_pr__nfet_01v8 w=5.04u l=0.15u
M137 a_42167_33886# wl_driver_0.WL write_driver_7.BLB VSS sky130_fd_pr__nfet_01v8 w=0.6u l=0.15u
M138 a_42167_48886# wl_driver_3.WL write_driver_7.BLB VSS sky130_fd_pr__nfet_01v8 w=0.6u l=0.15u
M139 a_32627_13496# DIN5 write_driver_5.BLB VDD sky130_fd_pr__pfet_01v8 w=5.04u l=0.15u
M140 VDD a_42227_13916# a_44627_13496# VDD sky130_fd_pr__pfet_01v8 w=5.04u l=0.15u
M141 a_31415_9496# DIN_B5 write_driver_5.BL VSS sky130_fd_pr__nfet_01v8 w=5.04u l=0.15u
M142 a_215_33974# wl_driver_0.WL write_driver_0.BL VSS sky130_fd_pr__nfet_01v8 w=0.6u l=0.15u
M143 a_215_48974# wl_driver_3.WL write_driver_0.BL VSS sky130_fd_pr__nfet_01v8 w=0.6u l=0.15u
M144 a_42215_38974# a_42167_38886# VDD VDD sky130_fd_pr__pfet_01v8 w=0.42u l=0.15u
M145 a_12215_43974# a_12167_43886# VSS VSS sky130_fd_pr__nfet_01v8 w=1.26u l=0.15u
M146 VDD A0 row_decoder_0.A0B VDD sky130_fd_pr__pfet_01v8 w=0.84u l=0.15u
M147 a_30167_43886# wl_driver_2.WL write_driver_5.BLB VSS sky130_fd_pr__nfet_01v8 w=0.6u l=0.15u
M148 VSS row_decoder_0.N2 DEC2 VSS sky130_fd_pr__nfet_01v8 w=2u l=0.15u
M149 VDD sense_amp_5.SA_OUTB DOUT5 VDD sky130_fd_pr__pfet_01v8 w=1.89u l=0.15u
M150 VDD a_n6773_39432# wl_driver_1.WL VDD sky130_fd_pr__pfet_01v8 w=5.04u l=0.15u
M151 VDD PRECH write_driver_1.BL VDD sky130_fd_pr__pfet_01v8 w=2.52u l=0.15u
M152 a_30215_48974# a_30167_48886# VDD VDD sky130_fd_pr__pfet_01v8 w=0.42u l=0.15u
M153 a_30215_33974# a_30167_33886# VDD VDD sky130_fd_pr__pfet_01v8 w=0.42u l=0.15u
M154 VDD WE a_36227_13916# VDD sky130_fd_pr__pfet_01v8 w=0.84u l=0.15u
M155 VSS WE a_227_13916# VSS sky130_fd_pr__nfet_01v8 w=0.84u l=0.15u
M156 VDD a_227_13916# a_1027_13496# VDD sky130_fd_pr__pfet_01v8 w=5.04u l=0.15u
M157 DOUT0 SCLK write_driver_0.BL VDD sky130_fd_pr__pfet_01v8 w=2u l=0.15u
M158 a_42615_19902# DOUT7 sense_amp_7.SA_OUTB VSS sky130_fd_pr__nfet_01v8 w=0.98u l=0.15u
M159 VDD DOUT6 sense_amp_6.SA_OUTB VDD sky130_fd_pr__pfet_01v8 w=1.89u l=0.15u
M160 a_6167_38886# a_6215_38974# VSS VSS sky130_fd_pr__nfet_01v8 w=1.26u l=0.15u
M161 a_6215_43974# wl_driver_2.WL write_driver_1.BL VSS sky130_fd_pr__nfet_01v8 w=0.6u l=0.15u
M162 a_9015_9496# DIN1 write_driver_1.BLB VSS sky130_fd_pr__nfet_01v8 w=5.04u l=0.15u
M163 VSS WE a_21015_9496# VSS sky130_fd_pr__nfet_01v8 w=5.04u l=0.15u
M164 VSS WE a_25415_9496# VSS sky130_fd_pr__nfet_01v8 w=5.04u l=0.15u
M165 a_6167_43886# a_6215_43974# VDD VDD sky130_fd_pr__pfet_01v8 w=0.42u l=0.15u
M166 VSS row_decoder_0.N3 DEC3 VSS sky130_fd_pr__nfet_01v8 w=2u l=0.15u
M167 VDD row_decoder_0.N2 DEC2 VDD sky130_fd_pr__pfet_01v8 w=3u l=0.15u
M168 VDD DEC2 row_decoder_0.N2 VDD sky130_fd_pr__pfet_01v8 w=0.84u l=0.15u
M169 write_driver_1.BLB SCLK sense_amp_1.SA_OUTB VDD sky130_fd_pr__pfet_01v8 w=2u l=0.15u
M170 VDD ROW1 a_n6773_39432# VDD sky130_fd_pr__pfet_01v8 w=1.68u l=0.15u
M171 a_36215_43974# a_36167_43886# VDD VDD sky130_fd_pr__pfet_01v8 w=0.42u l=0.15u
M172 a_36215_38974# wl_driver_1.WL write_driver_6.BL VSS sky130_fd_pr__nfet_01v8 w=0.6u l=0.15u
M173 a_18167_38886# wl_driver_1.WL write_driver_3.BLB VSS sky130_fd_pr__nfet_01v8 w=0.6u l=0.15u
M174 a_42167_43886# a_42215_43974# VSS VSS sky130_fd_pr__nfet_01v8 w=1.26u l=0.15u
M175 VDD PCLK row_decoder_0.N2 VDD sky130_fd_pr__pfet_01v8 w=1.25u l=0.15u
M176 a_36167_38886# a_36215_38974# VDD VDD sky130_fd_pr__pfet_01v8 w=0.42u l=0.15u
M177 a_167_48886# a_215_48974# VDD VDD sky130_fd_pr__pfet_01v8 w=0.42u l=0.15u
M178 VDD PRECH write_driver_2.BL VDD sky130_fd_pr__pfet_01v8 w=2.52u l=0.15u
M179 a_167_33886# a_215_33974# VDD VDD sky130_fd_pr__pfet_01v8 w=0.42u l=0.15u
M180 a_24215_33974# wl_driver_0.WL write_driver_4.BL VSS sky130_fd_pr__nfet_01v8 w=0.6u l=0.15u
M181 a_24215_48974# wl_driver_3.WL write_driver_4.BL VSS sky130_fd_pr__nfet_01v8 w=0.6u l=0.15u
M182 a_24167_48886# a_24215_48974# VDD VDD sky130_fd_pr__pfet_01v8 w=0.42u l=0.15u
M183 a_19027_13496# DIN_B3 write_driver_3.BL VDD sky130_fd_pr__pfet_01v8 w=5.04u l=0.15u
M184 a_24167_33886# a_24215_33974# VDD VDD sky130_fd_pr__pfet_01v8 w=0.42u l=0.15u
M185 VDD row_decoder_0.N3 DEC3 VDD sky130_fd_pr__pfet_01v8 w=3u l=0.15u
M186 a_30215_38974# a_30167_38886# VSS VSS sky130_fd_pr__nfet_01v8 w=1.26u l=0.15u
M187 a_12167_38886# a_12215_38974# VSS VSS sky130_fd_pr__nfet_01v8 w=1.26u l=0.15u
M188 a_27015_9496# DIN4 write_driver_4.BLB VSS sky130_fd_pr__nfet_01v8 w=5.04u l=0.15u
M189 a_12215_43974# wl_driver_2.WL write_driver_2.BL VSS sky130_fd_pr__nfet_01v8 w=0.6u l=0.15u
M190 VDD PRECH write_driver_3.BLB VDD sky130_fd_pr__pfet_01v8 w=2.52u l=0.15u
M191 VSS SCLK a_42615_19902# VSS sky130_fd_pr__nfet_01v8 w=0.98u l=0.15u
M192 VDD a_24227_13916# a_25027_13496# VDD sky130_fd_pr__pfet_01v8 w=5.04u l=0.15u
M193 VSS WE a_6227_13916# VSS sky130_fd_pr__nfet_01v8 w=0.84u l=0.15u
M194 a_12167_43886# a_12215_43974# VDD VDD sky130_fd_pr__pfet_01v8 w=0.42u l=0.15u
M195 DOUT4 SCLK write_driver_4.BL VDD sky130_fd_pr__pfet_01v8 w=2u l=0.15u
M196 write_driver_2.BLB SCLK sense_amp_2.SA_OUTB VDD sky130_fd_pr__pfet_01v8 w=2u l=0.15u
M197 write_driver_7.BLB PRECH write_driver_7.BL VDD sky130_fd_pr__pfet_01v8 w=2.52u l=0.15u
M198 row_decoder_0.net4 row_decoder_0.A1T row_decoder_0.N3 VSS sky130_fd_pr__nfet_01v8 w=2u l=0.15u
M199 a_1415_9496# DIN_B0 write_driver_0.BL VSS sky130_fd_pr__nfet_01v8 w=5.04u l=0.15u
M200 VSS PCLK row_decoder_0.EVAL_GND VSS sky130_fd_pr__nfet_01v8 w=1.5u l=0.15u
M201 a_6167_38886# wl_driver_1.WL write_driver_1.BLB VSS sky130_fd_pr__nfet_01v8 w=0.6u l=0.15u
M202 a_36215_33974# a_36167_33886# VSS VSS sky130_fd_pr__nfet_01v8 w=1.26u l=0.15u
M203 a_36215_48974# a_36167_48886# VSS VSS sky130_fd_pr__nfet_01v8 w=1.26u l=0.15u
M204 a_18167_33886# a_18215_33974# VSS VSS sky130_fd_pr__nfet_01v8 w=1.26u l=0.15u
M205 a_18167_48886# a_18215_48974# VSS VSS sky130_fd_pr__nfet_01v8 w=1.26u l=0.15u
M206 a_44627_13496# DIN7 write_driver_7.BLB VDD sky130_fd_pr__pfet_01v8 w=5.04u l=0.15u
M207 a_215_43974# a_167_43886# VSS VSS sky130_fd_pr__nfet_01v8 w=1.26u l=0.15u
M208 VDD WE a_30227_13916# VDD sky130_fd_pr__pfet_01v8 w=0.84u l=0.15u
M209 a_7027_13496# DIN_B1 write_driver_1.BL VDD sky130_fd_pr__pfet_01v8 w=5.04u l=0.15u
M210 a_24215_43974# a_24167_43886# VSS VSS sky130_fd_pr__nfet_01v8 w=1.26u l=0.15u
M211 a_42167_43886# wl_driver_2.WL write_driver_7.BLB VSS sky130_fd_pr__nfet_01v8 w=0.6u l=0.15u
M212 VSS WE a_24227_13916# VSS sky130_fd_pr__nfet_01v8 w=0.84u l=0.15u
M213 VDD sense_amp_7.SA_OUTB DOUT7 VDD sky130_fd_pr__pfet_01v8 w=1.89u l=0.15u
M214 VDD DOUT5 sense_amp_5.SA_OUTB VDD sky130_fd_pr__pfet_01v8 w=1.89u l=0.15u
M215 a_215_43974# wl_driver_2.WL write_driver_0.BL VSS sky130_fd_pr__nfet_01v8 w=0.6u l=0.15u
M216 a_42215_48974# a_42167_48886# VDD VDD sky130_fd_pr__pfet_01v8 w=0.42u l=0.15u
M217 VDD PRECH write_driver_1.BLB VDD sky130_fd_pr__pfet_01v8 w=2.52u l=0.15u
M218 a_42215_33974# a_42167_33886# VDD VDD sky130_fd_pr__pfet_01v8 w=0.42u l=0.15u
M219 VSS WE a_43415_9496# VSS sky130_fd_pr__nfet_01v8 w=5.04u l=0.15u
M220 VDD a_n6773_49432# wl_driver_3.WL VDD sky130_fd_pr__pfet_01v8 w=5.04u l=0.15u
M221 VSS row_decoder_0.A1B row_decoder_0.A1T VSS sky130_fd_pr__nfet_01v8 w=2u l=0.15u
M222 VDD a_n6773_34432# wl_driver_0.WL VDD sky130_fd_pr__pfet_01v8 w=5.04u l=0.15u
M223 write_driver_0.BLB SCLK sense_amp_0.SA_OUTB VDD sky130_fd_pr__pfet_01v8 w=2u l=0.15u
M224 a_30215_43974# a_30167_43886# VDD VDD sky130_fd_pr__pfet_01v8 w=0.42u l=0.15u
M225 a_30215_38974# wl_driver_1.WL write_driver_5.BL VSS sky130_fd_pr__nfet_01v8 w=0.6u l=0.15u
M226 a_12167_38886# wl_driver_1.WL write_driver_2.BLB VSS sky130_fd_pr__nfet_01v8 w=0.6u l=0.15u
M227 a_30167_38886# a_30215_38974# VDD VDD sky130_fd_pr__pfet_01v8 w=0.42u l=0.15u
M228 VSS row_decoder_0.N0 DEC0 VSS sky130_fd_pr__nfet_01v8 w=2u l=0.15u
M229 a_6167_33886# a_6215_33974# VSS VSS sky130_fd_pr__nfet_01v8 w=1.26u l=0.15u
M230 a_6167_48886# a_6215_48974# VSS VSS sky130_fd_pr__nfet_01v8 w=1.26u l=0.15u
M231 a_18615_19902# sense_amp_3.SA_OUTB DOUT3 VSS sky130_fd_pr__nfet_01v8 w=0.98u l=0.15u
M232 a_13027_13496# DIN_B2 write_driver_2.BL VDD sky130_fd_pr__pfet_01v8 w=5.04u l=0.15u
M233 VDD PRECH write_driver_0.BL VDD sky130_fd_pr__pfet_01v8 w=2.52u l=0.15u
M234 VDD A1 row_decoder_0.A1B VDD sky130_fd_pr__pfet_01v8 w=0.84u l=0.15u
M235 VDD ROW3 a_n6773_49432# VDD sky130_fd_pr__pfet_01v8 w=1.68u l=0.15u
M236 VDD PRECH write_driver_4.BL VDD sky130_fd_pr__pfet_01v8 w=2.52u l=0.15u
M237 VDD ROW0 a_n6773_34432# VDD sky130_fd_pr__pfet_01v8 w=1.68u l=0.15u
M238 VDD PRECH write_driver_2.BLB VDD sky130_fd_pr__pfet_01v8 w=2.52u l=0.15u
M239 a_45015_9496# DIN7 write_driver_7.BLB VSS sky130_fd_pr__nfet_01v8 w=5.04u l=0.15u
M240 a_36215_33974# wl_driver_0.WL write_driver_6.BL VSS sky130_fd_pr__nfet_01v8 w=0.6u l=0.15u
M241 a_36215_48974# wl_driver_3.WL write_driver_6.BL VSS sky130_fd_pr__nfet_01v8 w=0.6u l=0.15u
M242 a_18167_33886# wl_driver_0.WL write_driver_3.BLB VSS sky130_fd_pr__nfet_01v8 w=0.6u l=0.15u
M243 a_18167_48886# wl_driver_3.WL write_driver_3.BLB VSS sky130_fd_pr__nfet_01v8 w=0.6u l=0.15u
M244 a_36167_48886# a_36215_48974# VDD VDD sky130_fd_pr__pfet_01v8 w=0.42u l=0.15u
M245 a_36167_33886# a_36215_33974# VDD VDD sky130_fd_pr__pfet_01v8 w=0.42u l=0.15u
M246 VSS WE a_13415_9496# VSS sky130_fd_pr__nfet_01v8 w=5.04u l=0.15u
M247 a_167_38886# a_215_38974# VSS VSS sky130_fd_pr__nfet_01v8 w=1.26u l=0.15u
M248 a_18215_38974# a_18167_38886# VDD VDD sky130_fd_pr__pfet_01v8 w=0.42u l=0.15u
M249 a_42215_38974# a_42167_38886# VSS VSS sky130_fd_pr__nfet_01v8 w=1.26u l=0.15u
M250 a_167_43886# a_215_43974# VDD VDD sky130_fd_pr__pfet_01v8 w=0.42u l=0.15u
M251 a_24167_38886# a_24215_38974# VSS VSS sky130_fd_pr__nfet_01v8 w=1.26u l=0.15u
M252 VDD row_decoder_0.N0 DEC0 VDD sky130_fd_pr__pfet_01v8 w=3u l=0.15u
M253 a_24215_43974# wl_driver_2.WL write_driver_4.BL VSS sky130_fd_pr__nfet_01v8 w=0.6u l=0.15u
M254 a_24167_43886# a_24215_43974# VDD VDD sky130_fd_pr__pfet_01v8 w=0.42u l=0.15u
M255 VDD a_36227_13916# a_37027_13496# VDD sky130_fd_pr__pfet_01v8 w=5.04u l=0.15u
M256 a_167_38886# wl_driver_1.WL write_driver_0.BLB VSS sky130_fd_pr__nfet_01v8 w=0.6u l=0.15u
M257 VSS A0 row_decoder_0.A0B VSS sky130_fd_pr__nfet_01v8 w=0.84u l=0.15u
M258 a_30215_33974# a_30167_33886# VSS VSS sky130_fd_pr__nfet_01v8 w=1.26u l=0.15u
M259 a_30215_48974# a_30167_48886# VSS VSS sky130_fd_pr__nfet_01v8 w=1.26u l=0.15u
M260 a_12167_33886# a_12215_33974# VSS VSS sky130_fd_pr__nfet_01v8 w=1.26u l=0.15u
M261 a_12167_48886# a_12215_48974# VSS VSS sky130_fd_pr__nfet_01v8 w=1.26u l=0.15u
M262 DOUT6 SCLK write_driver_6.BL VDD sky130_fd_pr__pfet_01v8 w=2u l=0.15u
M263 write_driver_4.BLB SCLK sense_amp_4.SA_OUTB VDD sky130_fd_pr__pfet_01v8 w=2u l=0.15u
M264 a_18615_19902# DOUT3 sense_amp_3.SA_OUTB VSS sky130_fd_pr__nfet_01v8 w=0.98u l=0.15u
M265 VSS WE a_39015_9496# VSS sky130_fd_pr__nfet_01v8 w=5.04u l=0.15u
M266 a_1027_13496# DIN_B0 write_driver_0.BL VDD sky130_fd_pr__pfet_01v8 w=5.04u l=0.15u
M267 a_6615_19902# sense_amp_1.SA_OUTB DOUT1 VSS sky130_fd_pr__nfet_01v8 w=0.98u l=0.15u
M268 VSS WE a_42227_13916# VSS sky130_fd_pr__nfet_01v8 w=0.84u l=0.15u
M269 row_decoder_0.net1 row_decoder_0.A1B row_decoder_0.N0 VSS sky130_fd_pr__nfet_01v8 w=2u l=0.15u
M270 a_15015_9496# DIN2 write_driver_2.BLB VSS sky130_fd_pr__nfet_01v8 w=5.04u l=0.15u
M271 a_19415_9496# DIN_B3 write_driver_3.BL VSS sky130_fd_pr__nfet_01v8 w=5.04u l=0.15u
M272 VDD PRECH write_driver_0.BLB VDD sky130_fd_pr__pfet_01v8 w=2.52u l=0.15u
M273 VDD WE a_42227_13916# VDD sky130_fd_pr__pfet_01v8 w=0.84u l=0.15u
M274 a_6167_33886# wl_driver_0.WL write_driver_1.BLB VSS sky130_fd_pr__nfet_01v8 w=0.6u l=0.15u
M275 a_6167_48886# wl_driver_3.WL write_driver_1.BLB VSS sky130_fd_pr__nfet_01v8 w=0.6u l=0.15u
M276 a_36215_43974# a_36167_43886# VSS VSS sky130_fd_pr__nfet_01v8 w=1.26u l=0.15u
M277 VDD a_6227_13916# a_8627_13496# VDD sky130_fd_pr__pfet_01v8 w=5.04u l=0.15u
M278 a_18167_43886# a_18215_43974# VSS VSS sky130_fd_pr__nfet_01v8 w=1.26u l=0.15u
M279 a_6215_38974# a_6167_38886# VDD VDD sky130_fd_pr__pfet_01v8 w=0.42u l=0.15u
M280 row_decoder_0.net2 row_decoder_0.A1B row_decoder_0.N1 VSS sky130_fd_pr__nfet_01v8 w=2u l=0.15u
M281 VDD DOUT7 sense_amp_7.SA_OUTB VDD sky130_fd_pr__pfet_01v8 w=1.89u l=0.15u
M282 a_42215_38974# wl_driver_1.WL write_driver_7.BL VSS sky130_fd_pr__nfet_01v8 w=0.6u l=0.15u
M283 a_42215_43974# a_42167_43886# VDD VDD sky130_fd_pr__pfet_01v8 w=0.42u l=0.15u
M284 a_12615_19902# sense_amp_2.SA_OUTB DOUT2 VSS sky130_fd_pr__nfet_01v8 w=0.98u l=0.15u
M285 a_24167_38886# wl_driver_1.WL write_driver_4.BLB VSS sky130_fd_pr__nfet_01v8 w=0.6u l=0.15u
M286 a_42167_38886# a_42215_38974# VDD VDD sky130_fd_pr__pfet_01v8 w=0.42u l=0.15u
M287 a_6615_19902# DOUT1 sense_amp_1.SA_OUTB VSS sky130_fd_pr__nfet_01v8 w=0.98u l=0.15u
M288 VDD a_n6773_44432# wl_driver_2.WL VDD sky130_fd_pr__pfet_01v8 w=5.04u l=0.15u
M289 VSS WE a_12227_13916# VSS sky130_fd_pr__nfet_01v8 w=0.84u l=0.15u
M290 write_driver_3.BLB PRECH write_driver_3.BL VDD sky130_fd_pr__pfet_01v8 w=2.52u l=0.15u
M291 a_30215_33974# wl_driver_0.WL write_driver_5.BL VSS sky130_fd_pr__nfet_01v8 w=0.6u l=0.15u
M292 a_30215_48974# wl_driver_3.WL write_driver_5.BL VSS sky130_fd_pr__nfet_01v8 w=0.6u l=0.15u
M293 a_12167_33886# wl_driver_0.WL write_driver_2.BLB VSS sky130_fd_pr__nfet_01v8 w=0.6u l=0.15u
M294 a_12167_48886# wl_driver_3.WL write_driver_2.BLB VSS sky130_fd_pr__nfet_01v8 w=0.6u l=0.15u
M295 a_30167_48886# a_30215_48974# VDD VDD sky130_fd_pr__pfet_01v8 w=0.42u l=0.15u
M296 VDD a_12227_13916# a_14627_13496# VDD sky130_fd_pr__pfet_01v8 w=5.04u l=0.15u
M297 a_25027_13496# DIN_B4 write_driver_4.BL VDD sky130_fd_pr__pfet_01v8 w=5.04u l=0.15u
M298 a_30167_33886# a_30215_33974# VDD VDD sky130_fd_pr__pfet_01v8 w=0.42u l=0.15u
M299 VSS WE a_31415_9496# VSS sky130_fd_pr__nfet_01v8 w=5.04u l=0.15u
M300 a_12215_38974# a_12167_38886# VDD VDD sky130_fd_pr__pfet_01v8 w=0.42u l=0.15u
M301 VDD PRECH write_driver_6.BL VDD sky130_fd_pr__pfet_01v8 w=2.52u l=0.15u
M302 a_6167_43886# a_6215_43974# VSS VSS sky130_fd_pr__nfet_01v8 w=1.26u l=0.15u
M303 VDD PRECH write_driver_4.BLB VDD sky130_fd_pr__pfet_01v8 w=2.52u l=0.15u
M304 VDD a_30227_13916# a_31027_13496# VDD sky130_fd_pr__pfet_01v8 w=5.04u l=0.15u
M305 VDD PCLK row_decoder_0.N3 VDD sky130_fd_pr__pfet_01v8 w=1.25u l=0.15u
M306 DOUT5 SCLK write_driver_5.BL VDD sky130_fd_pr__pfet_01v8 w=2u l=0.15u
M307 write_driver_3.BLB SCLK sense_amp_3.SA_OUTB VDD sky130_fd_pr__pfet_01v8 w=2u l=0.15u
M308 VDD ROW2 a_n6773_44432# VDD sky130_fd_pr__pfet_01v8 w=1.68u l=0.15u
M309 row_decoder_0.EVAL_GND row_decoder_0.A0B row_decoder_0.net1 VSS sky130_fd_pr__nfet_01v8 w=2u l=0.15u
M310 a_36167_38886# a_36215_38974# VSS VSS sky130_fd_pr__nfet_01v8 w=1.26u l=0.15u
M311 a_36215_43974# wl_driver_2.WL write_driver_6.BL VSS sky130_fd_pr__nfet_01v8 w=0.6u l=0.15u
M312 a_18167_43886# wl_driver_2.WL write_driver_3.BLB VSS sky130_fd_pr__nfet_01v8 w=0.6u l=0.15u
M313 a_36167_43886# a_36215_43974# VDD VDD sky130_fd_pr__pfet_01v8 w=0.42u l=0.15u
M314 a_12615_19902# DOUT2 sense_amp_2.SA_OUTB VSS sky130_fd_pr__nfet_01v8 w=0.98u l=0.15u
M315 VDD sense_amp_3.SA_OUTB DOUT3 VDD sky130_fd_pr__pfet_01v8 w=1.89u l=0.15u
M316 a_167_33886# a_215_33974# VSS VSS sky130_fd_pr__nfet_01v8 w=1.26u l=0.15u
M317 a_167_48886# a_215_48974# VSS VSS sky130_fd_pr__nfet_01v8 w=1.26u l=0.15u
M318 a_18215_48974# a_18167_48886# VDD VDD sky130_fd_pr__pfet_01v8 w=0.42u l=0.15u
M319 a_18215_33974# a_18167_33886# VDD VDD sky130_fd_pr__pfet_01v8 w=0.42u l=0.15u
M320 VSS SCLK a_6615_19902# VSS sky130_fd_pr__nfet_01v8 w=0.98u l=0.15u
M321 a_42215_33974# a_42167_33886# VSS VSS sky130_fd_pr__nfet_01v8 w=1.26u l=0.15u
M322 a_42215_48974# a_42167_48886# VSS VSS sky130_fd_pr__nfet_01v8 w=1.26u l=0.15u
M323 VSS WE a_9015_9496# VSS sky130_fd_pr__nfet_01v8 w=5.04u l=0.15u
M324 a_24167_33886# a_24215_33974# VSS VSS sky130_fd_pr__nfet_01v8 w=1.26u l=0.15u
M325 write_driver_6.BLB SCLK sense_amp_6.SA_OUTB VDD sky130_fd_pr__pfet_01v8 w=2u l=0.15u
M326 a_24167_48886# a_24215_48974# VSS VSS sky130_fd_pr__nfet_01v8 w=1.26u l=0.15u
M327 a_33015_9496# DIN5 write_driver_5.BLB VSS sky130_fd_pr__nfet_01v8 w=5.04u l=0.15u
M328 row_decoder_0.EVAL_GND row_decoder_0.A0T row_decoder_0.net2 VSS sky130_fd_pr__nfet_01v8 w=2u l=0.15u
M329 a_37415_9496# DIN_B6 write_driver_6.BL VSS sky130_fd_pr__nfet_01v8 w=5.04u l=0.15u
M330 write_driver_1.BLB PRECH write_driver_1.BL VDD sky130_fd_pr__pfet_01v8 w=2.52u l=0.15u
M331 a_167_33886# wl_driver_0.WL write_driver_0.BLB VSS sky130_fd_pr__nfet_01v8 w=0.6u l=0.15u
M332 a_167_48886# wl_driver_3.WL write_driver_0.BLB VSS sky130_fd_pr__nfet_01v8 w=0.6u l=0.15u
M333 a_30215_43974# a_30167_43886# VSS VSS sky130_fd_pr__nfet_01v8 w=1.26u l=0.15u
M334 VDD a_227_13916# a_2627_13496# VDD sky130_fd_pr__pfet_01v8 w=5.04u l=0.15u
M335 a_12167_43886# a_12215_43974# VSS VSS sky130_fd_pr__nfet_01v8 w=1.26u l=0.15u
M336 a_8627_13496# DIN1 write_driver_1.BLB VDD sky130_fd_pr__pfet_01v8 w=5.04u l=0.15u
M337 a_6167_43886# wl_driver_2.WL write_driver_1.BLB VSS sky130_fd_pr__nfet_01v8 w=0.6u l=0.15u
M338 VSS SCLK a_12615_19902# VSS sky130_fd_pr__nfet_01v8 w=0.98u l=0.15u
M339 VSS WE a_27015_9496# VSS sky130_fd_pr__nfet_01v8 w=5.04u l=0.15u
M340 a_615_19902# DOUT0 sense_amp_0.SA_OUTB VSS sky130_fd_pr__nfet_01v8 w=0.98u l=0.15u
M341 VDD sense_amp_1.SA_OUTB DOUT1 VDD sky130_fd_pr__pfet_01v8 w=1.89u l=0.15u
M342 VSS A1 row_decoder_0.A1B VSS sky130_fd_pr__nfet_01v8 w=0.84u l=0.15u
M343 a_6215_48974# a_6167_48886# VDD VDD sky130_fd_pr__pfet_01v8 w=0.42u l=0.15u
M344 a_6215_33974# a_6167_33886# VDD VDD sky130_fd_pr__pfet_01v8 w=0.42u l=0.15u
M345 a_615_19902# sense_amp_0.SA_OUTB DOUT0 VSS sky130_fd_pr__nfet_01v8 w=0.98u l=0.15u
M346 VSS WE a_30227_13916# VSS sky130_fd_pr__nfet_01v8 w=0.84u l=0.15u
M347 write_driver_2.BLB PRECH write_driver_2.BL VDD sky130_fd_pr__pfet_01v8 w=2.52u l=0.15u
M348 a_18215_38974# a_18167_38886# VSS VSS sky130_fd_pr__nfet_01v8 w=1.26u l=0.15u
M349 a_36167_38886# wl_driver_1.WL write_driver_6.BLB VSS sky130_fd_pr__nfet_01v8 w=0.6u l=0.15u
M350 a_24615_19902# sense_amp_4.SA_OUTB DOUT4 VSS sky130_fd_pr__nfet_01v8 w=0.98u l=0.15u
M351 VDD PRECH write_driver_5.BL VDD sky130_fd_pr__pfet_01v8 w=2.52u l=0.15u
M352 VSS WE a_1415_9496# VSS sky130_fd_pr__nfet_01v8 w=5.04u l=0.15u
M353 a_42215_33974# wl_driver_0.WL write_driver_7.BL VSS sky130_fd_pr__nfet_01v8 w=0.6u l=0.15u
M354 a_42215_48974# wl_driver_3.WL write_driver_7.BL VSS sky130_fd_pr__nfet_01v8 w=0.6u l=0.15u
M355 a_24167_33886# wl_driver_0.WL write_driver_4.BLB VSS sky130_fd_pr__nfet_01v8 w=0.6u l=0.15u
M356 a_215_38974# a_167_38886# VDD VDD sky130_fd_pr__pfet_01v8 w=0.42u l=0.15u
M357 a_24167_48886# wl_driver_3.WL write_driver_4.BLB VSS sky130_fd_pr__nfet_01v8 w=0.6u l=0.15u
M358 VDD a_24227_13916# a_26627_13496# VDD sky130_fd_pr__pfet_01v8 w=5.04u l=0.15u
M359 a_37027_13496# DIN_B6 write_driver_6.BL VDD sky130_fd_pr__pfet_01v8 w=5.04u l=0.15u
M360 a_42167_33886# a_42215_33974# VDD VDD sky130_fd_pr__pfet_01v8 w=0.42u l=0.15u
M361 a_42167_48886# a_42215_48974# VDD VDD sky130_fd_pr__pfet_01v8 w=0.42u l=0.15u
M362 a_14627_13496# DIN2 write_driver_2.BLB VDD sky130_fd_pr__pfet_01v8 w=5.04u l=0.15u
M363 a_24215_38974# a_24167_38886# VDD VDD sky130_fd_pr__pfet_01v8 w=0.42u l=0.15u
M364 VSS a_n6773_39432# wl_driver_1.WL VSS sky130_fd_pr__nfet_01v8 w=5.04u l=0.15u
M365 a_30167_38886# a_30215_38974# VSS VSS sky130_fd_pr__nfet_01v8 w=1.26u l=0.15u
M366 a_30215_43974# wl_driver_2.WL write_driver_5.BL VSS sky130_fd_pr__nfet_01v8 w=0.6u l=0.15u
M367 VDD PRECH write_driver_6.BLB VDD sky130_fd_pr__pfet_01v8 w=2.52u l=0.15u
M368 a_12167_43886# wl_driver_2.WL write_driver_2.BLB VSS sky130_fd_pr__nfet_01v8 w=0.6u l=0.15u
M369 VSS row_decoder_0.N1 DEC1 VSS sky130_fd_pr__nfet_01v8 w=2u l=0.15u
M370 a_30167_43886# a_30215_43974# VDD VDD sky130_fd_pr__pfet_01v8 w=0.42u l=0.15u
M371 VDD a_42227_13916# a_43027_13496# VDD sky130_fd_pr__pfet_01v8 w=5.04u l=0.15u
M372 VDD sense_amp_2.SA_OUTB DOUT2 VDD sky130_fd_pr__pfet_01v8 w=1.89u l=0.15u
M373 a_12215_48974# a_12167_48886# VDD VDD sky130_fd_pr__pfet_01v8 w=0.42u l=0.15u
M374 VDD WE a_18227_13916# VDD sky130_fd_pr__pfet_01v8 w=0.84u l=0.15u
M375 a_12215_33974# a_12167_33886# VDD VDD sky130_fd_pr__pfet_01v8 w=0.42u l=0.15u
M376 VSS SCLK a_615_19902# VSS sky130_fd_pr__nfet_01v8 w=0.98u l=0.15u
M377 DOUT7 SCLK write_driver_7.BL VDD sky130_fd_pr__pfet_01v8 w=2u l=0.15u
M378 write_driver_5.BLB SCLK sense_amp_5.SA_OUTB VDD sky130_fd_pr__pfet_01v8 w=2u l=0.15u
M379 VDD DEC0 row_decoder_0.N0 VDD sky130_fd_pr__pfet_01v8 w=0.84u l=0.15u
M380 write_driver_0.BLB PRECH write_driver_0.BL VDD sky130_fd_pr__pfet_01v8 w=2.52u l=0.15u
M381 a_6215_38974# a_6167_38886# VSS VSS sky130_fd_pr__nfet_01v8 w=1.26u l=0.15u
M382 a_24615_19902# DOUT4 sense_amp_4.SA_OUTB VSS sky130_fd_pr__nfet_01v8 w=0.98u l=0.15u
M383 a_3015_9496# DIN0 write_driver_0.BLB VSS sky130_fd_pr__nfet_01v8 w=5.04u l=0.15u
M384 VDD DOUT3 sense_amp_3.SA_OUTB VDD sky130_fd_pr__pfet_01v8 w=1.89u l=0.15u
M385 a_7415_9496# DIN_B1 write_driver_1.BL VSS sky130_fd_pr__nfet_01v8 w=5.04u l=0.15u
M386 VDD PCLK row_decoder_0.N0 VDD sky130_fd_pr__pfet_01v8 w=1.25u l=0.15u
M387 VSS WE a_19415_9496# VSS sky130_fd_pr__nfet_01v8 w=5.04u l=0.15u
M388 a_36167_33886# a_36215_33974# VSS VSS sky130_fd_pr__nfet_01v8 w=1.26u l=0.15u
M389 VSS ROW1 a_n6773_39432# VSS sky130_fd_pr__nfet_01v8 w=1.68u l=0.15u
M390 a_36167_48886# a_36215_48974# VSS VSS sky130_fd_pr__nfet_01v8 w=1.26u l=0.15u
M391 VDD row_decoder_0.N1 DEC1 VDD sky130_fd_pr__pfet_01v8 w=3u l=0.15u
M392 VDD DEC1 row_decoder_0.N1 VDD sky130_fd_pr__pfet_01v8 w=0.84u l=0.15u
M393 a_167_43886# a_215_43974# VSS VSS sky130_fd_pr__nfet_01v8 w=1.26u l=0.15u
M394 a_18215_43974# a_18167_43886# VDD VDD sky130_fd_pr__pfet_01v8 w=0.42u l=0.15u
M395 a_18215_38974# wl_driver_1.WL write_driver_3.BL VSS sky130_fd_pr__nfet_01v8 w=0.6u l=0.15u
M396 a_2627_13496# DIN0 write_driver_0.BLB VDD sky130_fd_pr__pfet_01v8 w=5.04u l=0.15u
M397 a_42215_43974# a_42167_43886# VSS VSS sky130_fd_pr__nfet_01v8 w=1.26u l=0.15u
M398 VDD PCLK row_decoder_0.N1 VDD sky130_fd_pr__pfet_01v8 w=1.25u l=0.15u
M399 a_24167_43886# a_24215_43974# VSS VSS sky130_fd_pr__nfet_01v8 w=1.26u l=0.15u
M400 a_18167_38886# a_18215_38974# VDD VDD sky130_fd_pr__pfet_01v8 w=0.42u l=0.15u
.ends leaf_fabric
