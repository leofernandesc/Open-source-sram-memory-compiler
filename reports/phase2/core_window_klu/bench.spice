* Full 4x8 phase-window fixture; ideal phases, NOT a qualified macro
.lib "/opt/pdks/sky130A/libs.tech/ngspice/sky130.lib.spice" tt
.include "core.spice"
.include "capture_ff.spice"
.temp 27
.options method=gear reltol=1e-4 vabstol=1e-8 iabstol=1e-12
VSS_SRC VSS 0 0
VDD_SRC VDD 0 PWL(0 0 1n 1.8)
.options klu
V_CLK CLK 0 PWL(0n 0 10n 0 10.05n 1.8 20n 1.8 20.05n 0 30n 0 30.05n 1.8 40n 1.8 40.05n 0 50n 0 50.05n 1.8 60n 1.8 60.05n 0 70n 0 70.05n 1.8 80n 1.8 80.05n 0 90n 0 90.05n 1.8 100n 1.8 100.05n 0 110n 0 110.05n 1.8 120n 1.8 120.05n 0 130n 0 130.05n 1.8 140n 1.8 140.05n 0 150n 0 150.05n 1.8 160n 1.8 160.05n 0 170n 0 170.05n 1.8 180n 1.8 180.05n 0 190n 0 190.05n 1.8 200n 1.8 200.05n 0 210n 0 210.05n 1.8 220n 1.8 220.05n 0 230n 0 230.05n 1.8 240n 1.8 240.05n 0 250n 0 250.05n 1.8 260n 1.8 260.05n 0 270n 0 270.05n 1.8 280n 1.8 280.05n 0 290n 0 290.05n 1.8 300n 1.8 300.05n 0 310n 0 310.05n 1.8 320n 1.8 320.05n 0 330n 0 330.05n 1.8 340n 1.8 340.05n 0 350n 0 350.05n 1.8 360n 1.8 360.05n 0 370n 0 370.05n 1.8 380n 1.8 380.05n 0 390n 0 390.05n 1.8 400n 1.8 400.05n 0 410n 0 410.05n 1.8 420n 1.8 420.05n 0 430n 0 430.05n 1.8 440n 1.8 440.05n 0 450n 0 450.05n 1.8 460n 1.8 460.05n 0 470n 0 470.05n 1.8 480n 1.8 480.05n 0)
V_PCLK PCLK 0 PWL(0n 0 11n 0 11.05n 1.8 19n 1.8 19.05n 0 31n 0 31.05n 1.8 39n 1.8 39.05n 0 51n 0 51.05n 1.8 59n 1.8 59.05n 0 71n 0 71.05n 1.8 79n 1.8 79.05n 0 91n 0 91.05n 1.8 99n 1.8 99.05n 0 111n 0 111.05n 1.8 119n 1.8 119.05n 0 131n 0 131.05n 1.8 139n 1.8 139.05n 0 151n 0 151.05n 1.8 159n 1.8 159.05n 0 171n 0 171.05n 1.8 179n 1.8 179.05n 0 251n 0 251.05n 1.8 259n 1.8 259.05n 0 271n 0 271.05n 1.8 279n 1.8 279.05n 0 291n 0 291.05n 1.8 299n 1.8 299.05n 0 311n 0 311.05n 1.8 319n 1.8 319.05n 0 331n 0 331.05n 1.8 339n 1.8 339.05n 0 351n 0 351.05n 1.8 359n 1.8 359.05n 0 371n 0 371.05n 1.8 379n 1.8 379.05n 0 391n 0 391.05n 1.8 399n 1.8 399.05n 0 411n 0 411.05n 1.8 419n 1.8 419.05n 0 431n 0 431.05n 1.8 439n 1.8 439.05n 0 451n 0 451.05n 1.8 459n 1.8 459.05n 0 471n 0 471.05n 1.8 479n 1.8 479.05n 0)
V_PRECH PRECH 0 PWL(0n 0 10.2n 0 10.25n 1.8 20.5n 1.8 20.55n 0 30.2n 0 30.25n 1.8 40.5n 1.8 40.55n 0 50.2n 0 50.25n 1.8 60.5n 1.8 60.55n 0 70.2n 0 70.25n 1.8 80.5n 1.8 80.55n 0 90.2n 0 90.25n 1.8 100.5n 1.8 100.55n 0 110.2n 0 110.25n 1.8 120.5n 1.8 120.55n 0 130.2n 0 130.25n 1.8 140.5n 1.8 140.55n 0 150.2n 0 150.25n 1.8 160.5n 1.8 160.55n 0 170.2n 0 170.25n 1.8 180.5n 1.8 180.55n 0 250.2n 0 250.25n 1.8 260.5n 1.8 260.55n 0 270.2n 0 270.25n 1.8 280.5n 1.8 280.55n 0 290.2n 0 290.25n 1.8 300.5n 1.8 300.55n 0 310.2n 0 310.25n 1.8 320.5n 1.8 320.55n 0 330.2n 0 330.25n 1.8 340.5n 1.8 340.55n 0 350.2n 0 350.25n 1.8 360.5n 1.8 360.55n 0 370.2n 0 370.25n 1.8 380.5n 1.8 380.55n 0 390.2n 0 390.25n 1.8 400.5n 1.8 400.55n 0 410.2n 0 410.25n 1.8 420.5n 1.8 420.55n 0 430.2n 0 430.25n 1.8 440.5n 1.8 440.55n 0 450.2n 0 450.25n 1.8 460.5n 1.8 460.55n 0 470.2n 0 470.25n 1.8 480.5n 1.8 480.55n 0)
V_SCLK SCLK 0 PWL(0n 0 16n 0 16.05n 1.8 21n 1.8 21.05n 0 116n 0 116.05n 1.8 121n 1.8 121.05n 0 136n 0 136.05n 1.8 141n 1.8 141.05n 0 156n 0 156.05n 1.8 161n 1.8 161.05n 0 176n 0 176.05n 1.8 181n 1.8 181.05n 0 256n 0 256.05n 1.8 261n 1.8 261.05n 0 276n 0 276.05n 1.8 281n 1.8 281.05n 0 296n 0 296.05n 1.8 301n 1.8 301.05n 0 316n 0 316.05n 1.8 321n 1.8 321.05n 0 416n 0 416.05n 1.8 421n 1.8 421.05n 0 436n 0 436.05n 1.8 441n 1.8 441.05n 0 456n 0 456.05n 1.8 461n 1.8 461.05n 0 476n 0 476.05n 1.8 481n 1.8 481.05n 0)
V_WE WE 0 PWL(0n 0 30.5n 0 30.55n 1.8 39n 1.8 39.05n 0 50.5n 0 50.55n 1.8 59n 1.8 59.05n 0 70.5n 0 70.55n 1.8 79n 1.8 79.05n 0 90.5n 0 90.55n 1.8 99n 1.8 99.05n 0 330.5n 0 330.55n 1.8 339n 1.8 339.05n 0 350.5n 0 350.55n 1.8 359n 1.8 359.05n 0 370.5n 0 370.55n 1.8 379n 1.8 379.05n 0 390.5n 0 390.55n 1.8 399n 1.8 399.05n 0)
V_WL_EN WL_EN 0 PWL(0n 0 11.5n 0 11.55n 1.8 19n 1.8 19.05n 0 31.5n 0 31.55n 1.8 39n 1.8 39.05n 0 51.5n 0 51.55n 1.8 59n 1.8 59.05n 0 71.5n 0 71.55n 1.8 79n 1.8 79.05n 0 91.5n 0 91.55n 1.8 99n 1.8 99.05n 0 111.5n 0 111.55n 1.8 119n 1.8 119.05n 0 131.5n 0 131.55n 1.8 139n 1.8 139.05n 0 151.5n 0 151.55n 1.8 159n 1.8 159.05n 0 171.5n 0 171.55n 1.8 179n 1.8 179.05n 0 251.5n 0 251.55n 1.8 259n 1.8 259.05n 0 271.5n 0 271.55n 1.8 279n 1.8 279.05n 0 291.5n 0 291.55n 1.8 299n 1.8 299.05n 0 311.5n 0 311.55n 1.8 319n 1.8 319.05n 0 331.5n 0 331.55n 1.8 339n 1.8 339.05n 0 351.5n 0 351.55n 1.8 359n 1.8 359.05n 0 371.5n 0 371.55n 1.8 379n 1.8 379.05n 0 391.5n 0 391.55n 1.8 399n 1.8 399.05n 0 411.5n 0 411.55n 1.8 419n 1.8 419.05n 0 431.5n 0 431.55n 1.8 439n 1.8 439.05n 0 451.5n 0 451.55n 1.8 459n 1.8 459.05n 0 471.5n 0 471.55n 1.8 479n 1.8 479.05n 0)
V_A0 A0 0 PWL(0n 0 8n 0 8.05n 0 28n 0 28.05n 0 48n 0 48.05n 1.8 68n 1.8 68.05n 0 88n 0 88.05n 1.8 108n 1.8 108.05n 0 128n 0 128.05n 1.8 148n 1.8 148.05n 0 168n 0 168.05n 1.8 188n 1.8 188.05n 0 208n 0 208.05n 0 228n 0 228.05n 0 248n 0 248.05n 1.8 268n 1.8 268.05n 0 288n 0 288.05n 1.8 308n 1.8 308.05n 0 328n 0 328.05n 0 348n 0 348.05n 1.8 368n 1.8 368.05n 0 388n 0 388.05n 1.8 408n 1.8 408.05n 0 428n 0 428.05n 1.8 448n 1.8 448.05n 0 468n 0 468.05n 1.8)
V_A1 A1 0 PWL(0n 0 8n 0 8.05n 0 28n 0 28.05n 0 48n 0 48.05n 0 68n 0 68.05n 1.8 88n 1.8 88.05n 1.8 108n 1.8 108.05n 0 128n 0 128.05n 0 148n 0 148.05n 1.8 168n 1.8 168.05n 1.8 188n 1.8 188.05n 0 208n 0 208.05n 0 228n 0 228.05n 0 248n 0 248.05n 1.8 268n 1.8 268.05n 1.8 288n 1.8 288.05n 0 308n 0 308.05n 0 328n 0 328.05n 0 348n 0 348.05n 0 368n 0 368.05n 1.8 388n 1.8 388.05n 1.8 408n 1.8 408.05n 0 428n 0 428.05n 0 448n 0 448.05n 1.8 468n 1.8 468.05n 1.8)
V_DIN0 DIN0 0 PWL(0n 0 8n 0 8.05n 0 28n 0 28.05n 1.8 48n 1.8 48.05n 0 68n 0 68.05n 1.8 88n 1.8 88.05n 0 108n 0 108.05n 1.8 128n 1.8 128.05n 0 148n 0 148.05n 1.8 168n 1.8 168.05n 0 188n 0 188.05n 0 208n 0 208.05n 0 228n 0 228.05n 0 248n 0 248.05n 0 268n 0 268.05n 1.8 288n 1.8 288.05n 0 308n 0 308.05n 1.8 328n 1.8 328.05n 1.8 348n 1.8 348.05n 0 368n 0 368.05n 1.8 388n 1.8 388.05n 0 408n 0 408.05n 1.8 428n 1.8 428.05n 0 448n 0 448.05n 1.8 468n 1.8 468.05n 0)
V_DIN1 DIN1 0 PWL(0n 0 8n 0 8.05n 0 28n 0 28.05n 1.8 48n 1.8 48.05n 1.8 68n 1.8 68.05n 0 88n 0 88.05n 0 108n 0 108.05n 1.8 128n 1.8 128.05n 1.8 148n 1.8 148.05n 0 168n 0 168.05n 0 188n 0 188.05n 0 208n 0 208.05n 0 228n 0 228.05n 0 248n 0 248.05n 0 268n 0 268.05n 0 288n 0 288.05n 1.8 308n 1.8 308.05n 1.8 328n 1.8 328.05n 0 348n 0 348.05n 1.8 368n 1.8 368.05n 0 388n 0 388.05n 1.8 408n 1.8 408.05n 0 428n 0 428.05n 1.8 448n 1.8 448.05n 0 468n 0 468.05n 1.8)
V_DIN2 DIN2 0 PWL(0n 0 8n 0 8.05n 0 28n 0 28.05n 1.8 48n 1.8 48.05n 0 68n 0 68.05n 1.8 88n 1.8 88.05n 0 108n 0 108.05n 1.8 128n 1.8 128.05n 0 148n 0 148.05n 1.8 168n 1.8 168.05n 0 188n 0 188.05n 0 208n 0 208.05n 0 228n 0 228.05n 0 248n 0 248.05n 0 268n 0 268.05n 1.8 288n 1.8 288.05n 0 308n 0 308.05n 1.8 328n 1.8 328.05n 1.8 348n 1.8 348.05n 0 368n 0 368.05n 1.8 388n 1.8 388.05n 0 408n 0 408.05n 1.8 428n 1.8 428.05n 0 448n 0 448.05n 1.8 468n 1.8 468.05n 0)
V_DIN3 DIN3 0 PWL(0n 0 8n 0 8.05n 0 28n 0 28.05n 0 48n 0 48.05n 1.8 68n 1.8 68.05n 1.8 88n 1.8 88.05n 0 108n 0 108.05n 0 128n 0 128.05n 1.8 148n 1.8 148.05n 1.8 168n 1.8 168.05n 0 188n 0 188.05n 0 208n 0 208.05n 0 228n 0 228.05n 0 248n 0 248.05n 0 268n 0 268.05n 1.8 288n 1.8 288.05n 1.8 308n 1.8 308.05n 0 328n 0 328.05n 0 348n 0 348.05n 1.8 368n 1.8 368.05n 0 388n 0 388.05n 1.8 408n 1.8 408.05n 0 428n 0 428.05n 1.8 448n 1.8 448.05n 0 468n 0 468.05n 1.8)
V_DIN4 DIN4 0 PWL(0n 0 8n 0 8.05n 0 28n 0 28.05n 0 48n 0 48.05n 0 68n 0 68.05n 1.8 88n 1.8 88.05n 0 108n 0 108.05n 0 128n 0 128.05n 0 148n 0 148.05n 1.8 168n 1.8 168.05n 0 188n 0 188.05n 0 208n 0 208.05n 0 228n 0 228.05n 0 248n 0 248.05n 0 268n 0 268.05n 1.8 288n 1.8 288.05n 0 308n 0 308.05n 0 328n 0 328.05n 1.8 348n 1.8 348.05n 0 368n 0 368.05n 1.8 388n 1.8 388.05n 0 408n 0 408.05n 1.8 428n 1.8 428.05n 0 448n 0 448.05n 1.8 468n 1.8 468.05n 0)
V_DIN5 DIN5 0 PWL(0n 0 8n 0 8.05n 0 28n 0 28.05n 1.8 48n 1.8 48.05n 1.8 68n 1.8 68.05n 1.8 88n 1.8 88.05n 0 108n 0 108.05n 1.8 128n 1.8 128.05n 1.8 148n 1.8 148.05n 1.8 168n 1.8 168.05n 0 188n 0 188.05n 0 208n 0 208.05n 0 228n 0 228.05n 0 248n 0 248.05n 0 268n 0 268.05n 1.8 288n 1.8 288.05n 1.8 308n 1.8 308.05n 1.8 328n 1.8 328.05n 0 348n 0 348.05n 1.8 368n 1.8 368.05n 0 388n 0 388.05n 1.8 408n 1.8 408.05n 0 428n 0 428.05n 1.8 448n 1.8 448.05n 0 468n 0 468.05n 1.8)
V_DIN6 DIN6 0 PWL(0n 0 8n 0 8.05n 0 28n 0 28.05n 0 48n 0 48.05n 0 68n 0 68.05n 0 88n 0 88.05n 0 108n 0 108.05n 0 128n 0 128.05n 0 148n 0 148.05n 0 168n 0 168.05n 0 188n 0 188.05n 0 208n 0 208.05n 0 228n 0 228.05n 0 248n 0 248.05n 0 268n 0 268.05n 0 288n 0 288.05n 0 308n 0 308.05n 0 328n 0 328.05n 1.8 348n 1.8 348.05n 0 368n 0 368.05n 1.8 388n 1.8 388.05n 0 408n 0 408.05n 1.8 428n 1.8 428.05n 0 448n 0 448.05n 1.8 468n 1.8 468.05n 0)
V_DIN7 DIN7 0 PWL(0n 0 8n 0 8.05n 0 28n 0 28.05n 1.8 48n 1.8 48.05n 1.8 68n 1.8 68.05n 1.8 88n 1.8 88.05n 1.8 108n 1.8 108.05n 1.8 128n 1.8 128.05n 1.8 148n 1.8 148.05n 1.8 168n 1.8 168.05n 1.8 188n 1.8 188.05n 0 208n 0 208.05n 0 228n 0 228.05n 0 248n 0 248.05n 1.8 268n 1.8 268.05n 1.8 288n 1.8 288.05n 1.8 308n 1.8 308.05n 1.8 328n 1.8 328.05n 0 348n 0 348.05n 1.8 368n 1.8 368.05n 0 388n 0 388.05n 1.8 408n 1.8 408.05n 0 428n 0 428.05n 1.8 448n 1.8 448.05n 0 468n 0 468.05n 1.8)
XCORE VDD VSS A0 A1 DIN0 DIN1 DIN2 DIN3 DIN4 DIN5 DIN6 DIN7 PCLK PRECH SCLK WE WL_EN DOUT0 DOUT1 DOUT2 DOUT3 DOUT4 DOUT5 DOUT6 DOUT7 sram_4x8_phase_harness
XCLKINV CLK VSS VSS VDD VDD CLKB sky130_fd_sc_hd__inv_1
XFF0 CLKB DOUT0 VSS VSS VDD VDD Q0 sky130_fd_sc_hd__dfxtp_1
C_Q0 Q0 VSS 1f
XFF1 CLKB DOUT1 VSS VSS VDD VDD Q1 sky130_fd_sc_hd__dfxtp_1
C_Q1 Q1 VSS 1f
XFF2 CLKB DOUT2 VSS VSS VDD VDD Q2 sky130_fd_sc_hd__dfxtp_1
C_Q2 Q2 VSS 1f
XFF3 CLKB DOUT3 VSS VSS VDD VDD Q3 sky130_fd_sc_hd__dfxtp_1
C_Q3 Q3 VSS 1f
XFF4 CLKB DOUT4 VSS VSS VDD VDD Q4 sky130_fd_sc_hd__dfxtp_1
C_Q4 Q4 VSS 1f
XFF5 CLKB DOUT5 VSS VSS VDD VDD Q5 sky130_fd_sc_hd__dfxtp_1
C_Q5 Q5 VSS 1f
XFF6 CLKB DOUT6 VSS VSS VDD VDD Q6 sky130_fd_sc_hd__dfxtp_1
C_Q6 Q6 VSS 1f
XFF7 CLKB DOUT7 VSS VSS VDD VDD Q7 sky130_fd_sc_hd__dfxtp_1
C_Q7 Q7 VSS 1f
.save v(Q0) v(Q1) v(Q2) v(Q3) v(Q4) v(Q5) v(Q6) v(Q7) v(DOUT0) v(DOUT1) v(DOUT2) v(DOUT3) v(DOUT4) v(DOUT5) v(DOUT6) v(DOUT7) v(PRECH) v(SCLK) v(WL_EN)
.control
set noaskquit
set wr_singlescale
set wr_vecnames
tran 10p 490n 0 10p
wrdata waveform.dat v(Q0) v(Q1) v(Q2) v(Q3) v(Q4) v(Q5) v(Q6) v(Q7) v(DOUT0) v(DOUT1) v(DOUT2) v(DOUT3) v(DOUT4) v(DOUT5) v(DOUT6) v(DOUT7) v(PRECH) v(SCLK) v(WL_EN)
quit
.endc
.end
