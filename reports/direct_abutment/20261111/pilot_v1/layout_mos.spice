.model sky130_fd_pr__nfet_01v8 nmos
.model sky130_fd_pr__pfet_01v8 pmos
.model sky130_fd_pr__pfet_01v8_hvt pmos
.model sky130_fd_pr__special_nfet_01v8 nmos
.subckt array_2x2_abut X0 a_617_936# bitcell_6t_abut_1.WL bitcell_6t_abut_2.BLB bitcell_6t_abut_3.VSS sky130_fd_pr__nfet_01v8 ad=0.174 pd=1.78 as=0.174 ps=1.78 w=0.6 l=0.15
M0 a_617_936# bitcell_6t_abut_1.WL bitcell_6t_abut_2.BLB bitcell_6t_abut_3.VSS sky130_fd_pr__nfet_01v8 w=0.6u l=0.15u
M1 a_4115_3824# a_4067_3736# bitcell_6t_abut_3.VDD bitcell_6t_abut_3.VDD sky130_fd_pr__pfet_01v8 w=0.42u l=0.15u
M2 a_665_3824# a_617_3736# bitcell_6t_abut_3.VSS bitcell_6t_abut_3.VSS sky130_fd_pr__nfet_01v8 w=1.26u l=0.15u
M3 a_617_3736# a_665_3824# bitcell_6t_abut_3.VDD bitcell_6t_abut_3.VDD sky130_fd_pr__pfet_01v8 w=0.42u l=0.15u
M4 a_617_936# a_665_1024# bitcell_6t_abut_3.VSS bitcell_6t_abut_3.VSS sky130_fd_pr__nfet_01v8 w=1.26u l=0.15u
M5 a_665_1024# bitcell_6t_abut_1.WL bitcell_6t_abut_2.BL bitcell_6t_abut_3.VSS sky130_fd_pr__nfet_01v8 w=0.6u l=0.15u
M6 a_4115_3824# bitcell_6t_abut_3.WL bitcell_6t_abut_3.BL bitcell_6t_abut_3.VSS sky130_fd_pr__nfet_01v8 w=0.6u l=0.15u
M7 a_4115_3824# a_4067_3736# bitcell_6t_abut_3.VSS bitcell_6t_abut_3.VSS sky130_fd_pr__nfet_01v8 w=1.26u l=0.15u
M8 a_4067_936# bitcell_6t_abut_1.WL bitcell_6t_abut_3.BLB bitcell_6t_abut_3.VSS sky130_fd_pr__nfet_01v8 w=0.6u l=0.15u
M9 a_4067_3736# a_4115_3824# bitcell_6t_abut_3.VDD bitcell_6t_abut_3.VDD sky130_fd_pr__pfet_01v8 w=0.42u l=0.15u
M10 a_665_1024# a_617_936# bitcell_6t_abut_3.VDD bitcell_6t_abut_3.VDD sky130_fd_pr__pfet_01v8 w=0.42u l=0.15u
M11 a_4067_936# a_4115_1024# bitcell_6t_abut_3.VSS bitcell_6t_abut_3.VSS sky130_fd_pr__nfet_01v8 w=1.26u l=0.15u
M12 a_617_3736# bitcell_6t_abut_3.WL bitcell_6t_abut_2.BLB bitcell_6t_abut_3.VSS sky130_fd_pr__nfet_01v8 w=0.6u l=0.15u
M13 a_617_3736# a_665_3824# bitcell_6t_abut_3.VSS bitcell_6t_abut_3.VSS sky130_fd_pr__nfet_01v8 w=1.26u l=0.15u
M14 a_4115_1024# a_4067_936# bitcell_6t_abut_3.VDD bitcell_6t_abut_3.VDD sky130_fd_pr__pfet_01v8 w=0.42u l=0.15u
M15 a_665_3824# bitcell_6t_abut_3.WL bitcell_6t_abut_2.BL bitcell_6t_abut_3.VSS sky130_fd_pr__nfet_01v8 w=0.6u l=0.15u
M16 a_617_936# a_665_1024# bitcell_6t_abut_3.VDD bitcell_6t_abut_3.VDD sky130_fd_pr__pfet_01v8 w=0.42u l=0.15u
M17 a_665_1024# a_617_936# bitcell_6t_abut_3.VSS bitcell_6t_abut_3.VSS sky130_fd_pr__nfet_01v8 w=1.26u l=0.15u
M18 a_4115_1024# bitcell_6t_abut_1.WL bitcell_6t_abut_3.BL bitcell_6t_abut_3.VSS sky130_fd_pr__nfet_01v8 w=0.6u l=0.15u
M19 a_4067_3736# bitcell_6t_abut_3.WL bitcell_6t_abut_3.BLB bitcell_6t_abut_3.VSS sky130_fd_pr__nfet_01v8 w=0.6u l=0.15u
M20 a_665_3824# a_617_3736# bitcell_6t_abut_3.VDD bitcell_6t_abut_3.VDD sky130_fd_pr__pfet_01v8 w=0.42u l=0.15u
M21 a_4067_3736# a_4115_3824# bitcell_6t_abut_3.VSS bitcell_6t_abut_3.VSS sky130_fd_pr__nfet_01v8 w=1.26u l=0.15u
M22 a_4115_1024# a_4067_936# bitcell_6t_abut_3.VSS bitcell_6t_abut_3.VSS sky130_fd_pr__nfet_01v8 w=1.26u l=0.15u
M23 a_4067_936# a_4115_1024# bitcell_6t_abut_3.VDD bitcell_6t_abut_3.VDD sky130_fd_pr__pfet_01v8 w=0.42u l=0.15u
.ends array_2x2_abut
