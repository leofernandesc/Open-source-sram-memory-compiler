* NGSPICE file created from array_2x2_abut_flat.ext - technology: sky130A

.subckt array_2x2_abut_flat
X0 a_617_936# bitcell_6t_abut_1.WL bitcell_6t_abut_2.BLB bitcell_6t_abut_3.VSS sky130_fd_pr__nfet_01v8 ad=0.174 pd=1.78 as=0.174 ps=1.78 w=0.6 l=0.15
X1 a_4115_3824# a_4067_3736# bitcell_6t_abut_3.VDD bitcell_6t_abut_3.VDD sky130_fd_pr__pfet_01v8 ad=0.1218 pd=1.42 as=0.1218 ps=1.42 w=0.42 l=0.15
X2 a_665_3824# a_617_3736# bitcell_6t_abut_3.VSS bitcell_6t_abut_3.VSS sky130_fd_pr__nfet_01v8 ad=0.3654 pd=3.1 as=0.3654 ps=3.1 w=1.26 l=0.15
X3 a_617_3736# a_665_3824# bitcell_6t_abut_3.VDD bitcell_6t_abut_3.VDD sky130_fd_pr__pfet_01v8 ad=0.1218 pd=1.42 as=0.1218 ps=1.42 w=0.42 l=0.15
X4 a_617_936# a_665_1024# bitcell_6t_abut_3.VSS bitcell_6t_abut_3.VSS sky130_fd_pr__nfet_01v8 ad=0.3654 pd=3.1 as=0.3654 ps=3.1 w=1.26 l=0.15
X5 a_665_1024# bitcell_6t_abut_1.WL bitcell_6t_abut_2.BL bitcell_6t_abut_3.VSS sky130_fd_pr__nfet_01v8 ad=0.174 pd=1.78 as=0.174 ps=1.78 w=0.6 l=0.15
X6 a_4115_3824# bitcell_6t_abut_3.WL bitcell_6t_abut_3.BL bitcell_6t_abut_3.VSS sky130_fd_pr__nfet_01v8 ad=0.174 pd=1.78 as=0.174 ps=1.78 w=0.6 l=0.15
X7 a_4115_3824# a_4067_3736# bitcell_6t_abut_3.VSS bitcell_6t_abut_3.VSS sky130_fd_pr__nfet_01v8 ad=0.3654 pd=3.1 as=0.3654 ps=3.1 w=1.26 l=0.15
X8 a_4067_936# bitcell_6t_abut_1.WL bitcell_6t_abut_3.BLB bitcell_6t_abut_3.VSS sky130_fd_pr__nfet_01v8 ad=0.174 pd=1.78 as=0.174 ps=1.78 w=0.6 l=0.15
X9 a_4067_3736# a_4115_3824# bitcell_6t_abut_3.VDD bitcell_6t_abut_3.VDD sky130_fd_pr__pfet_01v8 ad=0.1218 pd=1.42 as=0.1218 ps=1.42 w=0.42 l=0.15
X10 a_665_1024# a_617_936# bitcell_6t_abut_3.VDD bitcell_6t_abut_3.VDD sky130_fd_pr__pfet_01v8 ad=0.1218 pd=1.42 as=0.1218 ps=1.42 w=0.42 l=0.15
X11 a_4067_936# a_4115_1024# bitcell_6t_abut_3.VSS bitcell_6t_abut_3.VSS sky130_fd_pr__nfet_01v8 ad=0.3654 pd=3.1 as=0.3654 ps=3.1 w=1.26 l=0.15
X12 a_617_3736# bitcell_6t_abut_3.WL bitcell_6t_abut_2.BLB bitcell_6t_abut_3.VSS sky130_fd_pr__nfet_01v8 ad=0.174 pd=1.78 as=0.174 ps=1.78 w=0.6 l=0.15
X13 a_617_3736# a_665_3824# bitcell_6t_abut_3.VSS bitcell_6t_abut_3.VSS sky130_fd_pr__nfet_01v8 ad=0.3654 pd=3.1 as=0.3654 ps=3.1 w=1.26 l=0.15
X14 a_4115_1024# a_4067_936# bitcell_6t_abut_3.VDD bitcell_6t_abut_3.VDD sky130_fd_pr__pfet_01v8 ad=0.1218 pd=1.42 as=0.1218 ps=1.42 w=0.42 l=0.15
X15 a_665_3824# bitcell_6t_abut_3.WL bitcell_6t_abut_2.BL bitcell_6t_abut_3.VSS sky130_fd_pr__nfet_01v8 ad=0.174 pd=1.78 as=0.174 ps=1.78 w=0.6 l=0.15
X16 a_617_936# a_665_1024# bitcell_6t_abut_3.VDD bitcell_6t_abut_3.VDD sky130_fd_pr__pfet_01v8 ad=0.1218 pd=1.42 as=0.1218 ps=1.42 w=0.42 l=0.15
X17 a_665_1024# a_617_936# bitcell_6t_abut_3.VSS bitcell_6t_abut_3.VSS sky130_fd_pr__nfet_01v8 ad=0.3654 pd=3.1 as=0.3654 ps=3.1 w=1.26 l=0.15
X18 a_4115_1024# bitcell_6t_abut_1.WL bitcell_6t_abut_3.BL bitcell_6t_abut_3.VSS sky130_fd_pr__nfet_01v8 ad=0.174 pd=1.78 as=0.174 ps=1.78 w=0.6 l=0.15
X19 a_4067_3736# bitcell_6t_abut_3.WL bitcell_6t_abut_3.BLB bitcell_6t_abut_3.VSS sky130_fd_pr__nfet_01v8 ad=0.174 pd=1.78 as=0.174 ps=1.78 w=0.6 l=0.15
X20 a_665_3824# a_617_3736# bitcell_6t_abut_3.VDD bitcell_6t_abut_3.VDD sky130_fd_pr__pfet_01v8 ad=0.1218 pd=1.42 as=0.1218 ps=1.42 w=0.42 l=0.15
X21 a_4067_3736# a_4115_3824# bitcell_6t_abut_3.VSS bitcell_6t_abut_3.VSS sky130_fd_pr__nfet_01v8 ad=0.3654 pd=3.1 as=0.3654 ps=3.1 w=1.26 l=0.15
X22 a_4115_1024# a_4067_936# bitcell_6t_abut_3.VSS bitcell_6t_abut_3.VSS sky130_fd_pr__nfet_01v8 ad=0.3654 pd=3.1 as=0.3654 ps=3.1 w=1.26 l=0.15
X23 a_4067_936# a_4115_1024# bitcell_6t_abut_3.VDD bitcell_6t_abut_3.VDD sky130_fd_pr__pfet_01v8 ad=0.1218 pd=1.42 as=0.1218 ps=1.42 w=0.42 l=0.15
.ends
