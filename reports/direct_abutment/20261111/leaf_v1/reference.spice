.model sky130_fd_pr__nfet_01v8 nmos
.model sky130_fd_pr__pfet_01v8 pmos
.model sky130_fd_pr__pfet_01v8_hvt pmos
.model sky130_fd_pr__special_nfet_01v8 nmos
.subckt bitcell_6t_abut VDD BL BLB VSS WL
MMPL_r0_b0 Q_0_0 QB_0_0 VDD VDD sky130_fd_pr__pfet_01v8 w=0.42u l=0.15u
MMNL_r0_b0 Q_0_0 QB_0_0 VSS VSS sky130_fd_pr__nfet_01v8 w=1.26u l=0.15u
MMPR_r0_b0 QB_0_0 Q_0_0 VDD VDD sky130_fd_pr__pfet_01v8 w=0.42u l=0.15u
MMNR_r0_b0 QB_0_0 Q_0_0 VSS VSS sky130_fd_pr__nfet_01v8 w=1.26u l=0.15u
MMAL_r0_b0 Q_0_0 WL BL VSS sky130_fd_pr__nfet_01v8 w=0.6u l=0.15u
MMAR_r0_b0 BLB WL QB_0_0 VSS sky130_fd_pr__nfet_01v8 w=0.6u l=0.15u
.ends bitcell_6t_abut
