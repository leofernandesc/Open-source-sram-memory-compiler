* NGSPICE file created from sense_amp_scale1p5_flat.ext - technology: sky130A

.subckt sense_amp_scale1p5_flat VDD VSS BL BLB SCLK SA_OUT SA_OUTB
X0 a_615_n3098.t0 SA_OUT.t3 SA_OUTB.t1 VSS.t0 sky130_fd_pr__nfet_01v8 ad=0.2842 pd=2.54 as=0.2842 ps=2.54 w=0.98 l=0.15
X1 a_615_n3098.t2 SA_OUTB.t3 SA_OUT.t0 VSS.t3 sky130_fd_pr__nfet_01v8 ad=0.2842 pd=2.54 as=0.2842 ps=2.54 w=0.98 l=0.15
X2 BLB.t0 SCLK.t1 SA_OUTB.t2 VDD.t3 sky130_fd_pr__pfet_01v8 ad=0.58 pd=4.58 as=0.58 ps=4.58 w=2 l=0.15
X3 VSS.t2 SCLK.t0 a_615_n3098.t1 VSS.t1 sky130_fd_pr__nfet_01v8 ad=0.2842 pd=2.54 as=0.2842 ps=2.54 w=0.98 l=0.15
X4 VDD.t5 SA_OUTB.t4 SA_OUT.t1 VDD.t4 sky130_fd_pr__pfet_01v8 ad=0.5481 pd=4.36 as=0.5481 ps=4.36 w=1.89 l=0.15
X5 VDD.t1 SA_OUT.t4 SA_OUTB.t0 VDD.t0 sky130_fd_pr__pfet_01v8 ad=0.5481 pd=4.36 as=0.5481 ps=4.36 w=1.89 l=0.15
X6 SA_OUT.t2 SCLK.t2 BL.t0 VDD.t2 sky130_fd_pr__pfet_01v8 ad=0.58 pd=4.58 as=0.58 ps=4.58 w=2 l=0.15
R0 BLB BLB.t0 123.972
R1 BL BL.t0 123.6
R2 SCLK.n0 SCLK.t1 567.159
R3 SCLK.n1 SCLK.t2 566.852
R4 SCLK.n0 SCLK.t0 387.618
R5 SCLK SCLK.n1 1.20627
R6 SCLK.n1 SCLK.n0 0.140381
R7 SA_OUT.n1 SA_OUT.t4 548.649
R8 SA_OUT.n0 SA_OUT.t3 388.132
R9 SA_OUT.n3 SA_OUT.t1 143.55
R10 SA_OUT.n0 SA_OUT.t2 123.656
R11 SA_OUT.n2 SA_OUT.t0 93.6408
R12 SA_OUT.n2 SA_OUT.n1 0.354119
R13 SA_OUT.n3 SA_OUT.n2 0.168357
R14 SA_OUT.n1 SA_OUT.n0 0.0844286
R15 SA_OUT SA_OUT.n3 0.013369
R16 SA_OUTB.n3 SA_OUTB.t4 549.981
R17 SA_OUTB.n2 SA_OUTB.t3 386.979
R18 SA_OUTB.n1 SA_OUTB.t0 144.882
R19 SA_OUTB.n0 SA_OUTB.t2 125.222
R20 SA_OUTB.n0 SA_OUTB.t1 92.3089
R21 SA_OUTB.n1 SA_OUTB.n0 0.22431
R22 SA_OUTB.n2 SA_OUTB.n1 0.206405
R23 SA_OUTB.n3 SA_OUTB.n2 0.168357
R24 SA_OUTB SA_OUTB.n3 0.0172857
R25 VDD.n0 VDD.t3 188.915
R26 VDD.n0 VDD.t2 188.668
R27 VDD.n3 VDD.t4 188.554
R28 VDD.n1 VDD.t0 188.554
R29 VDD.n4 VDD.t5 143.096
R30 VDD.n2 VDD.t1 143.096
R31 VDD.n1 VDD.n0 0.448119
R32 VDD VDD.n4 0.384893
R33 VDD.n3 VDD.n2 0.354119
R34 VDD.n2 VDD.n1 0.0945
R35 VDD.n4 VDD.n3 0.0945
R36 VSS.n17 VSS.n16 49410
R37 VSS.n16 VSS.n2 48563
R38 VSS.n16 VSS.n15 11628.6
R39 VSS.n7 VSS.n3 2294.47
R40 VSS.n5 VSS.n3 2294.47
R41 VSS.n7 VSS.n6 2294.47
R42 VSS.n6 VSS.n5 2294.47
R43 VSS.n13 VSS.n10 2294.47
R44 VSS.n13 VSS.n12 2294.47
R45 VSS.n12 VSS.n11 2294.47
R46 VSS.n11 VSS.n10 2294.47
R47 VSS.n18 VSS.n1 1264.24
R48 VSS.n14 VSS.n8 1155.92
R49 VSS.n4 VSS.n1 1155.92
R50 VSS.n19 VSS.n18 421.236
R51 VSS.t1 VSS.n2 312.731
R52 VSS.n8 VSS.t0 312.731
R53 VSS.n4 VSS.t0 312.731
R54 VSS.n10 VSS.n9 305.411
R55 VSS.n3 VSS.n0 304.697
R56 VSS.n6 VSS.t0 292.5
R57 VSS.n3 VSS.t0 292.5
R58 VSS.n12 VSS.t1 292.5
R59 VSS.n10 VSS.t1 292.5
R60 VSS.n17 VSS.n1 275.125
R61 VSS.n15 VSS.t1 197.931
R62 VSS.n18 VSS.t3 133.839
R63 VSS.n5 VSS.n4 117.001
R64 VSS.n8 VSS.n7 117.001
R65 VSS.n14 VSS.n13 117.001
R66 VSS.n11 VSS.n2 117.001
R67 VSS.n15 VSS.n14 114.8
R68 VSS.n9 VSS.t2 92.8751
R69 VSS.t3 VSS.n17 37.6073
R70 VSS VSS.n19 0.618774
R71 VSS.n19 VSS.n0 0.504071
R72 VSS.n9 VSS.n0 0.395524
R73 a_615_n3098.t0 a_615_n3098.n0 92.7554
R74 a_615_n3098.n0 a_615_n3098.t1 93.1112
R75 a_615_n3098.n0 a_615_n3098.t2 93.2589
.ends
