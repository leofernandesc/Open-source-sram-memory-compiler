* NGSPICE file created from sense_amp_scale1p5_flat.ext - technology: sky130A

.subckt sense_amp_scale1p5_flat VDD VSS BL BLB SCLK SA_OUT SA_OUTB
X0 a_615_n3098.n0 SA_OUT SA_OUTB VSS sky130_fd_pr__nfet_01v8 ad=0.2842 pd=2.54 as=0.2842 ps=2.54 w=0.98 l=0.15
X1 a_615_n3098.n0 SA_OUTB SA_OUT VSS sky130_fd_pr__nfet_01v8 ad=0.2842 pd=2.54 as=0.2842 ps=2.54 w=0.98 l=0.15
X2 BLB SCLK SA_OUTB VDD sky130_fd_pr__pfet_01v8 ad=0.58 pd=4.58 as=0.58 ps=4.58 w=2 l=0.15
X3 VSS SCLK a_615_n3098.n0 VSS sky130_fd_pr__nfet_01v8 ad=0.2842 pd=2.54 as=0.2842 ps=2.54 w=0.98 l=0.15
X4 VDD SA_OUTB SA_OUT VDD sky130_fd_pr__pfet_01v8 ad=0.5481 pd=4.36 as=0.5481 ps=4.36 w=1.89 l=0.15
X5 VDD SA_OUT SA_OUTB VDD sky130_fd_pr__pfet_01v8 ad=0.5481 pd=4.36 as=0.5481 ps=4.36 w=1.89 l=0.15
X6 SA_OUT SCLK BL VDD sky130_fd_pr__pfet_01v8 ad=0.58 pd=4.58 as=0.58 ps=4.58 w=2 l=0.15
C0 SA_OUTB BLB 0.16326f
C1 SA_OUTB SA_OUT 2.66022f
C2 SCLK VDD 0.72078f
C3 VDD BL 2.12194f
C4 SCLK BLB 0.38941f
C5 BL BLB 1.83586f
C6 SCLK SA_OUT 1.57224f
C7 BL SA_OUT 0.00366f
C8 SA_OUTB SCLK 1.47766f
C9 SA_OUTB BL 0.32693f
C10 VDD BLB 0.84654f
C11 VDD SA_OUT 1.45657f
C12 SCLK BL 0.32049f
C13 SA_OUT BLB 0.378f
C14 SA_OUTB VDD 1.48642f
C15 BLB VSS 4.01007f
C16 BL VSS 4.61029f
C17 SCLK VSS 2.8954f
C18 SA_OUTB VSS 2.1843f
C19 SA_OUT VSS 2.75812f
C20 VDD VSS 8.01856f
C21 a_615_n3098.n0 VSS 0.03785f $ **FLOATING
C22 a_615_n3098.n0 VSS 0.04078f $ **FLOATING
C23 a_615_n3098.n0 VSS 0.03941f $ **FLOATING
C24 a_615_n3098.n0 VSS 1.28991f $ **FLOATING
C25 VDD VSS 1.04825f $ **FLOATING
C26 VDD VSS 1.04785f $ **FLOATING
C27 VDD VSS 0.75551f $ **FLOATING
C28 VDD VSS 1.0213f $ **FLOATING
C29 VDD VSS 0.35492f $ **FLOATING
C30 VDD VSS 0.07062f $ **FLOATING
C31 VDD VSS 0.38512f $ **FLOATING
C32 VDD VSS 1.0213f $ **FLOATING
C33 VDD VSS 0.33459f $ **FLOATING
C34 VDD VSS 0.07062f $ **FLOATING
C35 VDD VSS 0.39178f $ **FLOATING
C36 SA_OUT VSS 0.23442f $ **FLOATING
C37 SA_OUT VSS 0.09088f $ **FLOATING
C38 SA_OUT VSS 2.54219f $ **FLOATING
C39 SA_OUT VSS 0.20642f $ **FLOATING
C40 SA_OUT VSS 1.64708f $ **FLOATING
C41 SA_OUT VSS 0.07945f $ **FLOATING
C42 SA_OUT VSS 0.60658f $ **FLOATING
C43 SA_OUT VSS 0.11778f $ **FLOATING
C44 SA_OUT VSS 1.51904f $ **FLOATING
C45 SA_OUTB VSS 0.21215f $ **FLOATING
C46 SA_OUTB VSS 0.08777f $ **FLOATING
C47 SA_OUTB VSS 2.25731f $ **FLOATING
C48 SA_OUTB VSS 0.11744f $ **FLOATING
C49 SA_OUTB VSS 1.17847f $ **FLOATING
C50 SA_OUTB VSS 0.12386f $ **FLOATING
C51 SA_OUTB VSS 1.11197f $ **FLOATING
C52 SA_OUTB VSS 0.19262f $ **FLOATING
C53 SA_OUTB VSS 1.04607f $ **FLOATING
C54 SCLK VSS 0.10791f $ **FLOATING
C55 SCLK VSS 0.07407f $ **FLOATING
C56 SCLK VSS 2.00064f $ **FLOATING
C57 SCLK VSS 0.10719f $ **FLOATING
C58 SCLK VSS 1.67222f $ **FLOATING
C59 BL VSS 0.32411f $ **FLOATING
C60 BLB VSS 0.26258f $ **FLOATING
.ends
