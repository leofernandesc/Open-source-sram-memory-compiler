* NGSPICE file created from precharge_w2p52_flat.ext - technology: sky130A

.subckt precharge_w2p52_flat VDD BL BLB PRECH VSS
X0 BLB.t1 PRECH.t0 BL.t0 VDD.t4 sky130_fd_pr__pfet_01v8 ad=0.7308 pd=5.62 as=0.7308 ps=5.62 w=2.52 l=0.15
X1 VDD.t1 PRECH.t2 BL.t1 VDD.t0 sky130_fd_pr__pfet_01v8 ad=0.7308 pd=5.62 as=0.7308 ps=5.62 w=2.52 l=0.15
X2 VDD.t3 PRECH.t1 BLB.t0 VDD.t2 sky130_fd_pr__pfet_01v8 ad=0.7308 pd=5.62 as=0.7308 ps=5.62 w=2.52 l=0.15
C0 BLB BL 2.34166f
C1 BLB VDD 1.05917f
C2 VDD BL 1.15615f
C3 BLB PRECH 0.17291f
C4 BL PRECH 0.4247f
C5 VDD PRECH 3.19177f
R0 BLB.n0 BLB.t1 105.877
R1 BLB.n0 BLB.t0 105.281
R2 BLB BLB.n0 0.684798
R3 BL.n0 BL.t0 105.954
R4 BL.n0 BL.t1 105.058
R5 BL BL.n0 0.237179
R6 PRECH.n0 PRECH.t0 648.718
R7 PRECH.n1 PRECH.t2 648.271
R8 PRECH.n0 PRECH.t1 648.271
R9 PRECH.n1 PRECH.n0 0.448119
R10 PRECH PRECH.n1 0.311036
R11 VDD.n0 VDD.t4 189.672
R12 VDD.n2 VDD.t0 189.224
R13 VDD.n0 VDD.t2 189.224
R14 VDD.n3 VDD.t1 105.356
R15 VDD.n1 VDD.t3 105.356
R16 VDD VDD.n3 0.384893
R17 VDD.n2 VDD.n1 0.342929
R18 VDD.n1 VDD.n0 0.10569
R19 VDD.n3 VDD.n2 0.10569
C6 BLB VSS 2.33527f
C7 BL VSS 1.00114f
C8 PRECH VSS 1.13141f
C9 VDD VSS 6.82691f
C10 VDD.t4 VSS 1.10339f $ **FLOATING
C11 VDD.t2 VSS 1.10247f $ **FLOATING
C12 VDD.n0 VSS 0.7137f $ **FLOATING
C13 VDD.t3 VSS 0.09098f $ **FLOATING
C14 VDD.n1 VSS 0.38433f $ **FLOATING
C15 VDD.t0 VSS 1.10247f $ **FLOATING
C16 VDD.n2 VSS 0.3034f $ **FLOATING
C17 VDD.t1 VSS 0.09098f $ **FLOATING
C18 VDD.n3 VSS 0.39286f $ **FLOATING
C19 PRECH.t0 VSS 0.16091f $ **FLOATING
C20 PRECH.t1 VSS 0.16011f $ **FLOATING
C21 PRECH.n0 VSS 2.10226f $ **FLOATING
C22 PRECH.t2 VSS 0.16011f $ **FLOATING
C23 PRECH.n1 VSS 0.84109f $ **FLOATING
C24 BL.t0 VSS 0.26889f $ **FLOATING
C25 BL.t1 VSS 0.25387f $ **FLOATING
C26 BL.n0 VSS 3.13527f $ **FLOATING
C27 BLB.t1 VSS 0.23187f $ **FLOATING
C28 BLB.t0 VSS 0.22443f $ **FLOATING
C29 BLB.n0 VSS 2.66202f $ **FLOATING
.ends
