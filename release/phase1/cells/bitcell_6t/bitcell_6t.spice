* Xschem-derived canonical electrical leaf; standalone stimuli omitted.
.subckt bitcell_6t VDD BL BLB VSS WL
XMPL Q QB VDD VDD sky130_fd_pr__pfet_01v8 L=0.15 W=0.42 nf=1 ad='W * 0.29' as='W * 0.29' pd='W + 2 * 0.29' ps='W + 2 * 0.29' nrd=0 nrs=0 sa=0 sb=0 sd=0 mult=1 m=1
XMNL Q QB VSS VSS sky130_fd_pr__nfet_01v8 L=0.15 W=1.26 nf=1 ad='W * 0.29' as='W * 0.29' pd='W + 2 * 0.29' ps='W + 2 * 0.29' nrd=0 nrs=0 sa=0 sb=0 sd=0 mult=1 m=1
XMPR QB Q VDD VDD sky130_fd_pr__pfet_01v8 L=0.15 W=0.42 nf=1 ad='W * 0.29' as='W * 0.29' pd='W + 2 * 0.29' ps='W + 2 * 0.29' nrd=0 nrs=0 sa=0 sb=0 sd=0 mult=1 m=1
XMNR QB Q VSS VSS sky130_fd_pr__nfet_01v8 L=0.15 W=1.26 nf=1 ad='W * 0.29' as='W * 0.29' pd='W + 2 * 0.29' ps='W + 2 * 0.29' nrd=0 nrs=0 sa=0 sb=0 sd=0 mult=1 m=1
XMAL Q WL BL VSS sky130_fd_pr__nfet_01v8 L=0.15 W=0.60 nf=1 ad='W * 0.29' as='W * 0.29' pd='W + 2 * 0.29' ps='W + 2 * 0.29' nrd=0 nrs=0 sa=0 sb=0 sd=0 mult=1 m=1
XMAR BLB WL QB VSS sky130_fd_pr__nfet_01v8 L=0.15 W=0.60 nf=1 ad='W * 0.29' as='W * 0.29' pd='W + 2 * 0.29' ps='W + 2 * 0.29' nrd=0 nrs=0 sa=0 sb=0 sd=0 mult=1 m=1
.ends bitcell_6t
