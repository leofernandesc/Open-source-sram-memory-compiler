.model sky130_fd_pr__nfet_01v8 nmos
.model sky130_fd_pr__pfet_01v8 pmos
.subckt g7_column BL BLB VSS VDD WLOFF PRECH SCLK WE DATA_B DATA
M0 a_617_40688# WLOFF BLB VSS sky130_fd_pr__nfet_01v8 w=0.6u l=0.15u
M1 a_617_6212# WLOFF BLB VSS sky130_fd_pr__nfet_01v8 w=0.6u l=0.15u
M2 a_665_48732# a_617_48644# VDD VDD sky130_fd_pr__pfet_01v8 w=0.42u l=0.15u
M3 a_617_908# a_665_996# VSS VSS sky130_fd_pr__nfet_01v8 w=1.26u l=0.15u
M4 a_665_46080# a_617_45992# VDD VDD sky130_fd_pr__pfet_01v8 w=0.42u l=0.15u
M5 a_3077_n9274# DATA BLB VDD sky130_fd_pr__pfet_01v8 w=5.04u l=0.15u
M6 a_665_77904# WLOFF BL VSS sky130_fd_pr__nfet_01v8 w=0.6u l=0.15u
M7 a_617_67208# WLOFF BLB VSS sky130_fd_pr__nfet_01v8 w=0.6u l=0.15u
M8 a_1065_n6268# sense_amp_scale1p5_flat_0.SA_OUT sense_amp_scale1p5_flat_0.SA_OUTB VSS sky130_fd_pr__nfet_01v8 w=0.98u l=0.15u
M9 VDD PRECH BLB VDD sky130_fd_pr__pfet_01v8 w=2.52u l=0.15u
M10 a_617_8864# WLOFF BLB VSS sky130_fd_pr__nfet_01v8 w=0.6u l=0.15u
M11 a_617_11516# a_665_11604# VDD VDD sky130_fd_pr__pfet_01v8 w=0.42u l=0.15u
M12 a_665_51384# WLOFF BL VSS sky130_fd_pr__nfet_01v8 w=0.6u l=0.15u
M13 a_617_3560# a_665_3648# VSS VSS sky130_fd_pr__nfet_01v8 w=1.26u l=0.15u
M14 a_665_51384# a_617_51296# VSS VSS sky130_fd_pr__nfet_01v8 w=1.26u l=0.15u
M15 a_617_77816# a_665_77904# VSS VSS sky130_fd_pr__nfet_01v8 w=1.26u l=0.15u
M16 a_665_54036# WLOFF BL VSS sky130_fd_pr__nfet_01v8 w=0.6u l=0.15u
M17 a_665_8952# a_617_8864# VSS VSS sky130_fd_pr__nfet_01v8 w=1.26u l=0.15u
M18 a_617_27428# WLOFF BLB VSS sky130_fd_pr__nfet_01v8 w=0.6u l=0.15u
M19 a_617_75164# a_665_75252# VSS VSS sky130_fd_pr__nfet_01v8 w=1.26u l=0.15u
M20 a_617_59252# a_665_59340# VDD VDD sky130_fd_pr__pfet_01v8 w=0.42u l=0.15u
M21 a_665_54036# a_617_53948# VSS VSS sky130_fd_pr__nfet_01v8 w=1.26u l=0.15u
M22 VSS SCLK a_1065_n6268# VSS sky130_fd_pr__nfet_01v8 w=0.98u l=0.15u
M23 a_617_8864# a_665_8952# VDD VDD sky130_fd_pr__pfet_01v8 w=0.42u l=0.15u
M24 a_665_11604# WLOFF BL VSS sky130_fd_pr__nfet_01v8 w=0.6u l=0.15u
M25 a_617_83120# a_665_83208# VDD VDD sky130_fd_pr__pfet_01v8 w=0.42u l=0.15u
M26 a_665_6300# WLOFF BL VSS sky130_fd_pr__nfet_01v8 w=0.6u l=0.15u
M27 a_617_6212# a_665_6300# VDD VDD sky130_fd_pr__pfet_01v8 w=0.42u l=0.15u
M28 a_665_61992# WLOFF BL VSS sky130_fd_pr__nfet_01v8 w=0.6u l=0.15u
M29 a_665_38124# WLOFF BL VSS sky130_fd_pr__nfet_01v8 w=0.6u l=0.15u
M30 a_665_14256# WLOFF BL VSS sky130_fd_pr__nfet_01v8 w=0.6u l=0.15u
M31 a_665_54036# a_617_53948# VDD VDD sky130_fd_pr__pfet_01v8 w=0.42u l=0.15u
M32 a_665_16908# a_617_16820# VSS VSS sky130_fd_pr__nfet_01v8 w=1.26u l=0.15u
M33 VDD WE a_677_n8854# VDD sky130_fd_pr__pfet_01v8 w=0.84u l=0.15u
M34 a_665_8952# WLOFF BL VSS sky130_fd_pr__nfet_01v8 w=0.6u l=0.15u
M35 a_617_11516# a_665_11604# VSS VSS sky130_fd_pr__nfet_01v8 w=1.26u l=0.15u
M36 a_665_61992# a_617_61904# VDD VDD sky130_fd_pr__pfet_01v8 w=0.42u l=0.15u
M37 a_617_35384# a_665_35472# VSS VSS sky130_fd_pr__nfet_01v8 w=1.26u l=0.15u
M38 a_665_14256# a_617_14168# VSS VSS sky130_fd_pr__nfet_01v8 w=1.26u l=0.15u
M39 a_617_19472# a_665_19560# VDD VDD sky130_fd_pr__pfet_01v8 w=0.42u l=0.15u
M40 a_617_48644# a_665_48732# VDD VDD sky130_fd_pr__pfet_01v8 w=0.42u l=0.15u
M41 a_665_48732# WLOFF BL VSS sky130_fd_pr__nfet_01v8 w=0.6u l=0.15u
M42 VSS WE a_677_n8854# VSS sky130_fd_pr__nfet_01v8 w=0.84u l=0.15u
M43 a_665_64644# a_617_64556# VDD VDD sky130_fd_pr__pfet_01v8 w=0.42u l=0.15u
M44 a_617_38036# a_665_38124# VSS VSS sky130_fd_pr__nfet_01v8 w=1.26u l=0.15u
M45 BLB PRECH BL VDD sky130_fd_pr__pfet_01v8 w=2.52u l=0.15u
M46 a_617_45992# a_665_46080# VDD VDD sky130_fd_pr__pfet_01v8 w=0.42u l=0.15u
M47 a_665_14256# a_617_14168# VDD VDD sky130_fd_pr__pfet_01v8 w=0.42u l=0.15u
M48 a_665_22212# WLOFF BL VSS sky130_fd_pr__nfet_01v8 w=0.6u l=0.15u
M49 a_1865_n13274# DATA_B BL VSS sky130_fd_pr__nfet_01v8 w=5.04u l=0.15u
M50 a_617_83120# WLOFF BLB VSS sky130_fd_pr__nfet_01v8 w=0.6u l=0.15u
M51 a_665_24864# a_617_24776# VDD VDD sky130_fd_pr__pfet_01v8 w=0.42u l=0.15u
M52 a_665_69948# WLOFF BL VSS sky130_fd_pr__nfet_01v8 w=0.6u l=0.15u
M53 a_665_22212# a_617_22124# VDD VDD sky130_fd_pr__pfet_01v8 w=0.42u l=0.15u
M54 a_665_48732# a_617_48644# VSS VSS sky130_fd_pr__nfet_01v8 w=1.26u l=0.15u
M55 a_617_43340# WLOFF BLB VSS sky130_fd_pr__nfet_01v8 w=0.6u l=0.15u
M56 a_665_69948# a_617_69860# VDD VDD sky130_fd_pr__pfet_01v8 w=0.42u l=0.15u
M57 a_665_22212# a_617_22124# VSS VSS sky130_fd_pr__nfet_01v8 w=1.26u l=0.15u
M58 a_665_46080# a_617_45992# VSS VSS sky130_fd_pr__nfet_01v8 w=1.26u l=0.15u
M59 a_665_56688# WLOFF BL VSS sky130_fd_pr__nfet_01v8 w=0.6u l=0.15u
M60 a_617_45992# WLOFF BLB VSS sky130_fd_pr__nfet_01v8 w=0.6u l=0.15u
M61 a_617_53948# a_665_54036# VDD VDD sky130_fd_pr__pfet_01v8 w=0.42u l=0.15u
M62 a_665_30168# WLOFF BL VSS sky130_fd_pr__nfet_01v8 w=0.6u l=0.15u
M63 a_617_61904# a_665_61992# VDD VDD sky130_fd_pr__pfet_01v8 w=0.42u l=0.15u
M64 a_665_59340# WLOFF BL VSS sky130_fd_pr__nfet_01v8 w=0.6u l=0.15u
M65 a_665_56688# a_617_56600# VSS VSS sky130_fd_pr__nfet_01v8 w=1.26u l=0.15u
M66 a_617_51296# a_665_51384# VSS VSS sky130_fd_pr__nfet_01v8 w=1.26u l=0.15u
M67 a_665_30168# a_617_30080# VSS VSS sky130_fd_pr__nfet_01v8 w=1.26u l=0.15u
M68 a_665_16908# WLOFF BL VSS sky130_fd_pr__nfet_01v8 w=0.6u l=0.15u
M69 a_617_64556# a_665_64644# VDD VDD sky130_fd_pr__pfet_01v8 w=0.42u l=0.15u
M70 a_665_32820# a_617_32732# VDD VDD sky130_fd_pr__pfet_01v8 w=0.42u l=0.15u
M71 a_665_56688# a_617_56600# VDD VDD sky130_fd_pr__pfet_01v8 w=0.42u l=0.15u
M72 a_617_53948# a_665_54036# VSS VSS sky130_fd_pr__nfet_01v8 w=1.26u l=0.15u
M73 a_617_77816# WLOFF BLB VSS sky130_fd_pr__nfet_01v8 w=0.6u l=0.15u
M74 a_617_14168# a_665_14256# VDD VDD sky130_fd_pr__pfet_01v8 w=0.42u l=0.15u
M75 a_665_30168# a_617_30080# VDD VDD sky130_fd_pr__pfet_01v8 w=0.42u l=0.15u
M76 a_617_51296# WLOFF BLB VSS sky130_fd_pr__nfet_01v8 w=0.6u l=0.15u
M77 a_617_6212# a_665_6300# VSS VSS sky130_fd_pr__nfet_01v8 w=1.26u l=0.15u
M78 a_665_19560# WLOFF BL VSS sky130_fd_pr__nfet_01v8 w=0.6u l=0.15u
M79 a_617_16820# a_665_16908# VSS VSS sky130_fd_pr__nfet_01v8 w=1.26u l=0.15u
M80 a_665_64644# WLOFF BL VSS sky130_fd_pr__nfet_01v8 w=0.6u l=0.15u
M81 a_665_61992# a_617_61904# VSS VSS sky130_fd_pr__nfet_01v8 w=1.26u l=0.15u
M82 a_617_53948# WLOFF BLB VSS sky130_fd_pr__nfet_01v8 w=0.6u l=0.15u
M83 a_617_24776# a_665_24864# VDD VDD sky130_fd_pr__pfet_01v8 w=0.42u l=0.15u
M84 a_617_14168# a_665_14256# VSS VSS sky130_fd_pr__nfet_01v8 w=1.26u l=0.15u
M85 a_665_16908# a_617_16820# VDD VDD sky130_fd_pr__pfet_01v8 w=0.42u l=0.15u
M86 VDD a_677_n8854# a_1477_n9274# VDD sky130_fd_pr__pfet_01v8 w=5.04u l=0.15u
M87 a_617_22124# a_665_22212# VDD VDD sky130_fd_pr__pfet_01v8 w=0.42u l=0.15u
M88 a_617_11516# WLOFF BLB VSS sky130_fd_pr__nfet_01v8 w=0.6u l=0.15u
M89 a_617_69860# a_665_69948# VDD VDD sky130_fd_pr__pfet_01v8 w=0.42u l=0.15u
M90 a_665_64644# a_617_64556# VSS VSS sky130_fd_pr__nfet_01v8 w=1.26u l=0.15u
M91 VSS WE a_1865_n13274# VSS sky130_fd_pr__nfet_01v8 w=5.04u l=0.15u
M92 a_617_14168# WLOFF BLB VSS sky130_fd_pr__nfet_01v8 w=0.6u l=0.15u
M93 a_665_24864# WLOFF BL VSS sky130_fd_pr__nfet_01v8 w=0.6u l=0.15u
M94 a_665_72600# WLOFF BL VSS sky130_fd_pr__nfet_01v8 w=0.6u l=0.15u
M95 a_617_61904# WLOFF BLB VSS sky130_fd_pr__nfet_01v8 w=0.6u l=0.15u
M96 a_617_38036# WLOFF BLB VSS sky130_fd_pr__nfet_01v8 w=0.6u l=0.15u
M97 a_665_24864# a_617_24776# VSS VSS sky130_fd_pr__nfet_01v8 w=1.26u l=0.15u
M98 a_665_75252# WLOFF BL VSS sky130_fd_pr__nfet_01v8 w=0.6u l=0.15u
M99 a_617_48644# WLOFF BLB VSS sky130_fd_pr__nfet_01v8 w=0.6u l=0.15u
M100 a_617_48644# a_665_48732# VSS VSS sky130_fd_pr__nfet_01v8 w=1.26u l=0.15u
M101 a_617_32732# a_665_32820# VDD VDD sky130_fd_pr__pfet_01v8 w=0.42u l=0.15u
M102 VDD sense_amp_scale1p5_flat_0.SA_OUTB sense_amp_scale1p5_flat_0.SA_OUT VDD sky130_fd_pr__pfet_01v8 w=1.89u l=0.15u
M103 a_665_3648# a_617_3560# VSS VSS sky130_fd_pr__nfet_01v8 w=1.26u l=0.15u
M104 a_617_22124# WLOFF BLB VSS sky130_fd_pr__nfet_01v8 w=0.6u l=0.15u
M105 a_665_27516# a_617_27428# VSS VSS sky130_fd_pr__nfet_01v8 w=1.26u l=0.15u
M106 a_665_32820# WLOFF BL VSS sky130_fd_pr__nfet_01v8 w=0.6u l=0.15u
M107 a_617_56600# a_665_56688# VDD VDD sky130_fd_pr__pfet_01v8 w=0.42u l=0.15u
M108 a_665_996# a_617_908# VDD VDD sky130_fd_pr__pfet_01v8 w=0.42u l=0.15u
M109 a_617_22124# a_665_22212# VSS VSS sky130_fd_pr__nfet_01v8 w=1.26u l=0.15u
M110 a_665_72600# a_617_72512# VDD VDD sky130_fd_pr__pfet_01v8 w=0.42u l=0.15u
M111 a_617_45992# a_665_46080# VSS VSS sky130_fd_pr__nfet_01v8 w=1.26u l=0.15u
M112 a_617_30080# a_665_30168# VDD VDD sky130_fd_pr__pfet_01v8 w=0.42u l=0.15u
M113 a_665_72600# a_617_72512# VSS VSS sky130_fd_pr__nfet_01v8 w=1.26u l=0.15u
M114 a_665_35472# WLOFF BL VSS sky130_fd_pr__nfet_01v8 w=0.6u l=0.15u
M115 a_665_3648# a_617_3560# VDD VDD sky130_fd_pr__pfet_01v8 w=0.42u l=0.15u
M116 a_665_27516# a_617_27428# VDD VDD sky130_fd_pr__pfet_01v8 w=0.42u l=0.15u
M117 a_665_75252# a_617_75164# VDD VDD sky130_fd_pr__pfet_01v8 w=0.42u l=0.15u
M118 a_617_56600# a_665_56688# VSS VSS sky130_fd_pr__nfet_01v8 w=1.26u l=0.15u
M119 a_665_80556# WLOFF BL VSS sky130_fd_pr__nfet_01v8 w=0.6u l=0.15u
M120 a_617_69860# WLOFF BLB VSS sky130_fd_pr__nfet_01v8 w=0.6u l=0.15u
M121 a_1477_n9274# DATA_B BL VDD sky130_fd_pr__pfet_01v8 w=5.04u l=0.15u
M122 a_617_16820# a_665_16908# VDD VDD sky130_fd_pr__pfet_01v8 w=0.42u l=0.15u
M123 a_617_8864# a_665_8952# VSS VSS sky130_fd_pr__nfet_01v8 w=1.26u l=0.15u
M124 a_617_30080# a_665_30168# VSS VSS sky130_fd_pr__nfet_01v8 w=1.26u l=0.15u
M125 VDD sense_amp_scale1p5_flat_0.SA_OUT sense_amp_scale1p5_flat_0.SA_OUTB VDD sky130_fd_pr__pfet_01v8 w=1.89u l=0.15u
M126 a_665_32820# a_617_32732# VSS VSS sky130_fd_pr__nfet_01v8 w=1.26u l=0.15u
M127 a_665_80556# a_617_80468# VSS VSS sky130_fd_pr__nfet_01v8 w=1.26u l=0.15u
M128 a_665_35472# a_617_35384# VDD VDD sky130_fd_pr__pfet_01v8 w=0.42u l=0.15u
M129 a_617_56600# WLOFF BLB VSS sky130_fd_pr__nfet_01v8 w=0.6u l=0.15u
M130 a_665_40776# WLOFF BL VSS sky130_fd_pr__nfet_01v8 w=0.6u l=0.15u
M131 a_617_30080# WLOFF BLB VSS sky130_fd_pr__nfet_01v8 w=0.6u l=0.15u
M132 a_665_83208# a_617_83120# VSS VSS sky130_fd_pr__nfet_01v8 w=1.26u l=0.15u
M133 a_665_59340# a_617_59252# VSS VSS sky130_fd_pr__nfet_01v8 w=1.26u l=0.15u
M134 a_665_80556# a_617_80468# VDD VDD sky130_fd_pr__pfet_01v8 w=0.42u l=0.15u
M135 a_665_38124# a_617_38036# VDD VDD sky130_fd_pr__pfet_01v8 w=0.42u l=0.15u
M136 a_617_59252# WLOFF BLB VSS sky130_fd_pr__nfet_01v8 w=0.6u l=0.15u
M137 a_617_61904# a_665_61992# VSS VSS sky130_fd_pr__nfet_01v8 w=1.26u l=0.15u
M138 a_665_40776# a_617_40688# VSS VSS sky130_fd_pr__nfet_01v8 w=1.26u l=0.15u
M139 a_665_67296# WLOFF BL VSS sky130_fd_pr__nfet_01v8 w=0.6u l=0.15u
M140 a_665_69948# a_617_69860# VSS VSS sky130_fd_pr__nfet_01v8 w=1.26u l=0.15u
M141 a_617_16820# WLOFF BLB VSS sky130_fd_pr__nfet_01v8 w=0.6u l=0.15u
M142 a_3465_n13274# DATA BLB VSS sky130_fd_pr__nfet_01v8 w=5.04u l=0.15u
M143 a_617_64556# a_665_64644# VSS VSS sky130_fd_pr__nfet_01v8 w=1.26u l=0.15u
M144 a_665_43428# a_617_43340# VSS VSS sky130_fd_pr__nfet_01v8 w=1.26u l=0.15u
M145 a_665_19560# a_617_19472# VSS VSS sky130_fd_pr__nfet_01v8 w=1.26u l=0.15u
M146 a_617_72512# a_665_72600# VDD VDD sky130_fd_pr__pfet_01v8 w=0.42u l=0.15u
M147 a_665_67296# a_617_67208# VSS VSS sky130_fd_pr__nfet_01v8 w=1.26u l=0.15u
M148 a_665_40776# a_617_40688# VDD VDD sky130_fd_pr__pfet_01v8 w=0.42u l=0.15u
M149 a_665_996# a_617_908# VSS VSS sky130_fd_pr__nfet_01v8 w=1.26u l=0.15u
M150 a_617_3560# WLOFF BLB VSS sky130_fd_pr__nfet_01v8 w=0.6u l=0.15u
M151 a_617_19472# WLOFF BLB VSS sky130_fd_pr__nfet_01v8 w=0.6u l=0.15u
M152 a_617_908# WLOFF BLB VSS sky130_fd_pr__nfet_01v8 w=0.6u l=0.15u
M153 a_665_27516# WLOFF BL VSS sky130_fd_pr__nfet_01v8 w=0.6u l=0.15u
M154 a_617_27428# a_665_27516# VDD VDD sky130_fd_pr__pfet_01v8 w=0.42u l=0.15u
M155 a_617_75164# a_665_75252# VDD VDD sky130_fd_pr__pfet_01v8 w=0.42u l=0.15u
M156 a_665_43428# a_617_43340# VDD VDD sky130_fd_pr__pfet_01v8 w=0.42u l=0.15u
M157 VDD a_677_n8854# a_3077_n9274# VDD sky130_fd_pr__pfet_01v8 w=5.04u l=0.15u
M158 a_665_67296# a_617_67208# VDD VDD sky130_fd_pr__pfet_01v8 w=0.42u l=0.15u
M159 a_617_64556# WLOFF BLB VSS sky130_fd_pr__nfet_01v8 w=0.6u l=0.15u
M160 a_617_24776# a_665_24864# VSS VSS sky130_fd_pr__nfet_01v8 w=1.26u l=0.15u
M161 a_665_77904# a_617_77816# VDD VDD sky130_fd_pr__pfet_01v8 w=0.42u l=0.15u
M162 a_617_27428# a_665_27516# VSS VSS sky130_fd_pr__nfet_01v8 w=1.26u l=0.15u
M163 a_617_35384# a_665_35472# VDD VDD sky130_fd_pr__pfet_01v8 w=0.42u l=0.15u
M164 sense_amp_scale1p5_flat_0.SA_OUT SCLK BL VDD sky130_fd_pr__pfet_01v8 w=2u l=0.15u
M165 a_665_77904# a_617_77816# VSS VSS sky130_fd_pr__nfet_01v8 w=1.26u l=0.15u
M166 a_665_51384# a_617_51296# VDD VDD sky130_fd_pr__pfet_01v8 w=0.42u l=0.15u
M167 a_617_908# a_665_996# VDD VDD sky130_fd_pr__pfet_01v8 w=0.42u l=0.15u
M168 a_617_24776# WLOFF BLB VSS sky130_fd_pr__nfet_01v8 w=0.6u l=0.15u
M169 a_617_72512# WLOFF BLB VSS sky130_fd_pr__nfet_01v8 w=0.6u l=0.15u
M170 a_617_72512# a_665_72600# VSS VSS sky130_fd_pr__nfet_01v8 w=1.26u l=0.15u
M171 a_665_8952# a_617_8864# VDD VDD sky130_fd_pr__pfet_01v8 w=0.42u l=0.15u
M172 a_617_80468# a_665_80556# VDD VDD sky130_fd_pr__pfet_01v8 w=0.42u l=0.15u
M173 a_665_75252# a_617_75164# VSS VSS sky130_fd_pr__nfet_01v8 w=1.26u l=0.15u
M174 a_617_38036# a_665_38124# VDD VDD sky130_fd_pr__pfet_01v8 w=0.42u l=0.15u
M175 a_665_3648# WLOFF BL VSS sky130_fd_pr__nfet_01v8 w=0.6u l=0.15u
M176 a_617_3560# a_665_3648# VDD VDD sky130_fd_pr__pfet_01v8 w=0.42u l=0.15u
M177 a_665_6300# a_617_6212# VDD VDD sky130_fd_pr__pfet_01v8 w=0.42u l=0.15u
M178 a_617_75164# WLOFF BLB VSS sky130_fd_pr__nfet_01v8 w=0.6u l=0.15u
M179 a_1065_n6268# sense_amp_scale1p5_flat_0.SA_OUTB sense_amp_scale1p5_flat_0.SA_OUT VSS sky130_fd_pr__nfet_01v8 w=0.98u l=0.15u
M180 a_665_996# WLOFF BL VSS sky130_fd_pr__nfet_01v8 w=0.6u l=0.15u
M181 a_665_83208# WLOFF BL VSS sky130_fd_pr__nfet_01v8 w=0.6u l=0.15u
M182 a_665_6300# a_617_6212# VSS VSS sky130_fd_pr__nfet_01v8 w=1.26u l=0.15u
M183 a_665_11604# a_617_11516# VDD VDD sky130_fd_pr__pfet_01v8 w=0.42u l=0.15u
M184 a_617_32732# WLOFF BLB VSS sky130_fd_pr__nfet_01v8 w=0.6u l=0.15u
M185 a_665_11604# a_617_11516# VSS VSS sky130_fd_pr__nfet_01v8 w=1.26u l=0.15u
M186 a_617_32732# a_665_32820# VSS VSS sky130_fd_pr__nfet_01v8 w=1.26u l=0.15u
M187 a_617_80468# a_665_80556# VSS VSS sky130_fd_pr__nfet_01v8 w=1.26u l=0.15u
M188 a_617_40688# a_665_40776# VDD VDD sky130_fd_pr__pfet_01v8 w=0.42u l=0.15u
M189 a_665_35472# a_617_35384# VSS VSS sky130_fd_pr__nfet_01v8 w=1.26u l=0.15u
M190 a_617_35384# WLOFF BLB VSS sky130_fd_pr__nfet_01v8 w=0.6u l=0.15u
M191 a_617_83120# a_665_83208# VSS VSS sky130_fd_pr__nfet_01v8 w=1.26u l=0.15u
M192 a_617_59252# a_665_59340# VSS VSS sky130_fd_pr__nfet_01v8 w=1.26u l=0.15u
M193 a_617_43340# a_665_43428# VDD VDD sky130_fd_pr__pfet_01v8 w=0.42u l=0.15u
M194 a_665_43428# WLOFF BL VSS sky130_fd_pr__nfet_01v8 w=0.6u l=0.15u
M195 a_665_38124# a_617_38036# VSS VSS sky130_fd_pr__nfet_01v8 w=1.26u l=0.15u
M196 a_617_67208# a_665_67296# VDD VDD sky130_fd_pr__pfet_01v8 w=0.42u l=0.15u
M197 a_665_59340# a_617_59252# VDD VDD sky130_fd_pr__pfet_01v8 w=0.42u l=0.15u
M198 a_665_83208# a_617_83120# VDD VDD sky130_fd_pr__pfet_01v8 w=0.42u l=0.15u
M199 a_617_80468# WLOFF BLB VSS sky130_fd_pr__nfet_01v8 w=0.6u l=0.15u
M200 a_617_40688# a_665_40776# VSS VSS sky130_fd_pr__nfet_01v8 w=1.26u l=0.15u
M201 VDD PRECH BL VDD sky130_fd_pr__pfet_01v8 w=2.52u l=0.15u
M202 a_665_46080# WLOFF BL VSS sky130_fd_pr__nfet_01v8 w=0.6u l=0.15u
M203 VSS WE a_3465_n13274# VSS sky130_fd_pr__nfet_01v8 w=5.04u l=0.15u
M204 a_617_69860# a_665_69948# VSS VSS sky130_fd_pr__nfet_01v8 w=1.26u l=0.15u
M205 BLB SCLK sense_amp_scale1p5_flat_0.SA_OUTB VDD sky130_fd_pr__pfet_01v8 w=2u l=0.15u
M206 a_617_77816# a_665_77904# VDD VDD sky130_fd_pr__pfet_01v8 w=0.42u l=0.15u
M207 a_617_43340# a_665_43428# VSS VSS sky130_fd_pr__nfet_01v8 w=1.26u l=0.15u
M208 a_617_19472# a_665_19560# VSS VSS sky130_fd_pr__nfet_01v8 w=1.26u l=0.15u
M209 a_617_67208# a_665_67296# VSS VSS sky130_fd_pr__nfet_01v8 w=1.26u l=0.15u
M210 a_617_51296# a_665_51384# VDD VDD sky130_fd_pr__pfet_01v8 w=0.42u l=0.15u
M211 a_665_19560# a_617_19472# VDD VDD sky130_fd_pr__pfet_01v8 w=0.42u l=0.15u
.ends g7_column
