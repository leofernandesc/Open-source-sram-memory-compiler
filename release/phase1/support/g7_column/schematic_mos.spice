.model sky130_fd_pr__nfet_01v8 nmos
.model sky130_fd_pr__pfet_01v8 pmos
.subckt g7_column BL BLB VSS VDD WLOFF PRECH SCLK WE DATA_B DATA
MBC00_XMPL XBC00/Q XBC00/QB VDD VDD sky130_fd_pr__pfet_01v8 w=0.42u l=0.15u
MBC00_XMNL XBC00/Q XBC00/QB VSS VSS sky130_fd_pr__nfet_01v8 w=1.26u l=0.15u
MBC00_XMPR XBC00/QB XBC00/Q VDD VDD sky130_fd_pr__pfet_01v8 w=0.42u l=0.15u
MBC00_XMNR XBC00/QB XBC00/Q VSS VSS sky130_fd_pr__nfet_01v8 w=1.26u l=0.15u
MBC00_XMAL XBC00/Q WLOFF BL VSS sky130_fd_pr__nfet_01v8 w=0.6u l=0.15u
MBC00_XMAR BLB WLOFF XBC00/QB VSS sky130_fd_pr__nfet_01v8 w=0.6u l=0.15u
MBC01_XMPL XBC01/Q XBC01/QB VDD VDD sky130_fd_pr__pfet_01v8 w=0.42u l=0.15u
MBC01_XMNL XBC01/Q XBC01/QB VSS VSS sky130_fd_pr__nfet_01v8 w=1.26u l=0.15u
MBC01_XMPR XBC01/QB XBC01/Q VDD VDD sky130_fd_pr__pfet_01v8 w=0.42u l=0.15u
MBC01_XMNR XBC01/QB XBC01/Q VSS VSS sky130_fd_pr__nfet_01v8 w=1.26u l=0.15u
MBC01_XMAL XBC01/Q WLOFF BL VSS sky130_fd_pr__nfet_01v8 w=0.6u l=0.15u
MBC01_XMAR BLB WLOFF XBC01/QB VSS sky130_fd_pr__nfet_01v8 w=0.6u l=0.15u
MBC02_XMPL XBC02/Q XBC02/QB VDD VDD sky130_fd_pr__pfet_01v8 w=0.42u l=0.15u
MBC02_XMNL XBC02/Q XBC02/QB VSS VSS sky130_fd_pr__nfet_01v8 w=1.26u l=0.15u
MBC02_XMPR XBC02/QB XBC02/Q VDD VDD sky130_fd_pr__pfet_01v8 w=0.42u l=0.15u
MBC02_XMNR XBC02/QB XBC02/Q VSS VSS sky130_fd_pr__nfet_01v8 w=1.26u l=0.15u
MBC02_XMAL XBC02/Q WLOFF BL VSS sky130_fd_pr__nfet_01v8 w=0.6u l=0.15u
MBC02_XMAR BLB WLOFF XBC02/QB VSS sky130_fd_pr__nfet_01v8 w=0.6u l=0.15u
MBC03_XMPL XBC03/Q XBC03/QB VDD VDD sky130_fd_pr__pfet_01v8 w=0.42u l=0.15u
MBC03_XMNL XBC03/Q XBC03/QB VSS VSS sky130_fd_pr__nfet_01v8 w=1.26u l=0.15u
MBC03_XMPR XBC03/QB XBC03/Q VDD VDD sky130_fd_pr__pfet_01v8 w=0.42u l=0.15u
MBC03_XMNR XBC03/QB XBC03/Q VSS VSS sky130_fd_pr__nfet_01v8 w=1.26u l=0.15u
MBC03_XMAL XBC03/Q WLOFF BL VSS sky130_fd_pr__nfet_01v8 w=0.6u l=0.15u
MBC03_XMAR BLB WLOFF XBC03/QB VSS sky130_fd_pr__nfet_01v8 w=0.6u l=0.15u
MBC04_XMPL XBC04/Q XBC04/QB VDD VDD sky130_fd_pr__pfet_01v8 w=0.42u l=0.15u
MBC04_XMNL XBC04/Q XBC04/QB VSS VSS sky130_fd_pr__nfet_01v8 w=1.26u l=0.15u
MBC04_XMPR XBC04/QB XBC04/Q VDD VDD sky130_fd_pr__pfet_01v8 w=0.42u l=0.15u
MBC04_XMNR XBC04/QB XBC04/Q VSS VSS sky130_fd_pr__nfet_01v8 w=1.26u l=0.15u
MBC04_XMAL XBC04/Q WLOFF BL VSS sky130_fd_pr__nfet_01v8 w=0.6u l=0.15u
MBC04_XMAR BLB WLOFF XBC04/QB VSS sky130_fd_pr__nfet_01v8 w=0.6u l=0.15u
MBC05_XMPL XBC05/Q XBC05/QB VDD VDD sky130_fd_pr__pfet_01v8 w=0.42u l=0.15u
MBC05_XMNL XBC05/Q XBC05/QB VSS VSS sky130_fd_pr__nfet_01v8 w=1.26u l=0.15u
MBC05_XMPR XBC05/QB XBC05/Q VDD VDD sky130_fd_pr__pfet_01v8 w=0.42u l=0.15u
MBC05_XMNR XBC05/QB XBC05/Q VSS VSS sky130_fd_pr__nfet_01v8 w=1.26u l=0.15u
MBC05_XMAL XBC05/Q WLOFF BL VSS sky130_fd_pr__nfet_01v8 w=0.6u l=0.15u
MBC05_XMAR BLB WLOFF XBC05/QB VSS sky130_fd_pr__nfet_01v8 w=0.6u l=0.15u
MBC06_XMPL XBC06/Q XBC06/QB VDD VDD sky130_fd_pr__pfet_01v8 w=0.42u l=0.15u
MBC06_XMNL XBC06/Q XBC06/QB VSS VSS sky130_fd_pr__nfet_01v8 w=1.26u l=0.15u
MBC06_XMPR XBC06/QB XBC06/Q VDD VDD sky130_fd_pr__pfet_01v8 w=0.42u l=0.15u
MBC06_XMNR XBC06/QB XBC06/Q VSS VSS sky130_fd_pr__nfet_01v8 w=1.26u l=0.15u
MBC06_XMAL XBC06/Q WLOFF BL VSS sky130_fd_pr__nfet_01v8 w=0.6u l=0.15u
MBC06_XMAR BLB WLOFF XBC06/QB VSS sky130_fd_pr__nfet_01v8 w=0.6u l=0.15u
MBC07_XMPL XBC07/Q XBC07/QB VDD VDD sky130_fd_pr__pfet_01v8 w=0.42u l=0.15u
MBC07_XMNL XBC07/Q XBC07/QB VSS VSS sky130_fd_pr__nfet_01v8 w=1.26u l=0.15u
MBC07_XMPR XBC07/QB XBC07/Q VDD VDD sky130_fd_pr__pfet_01v8 w=0.42u l=0.15u
MBC07_XMNR XBC07/QB XBC07/Q VSS VSS sky130_fd_pr__nfet_01v8 w=1.26u l=0.15u
MBC07_XMAL XBC07/Q WLOFF BL VSS sky130_fd_pr__nfet_01v8 w=0.6u l=0.15u
MBC07_XMAR BLB WLOFF XBC07/QB VSS sky130_fd_pr__nfet_01v8 w=0.6u l=0.15u
MBC08_XMPL XBC08/Q XBC08/QB VDD VDD sky130_fd_pr__pfet_01v8 w=0.42u l=0.15u
MBC08_XMNL XBC08/Q XBC08/QB VSS VSS sky130_fd_pr__nfet_01v8 w=1.26u l=0.15u
MBC08_XMPR XBC08/QB XBC08/Q VDD VDD sky130_fd_pr__pfet_01v8 w=0.42u l=0.15u
MBC08_XMNR XBC08/QB XBC08/Q VSS VSS sky130_fd_pr__nfet_01v8 w=1.26u l=0.15u
MBC08_XMAL XBC08/Q WLOFF BL VSS sky130_fd_pr__nfet_01v8 w=0.6u l=0.15u
MBC08_XMAR BLB WLOFF XBC08/QB VSS sky130_fd_pr__nfet_01v8 w=0.6u l=0.15u
MBC09_XMPL XBC09/Q XBC09/QB VDD VDD sky130_fd_pr__pfet_01v8 w=0.42u l=0.15u
MBC09_XMNL XBC09/Q XBC09/QB VSS VSS sky130_fd_pr__nfet_01v8 w=1.26u l=0.15u
MBC09_XMPR XBC09/QB XBC09/Q VDD VDD sky130_fd_pr__pfet_01v8 w=0.42u l=0.15u
MBC09_XMNR XBC09/QB XBC09/Q VSS VSS sky130_fd_pr__nfet_01v8 w=1.26u l=0.15u
MBC09_XMAL XBC09/Q WLOFF BL VSS sky130_fd_pr__nfet_01v8 w=0.6u l=0.15u
MBC09_XMAR BLB WLOFF XBC09/QB VSS sky130_fd_pr__nfet_01v8 w=0.6u l=0.15u
MBC10_XMPL XBC10/Q XBC10/QB VDD VDD sky130_fd_pr__pfet_01v8 w=0.42u l=0.15u
MBC10_XMNL XBC10/Q XBC10/QB VSS VSS sky130_fd_pr__nfet_01v8 w=1.26u l=0.15u
MBC10_XMPR XBC10/QB XBC10/Q VDD VDD sky130_fd_pr__pfet_01v8 w=0.42u l=0.15u
MBC10_XMNR XBC10/QB XBC10/Q VSS VSS sky130_fd_pr__nfet_01v8 w=1.26u l=0.15u
MBC10_XMAL XBC10/Q WLOFF BL VSS sky130_fd_pr__nfet_01v8 w=0.6u l=0.15u
MBC10_XMAR BLB WLOFF XBC10/QB VSS sky130_fd_pr__nfet_01v8 w=0.6u l=0.15u
MBC11_XMPL XBC11/Q XBC11/QB VDD VDD sky130_fd_pr__pfet_01v8 w=0.42u l=0.15u
MBC11_XMNL XBC11/Q XBC11/QB VSS VSS sky130_fd_pr__nfet_01v8 w=1.26u l=0.15u
MBC11_XMPR XBC11/QB XBC11/Q VDD VDD sky130_fd_pr__pfet_01v8 w=0.42u l=0.15u
MBC11_XMNR XBC11/QB XBC11/Q VSS VSS sky130_fd_pr__nfet_01v8 w=1.26u l=0.15u
MBC11_XMAL XBC11/Q WLOFF BL VSS sky130_fd_pr__nfet_01v8 w=0.6u l=0.15u
MBC11_XMAR BLB WLOFF XBC11/QB VSS sky130_fd_pr__nfet_01v8 w=0.6u l=0.15u
MBC12_XMPL XBC12/Q XBC12/QB VDD VDD sky130_fd_pr__pfet_01v8 w=0.42u l=0.15u
MBC12_XMNL XBC12/Q XBC12/QB VSS VSS sky130_fd_pr__nfet_01v8 w=1.26u l=0.15u
MBC12_XMPR XBC12/QB XBC12/Q VDD VDD sky130_fd_pr__pfet_01v8 w=0.42u l=0.15u
MBC12_XMNR XBC12/QB XBC12/Q VSS VSS sky130_fd_pr__nfet_01v8 w=1.26u l=0.15u
MBC12_XMAL XBC12/Q WLOFF BL VSS sky130_fd_pr__nfet_01v8 w=0.6u l=0.15u
MBC12_XMAR BLB WLOFF XBC12/QB VSS sky130_fd_pr__nfet_01v8 w=0.6u l=0.15u
MBC13_XMPL XBC13/Q XBC13/QB VDD VDD sky130_fd_pr__pfet_01v8 w=0.42u l=0.15u
MBC13_XMNL XBC13/Q XBC13/QB VSS VSS sky130_fd_pr__nfet_01v8 w=1.26u l=0.15u
MBC13_XMPR XBC13/QB XBC13/Q VDD VDD sky130_fd_pr__pfet_01v8 w=0.42u l=0.15u
MBC13_XMNR XBC13/QB XBC13/Q VSS VSS sky130_fd_pr__nfet_01v8 w=1.26u l=0.15u
MBC13_XMAL XBC13/Q WLOFF BL VSS sky130_fd_pr__nfet_01v8 w=0.6u l=0.15u
MBC13_XMAR BLB WLOFF XBC13/QB VSS sky130_fd_pr__nfet_01v8 w=0.6u l=0.15u
MBC14_XMPL XBC14/Q XBC14/QB VDD VDD sky130_fd_pr__pfet_01v8 w=0.42u l=0.15u
MBC14_XMNL XBC14/Q XBC14/QB VSS VSS sky130_fd_pr__nfet_01v8 w=1.26u l=0.15u
MBC14_XMPR XBC14/QB XBC14/Q VDD VDD sky130_fd_pr__pfet_01v8 w=0.42u l=0.15u
MBC14_XMNR XBC14/QB XBC14/Q VSS VSS sky130_fd_pr__nfet_01v8 w=1.26u l=0.15u
MBC14_XMAL XBC14/Q WLOFF BL VSS sky130_fd_pr__nfet_01v8 w=0.6u l=0.15u
MBC14_XMAR BLB WLOFF XBC14/QB VSS sky130_fd_pr__nfet_01v8 w=0.6u l=0.15u
MBC15_XMPL XBC15/Q XBC15/QB VDD VDD sky130_fd_pr__pfet_01v8 w=0.42u l=0.15u
MBC15_XMNL XBC15/Q XBC15/QB VSS VSS sky130_fd_pr__nfet_01v8 w=1.26u l=0.15u
MBC15_XMPR XBC15/QB XBC15/Q VDD VDD sky130_fd_pr__pfet_01v8 w=0.42u l=0.15u
MBC15_XMNR XBC15/QB XBC15/Q VSS VSS sky130_fd_pr__nfet_01v8 w=1.26u l=0.15u
MBC15_XMAL XBC15/Q WLOFF BL VSS sky130_fd_pr__nfet_01v8 w=0.6u l=0.15u
MBC15_XMAR BLB WLOFF XBC15/QB VSS sky130_fd_pr__nfet_01v8 w=0.6u l=0.15u
MBC16_XMPL XBC16/Q XBC16/QB VDD VDD sky130_fd_pr__pfet_01v8 w=0.42u l=0.15u
MBC16_XMNL XBC16/Q XBC16/QB VSS VSS sky130_fd_pr__nfet_01v8 w=1.26u l=0.15u
MBC16_XMPR XBC16/QB XBC16/Q VDD VDD sky130_fd_pr__pfet_01v8 w=0.42u l=0.15u
MBC16_XMNR XBC16/QB XBC16/Q VSS VSS sky130_fd_pr__nfet_01v8 w=1.26u l=0.15u
MBC16_XMAL XBC16/Q WLOFF BL VSS sky130_fd_pr__nfet_01v8 w=0.6u l=0.15u
MBC16_XMAR BLB WLOFF XBC16/QB VSS sky130_fd_pr__nfet_01v8 w=0.6u l=0.15u
MBC17_XMPL XBC17/Q XBC17/QB VDD VDD sky130_fd_pr__pfet_01v8 w=0.42u l=0.15u
MBC17_XMNL XBC17/Q XBC17/QB VSS VSS sky130_fd_pr__nfet_01v8 w=1.26u l=0.15u
MBC17_XMPR XBC17/QB XBC17/Q VDD VDD sky130_fd_pr__pfet_01v8 w=0.42u l=0.15u
MBC17_XMNR XBC17/QB XBC17/Q VSS VSS sky130_fd_pr__nfet_01v8 w=1.26u l=0.15u
MBC17_XMAL XBC17/Q WLOFF BL VSS sky130_fd_pr__nfet_01v8 w=0.6u l=0.15u
MBC17_XMAR BLB WLOFF XBC17/QB VSS sky130_fd_pr__nfet_01v8 w=0.6u l=0.15u
MBC18_XMPL XBC18/Q XBC18/QB VDD VDD sky130_fd_pr__pfet_01v8 w=0.42u l=0.15u
MBC18_XMNL XBC18/Q XBC18/QB VSS VSS sky130_fd_pr__nfet_01v8 w=1.26u l=0.15u
MBC18_XMPR XBC18/QB XBC18/Q VDD VDD sky130_fd_pr__pfet_01v8 w=0.42u l=0.15u
MBC18_XMNR XBC18/QB XBC18/Q VSS VSS sky130_fd_pr__nfet_01v8 w=1.26u l=0.15u
MBC18_XMAL XBC18/Q WLOFF BL VSS sky130_fd_pr__nfet_01v8 w=0.6u l=0.15u
MBC18_XMAR BLB WLOFF XBC18/QB VSS sky130_fd_pr__nfet_01v8 w=0.6u l=0.15u
MBC19_XMPL XBC19/Q XBC19/QB VDD VDD sky130_fd_pr__pfet_01v8 w=0.42u l=0.15u
MBC19_XMNL XBC19/Q XBC19/QB VSS VSS sky130_fd_pr__nfet_01v8 w=1.26u l=0.15u
MBC19_XMPR XBC19/QB XBC19/Q VDD VDD sky130_fd_pr__pfet_01v8 w=0.42u l=0.15u
MBC19_XMNR XBC19/QB XBC19/Q VSS VSS sky130_fd_pr__nfet_01v8 w=1.26u l=0.15u
MBC19_XMAL XBC19/Q WLOFF BL VSS sky130_fd_pr__nfet_01v8 w=0.6u l=0.15u
MBC19_XMAR BLB WLOFF XBC19/QB VSS sky130_fd_pr__nfet_01v8 w=0.6u l=0.15u
MBC20_XMPL XBC20/Q XBC20/QB VDD VDD sky130_fd_pr__pfet_01v8 w=0.42u l=0.15u
MBC20_XMNL XBC20/Q XBC20/QB VSS VSS sky130_fd_pr__nfet_01v8 w=1.26u l=0.15u
MBC20_XMPR XBC20/QB XBC20/Q VDD VDD sky130_fd_pr__pfet_01v8 w=0.42u l=0.15u
MBC20_XMNR XBC20/QB XBC20/Q VSS VSS sky130_fd_pr__nfet_01v8 w=1.26u l=0.15u
MBC20_XMAL XBC20/Q WLOFF BL VSS sky130_fd_pr__nfet_01v8 w=0.6u l=0.15u
MBC20_XMAR BLB WLOFF XBC20/QB VSS sky130_fd_pr__nfet_01v8 w=0.6u l=0.15u
MBC21_XMPL XBC21/Q XBC21/QB VDD VDD sky130_fd_pr__pfet_01v8 w=0.42u l=0.15u
MBC21_XMNL XBC21/Q XBC21/QB VSS VSS sky130_fd_pr__nfet_01v8 w=1.26u l=0.15u
MBC21_XMPR XBC21/QB XBC21/Q VDD VDD sky130_fd_pr__pfet_01v8 w=0.42u l=0.15u
MBC21_XMNR XBC21/QB XBC21/Q VSS VSS sky130_fd_pr__nfet_01v8 w=1.26u l=0.15u
MBC21_XMAL XBC21/Q WLOFF BL VSS sky130_fd_pr__nfet_01v8 w=0.6u l=0.15u
MBC21_XMAR BLB WLOFF XBC21/QB VSS sky130_fd_pr__nfet_01v8 w=0.6u l=0.15u
MBC22_XMPL XBC22/Q XBC22/QB VDD VDD sky130_fd_pr__pfet_01v8 w=0.42u l=0.15u
MBC22_XMNL XBC22/Q XBC22/QB VSS VSS sky130_fd_pr__nfet_01v8 w=1.26u l=0.15u
MBC22_XMPR XBC22/QB XBC22/Q VDD VDD sky130_fd_pr__pfet_01v8 w=0.42u l=0.15u
MBC22_XMNR XBC22/QB XBC22/Q VSS VSS sky130_fd_pr__nfet_01v8 w=1.26u l=0.15u
MBC22_XMAL XBC22/Q WLOFF BL VSS sky130_fd_pr__nfet_01v8 w=0.6u l=0.15u
MBC22_XMAR BLB WLOFF XBC22/QB VSS sky130_fd_pr__nfet_01v8 w=0.6u l=0.15u
MBC23_XMPL XBC23/Q XBC23/QB VDD VDD sky130_fd_pr__pfet_01v8 w=0.42u l=0.15u
MBC23_XMNL XBC23/Q XBC23/QB VSS VSS sky130_fd_pr__nfet_01v8 w=1.26u l=0.15u
MBC23_XMPR XBC23/QB XBC23/Q VDD VDD sky130_fd_pr__pfet_01v8 w=0.42u l=0.15u
MBC23_XMNR XBC23/QB XBC23/Q VSS VSS sky130_fd_pr__nfet_01v8 w=1.26u l=0.15u
MBC23_XMAL XBC23/Q WLOFF BL VSS sky130_fd_pr__nfet_01v8 w=0.6u l=0.15u
MBC23_XMAR BLB WLOFF XBC23/QB VSS sky130_fd_pr__nfet_01v8 w=0.6u l=0.15u
MBC24_XMPL XBC24/Q XBC24/QB VDD VDD sky130_fd_pr__pfet_01v8 w=0.42u l=0.15u
MBC24_XMNL XBC24/Q XBC24/QB VSS VSS sky130_fd_pr__nfet_01v8 w=1.26u l=0.15u
MBC24_XMPR XBC24/QB XBC24/Q VDD VDD sky130_fd_pr__pfet_01v8 w=0.42u l=0.15u
MBC24_XMNR XBC24/QB XBC24/Q VSS VSS sky130_fd_pr__nfet_01v8 w=1.26u l=0.15u
MBC24_XMAL XBC24/Q WLOFF BL VSS sky130_fd_pr__nfet_01v8 w=0.6u l=0.15u
MBC24_XMAR BLB WLOFF XBC24/QB VSS sky130_fd_pr__nfet_01v8 w=0.6u l=0.15u
MBC25_XMPL XBC25/Q XBC25/QB VDD VDD sky130_fd_pr__pfet_01v8 w=0.42u l=0.15u
MBC25_XMNL XBC25/Q XBC25/QB VSS VSS sky130_fd_pr__nfet_01v8 w=1.26u l=0.15u
MBC25_XMPR XBC25/QB XBC25/Q VDD VDD sky130_fd_pr__pfet_01v8 w=0.42u l=0.15u
MBC25_XMNR XBC25/QB XBC25/Q VSS VSS sky130_fd_pr__nfet_01v8 w=1.26u l=0.15u
MBC25_XMAL XBC25/Q WLOFF BL VSS sky130_fd_pr__nfet_01v8 w=0.6u l=0.15u
MBC25_XMAR BLB WLOFF XBC25/QB VSS sky130_fd_pr__nfet_01v8 w=0.6u l=0.15u
MBC26_XMPL XBC26/Q XBC26/QB VDD VDD sky130_fd_pr__pfet_01v8 w=0.42u l=0.15u
MBC26_XMNL XBC26/Q XBC26/QB VSS VSS sky130_fd_pr__nfet_01v8 w=1.26u l=0.15u
MBC26_XMPR XBC26/QB XBC26/Q VDD VDD sky130_fd_pr__pfet_01v8 w=0.42u l=0.15u
MBC26_XMNR XBC26/QB XBC26/Q VSS VSS sky130_fd_pr__nfet_01v8 w=1.26u l=0.15u
MBC26_XMAL XBC26/Q WLOFF BL VSS sky130_fd_pr__nfet_01v8 w=0.6u l=0.15u
MBC26_XMAR BLB WLOFF XBC26/QB VSS sky130_fd_pr__nfet_01v8 w=0.6u l=0.15u
MBC27_XMPL XBC27/Q XBC27/QB VDD VDD sky130_fd_pr__pfet_01v8 w=0.42u l=0.15u
MBC27_XMNL XBC27/Q XBC27/QB VSS VSS sky130_fd_pr__nfet_01v8 w=1.26u l=0.15u
MBC27_XMPR XBC27/QB XBC27/Q VDD VDD sky130_fd_pr__pfet_01v8 w=0.42u l=0.15u
MBC27_XMNR XBC27/QB XBC27/Q VSS VSS sky130_fd_pr__nfet_01v8 w=1.26u l=0.15u
MBC27_XMAL XBC27/Q WLOFF BL VSS sky130_fd_pr__nfet_01v8 w=0.6u l=0.15u
MBC27_XMAR BLB WLOFF XBC27/QB VSS sky130_fd_pr__nfet_01v8 w=0.6u l=0.15u
MBC28_XMPL XBC28/Q XBC28/QB VDD VDD sky130_fd_pr__pfet_01v8 w=0.42u l=0.15u
MBC28_XMNL XBC28/Q XBC28/QB VSS VSS sky130_fd_pr__nfet_01v8 w=1.26u l=0.15u
MBC28_XMPR XBC28/QB XBC28/Q VDD VDD sky130_fd_pr__pfet_01v8 w=0.42u l=0.15u
MBC28_XMNR XBC28/QB XBC28/Q VSS VSS sky130_fd_pr__nfet_01v8 w=1.26u l=0.15u
MBC28_XMAL XBC28/Q WLOFF BL VSS sky130_fd_pr__nfet_01v8 w=0.6u l=0.15u
MBC28_XMAR BLB WLOFF XBC28/QB VSS sky130_fd_pr__nfet_01v8 w=0.6u l=0.15u
MBC29_XMPL XBC29/Q XBC29/QB VDD VDD sky130_fd_pr__pfet_01v8 w=0.42u l=0.15u
MBC29_XMNL XBC29/Q XBC29/QB VSS VSS sky130_fd_pr__nfet_01v8 w=1.26u l=0.15u
MBC29_XMPR XBC29/QB XBC29/Q VDD VDD sky130_fd_pr__pfet_01v8 w=0.42u l=0.15u
MBC29_XMNR XBC29/QB XBC29/Q VSS VSS sky130_fd_pr__nfet_01v8 w=1.26u l=0.15u
MBC29_XMAL XBC29/Q WLOFF BL VSS sky130_fd_pr__nfet_01v8 w=0.6u l=0.15u
MBC29_XMAR BLB WLOFF XBC29/QB VSS sky130_fd_pr__nfet_01v8 w=0.6u l=0.15u
MBC30_XMPL XBC30/Q XBC30/QB VDD VDD sky130_fd_pr__pfet_01v8 w=0.42u l=0.15u
MBC30_XMNL XBC30/Q XBC30/QB VSS VSS sky130_fd_pr__nfet_01v8 w=1.26u l=0.15u
MBC30_XMPR XBC30/QB XBC30/Q VDD VDD sky130_fd_pr__pfet_01v8 w=0.42u l=0.15u
MBC30_XMNR XBC30/QB XBC30/Q VSS VSS sky130_fd_pr__nfet_01v8 w=1.26u l=0.15u
MBC30_XMAL XBC30/Q WLOFF BL VSS sky130_fd_pr__nfet_01v8 w=0.6u l=0.15u
MBC30_XMAR BLB WLOFF XBC30/QB VSS sky130_fd_pr__nfet_01v8 w=0.6u l=0.15u
MBC31_XMPL XBC31/Q XBC31/QB VDD VDD sky130_fd_pr__pfet_01v8 w=0.42u l=0.15u
MBC31_XMNL XBC31/Q XBC31/QB VSS VSS sky130_fd_pr__nfet_01v8 w=1.26u l=0.15u
MBC31_XMPR XBC31/QB XBC31/Q VDD VDD sky130_fd_pr__pfet_01v8 w=0.42u l=0.15u
MBC31_XMNR XBC31/QB XBC31/Q VSS VSS sky130_fd_pr__nfet_01v8 w=1.26u l=0.15u
MBC31_XMAL XBC31/Q WLOFF BL VSS sky130_fd_pr__nfet_01v8 w=0.6u l=0.15u
MBC31_XMAR BLB WLOFF XBC31/QB VSS sky130_fd_pr__nfet_01v8 w=0.6u l=0.15u
MPRE_XMPBL BL PRECH VDD VDD sky130_fd_pr__pfet_01v8 w=2.52u l=0.15u
MPRE_XMPBLB BLB PRECH VDD VDD sky130_fd_pr__pfet_01v8 w=2.52u l=0.15u
MPRE_XMEQ BL PRECH BLB VDD sky130_fd_pr__pfet_01v8 w=2.52u l=0.15u
MSA_XMP1 SA_OUT SA_OUTB VDD VDD sky130_fd_pr__pfet_01v8 w=1.89u l=0.15u
MSA_XMN1 SA_OUT SA_OUTB XSA/NTAIL VSS sky130_fd_pr__nfet_01v8 w=0.975u l=0.15u
MSA_XMP2 SA_OUTB SA_OUT VDD VDD sky130_fd_pr__pfet_01v8 w=1.89u l=0.15u
MSA_XMN2 SA_OUTB SA_OUT XSA/NTAIL VSS sky130_fd_pr__nfet_01v8 w=0.975u l=0.15u
MSA_XMSAMPBL BL SCLK SA_OUT VDD sky130_fd_pr__pfet_01v8 w=2u l=0.15u
MSA_XMSAMPBLB SA_OUTB SCLK BLB VDD sky130_fd_pr__pfet_01v8 w=2u l=0.15u
MSA_XMTAIL XSA/NTAIL SCLK VSS VSS sky130_fd_pr__nfet_01v8 w=0.975u l=0.15u
MWRITE_XMPWEB XWRITE/WE_B WE VDD VDD sky130_fd_pr__pfet_01v8 w=0.84u l=0.15u
MWRITE_XMNWEB XWRITE/WE_B WE VSS VSS sky130_fd_pr__nfet_01v8 w=0.84u l=0.15u
MWRITE_XMPENBL XWRITE/net1 XWRITE/WE_B VDD VDD sky130_fd_pr__pfet_01v8 w=5.04u l=0.15u
MWRITE_XMPDBL BL DATA_B XWRITE/net1 VDD sky130_fd_pr__pfet_01v8 w=5.04u l=0.15u
MWRITE_XMNDBL BL DATA_B XWRITE/net2 VSS sky130_fd_pr__nfet_01v8 w=5.04u l=0.15u
MWRITE_XMNENBL XWRITE/net2 WE VSS VSS sky130_fd_pr__nfet_01v8 w=5.04u l=0.15u
MWRITE_XMPENBLB XWRITE/net3 XWRITE/WE_B VDD VDD sky130_fd_pr__pfet_01v8 w=5.04u l=0.15u
MWRITE_XMPDBLB BLB DATA XWRITE/net3 VDD sky130_fd_pr__pfet_01v8 w=5.04u l=0.15u
MWRITE_XMNDBLB BLB DATA XWRITE/net4 VSS sky130_fd_pr__nfet_01v8 w=5.04u l=0.15u
MWRITE_XMNENBLB XWRITE/net4 WE VSS VSS sky130_fd_pr__nfet_01v8 w=5.04u l=0.15u
.ends g7_column
