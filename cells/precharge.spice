* Canonical SKY130A three-PMOS precharge/equalization leaf.
* PRECH is active low.  Pin order follows cells/precharge.sch.
.subckt precharge VDD BL BLB PRECH VSS
XMPBL  BL  PRECH VDD VDD sky130_fd_pr__pfet_01v8 l=0.15 w=0.42 nf=1
XMPBLB BLB PRECH VDD VDD sky130_fd_pr__pfet_01v8 l=0.15 w=0.42 nf=1
XMEQ   BL  PRECH BLB VDD sky130_fd_pr__pfet_01v8 l=0.15 w=0.42 nf=1
.ends precharge
