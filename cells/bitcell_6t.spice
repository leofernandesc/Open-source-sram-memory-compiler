* Canonical SKY130A SRAM 6T single-port schematic netlist.
* Pin order matches the Xschem symbol: VDD BL BLB VSS WL.
.subckt bitcell_6t VDD BL BLB VSS WL
XPU_L Q  QB VDD VDD sky130_fd_pr__pfet_01v8 l=0.15 w=0.42 nf=1
XPU_R QB Q  VDD VDD sky130_fd_pr__pfet_01v8 l=0.15 w=0.42 nf=1
XPD_L Q  QB VSS VSS sky130_fd_pr__nfet_01v8 l=0.15 w=1.26 nf=1
XPD_R QB Q  VSS VSS sky130_fd_pr__nfet_01v8 l=0.15 w=1.26 nf=1
XACC_L Q  WL BL  VSS sky130_fd_pr__nfet_01v8 l=0.15 w=0.60 nf=1
XACC_R QB WL BLB VSS sky130_fd_pr__nfet_01v8 l=0.15 w=0.60 nf=1
.ends bitcell_6t
