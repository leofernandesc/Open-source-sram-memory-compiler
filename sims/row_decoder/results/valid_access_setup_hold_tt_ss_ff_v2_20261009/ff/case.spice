* valid_access_capture setup/hold screen: FF
.lib "/opt/pdks/sky130A/libs.tech/ngspice/sky130.lib.spice" ff
.include "/opt/pdks/sky130A/libs.ref/sky130_fd_sc_hd/spice/sky130_fd_sc_hd.spice"
.include "/work/sims/row_decoder/results/valid_access_setup_hold_tt_ss_ff_v2_20261009/xschem/valid_access_capture_cell.spice"
.temp 125
.options method=gear reltol=1e-4 vabstol=1e-9 iabstol=1e-12
VSS_SRC VSS 0 0
VDD_SRC VDD VSS 1.8
VCLK CLK VSS PWL(0 0 9.75e-10 0 1.025e-09 1.8 1.975e-09 1.8 2.025e-09 0 2.975e-09 0 3.025e-09 1.8 3.975e-09 1.8 4.025e-09 0 4.5e-09 0)
VSETUP_p0500_CSb SETUP_p0500_CSB VSS PWL(0 1 2.475e-09 1 2.525e-09 0 4.5e-09 0)
VSETUP_p0500_OEb SETUP_p0500_OEB VSS PWL(0 1 2.475e-09 1 2.525e-09 0 4.5e-09 0)
VSETUP_p0500_WEb SETUP_p0500_WEB VSS PWL(0 1 2.475e-09 1 2.525e-09 1 4.5e-09 1)
VSETUP_p0300_CSb SETUP_p0300_CSB VSS PWL(0 1 2.675e-09 1 2.725e-09 0 4.5e-09 0)
VSETUP_p0300_OEb SETUP_p0300_OEB VSS PWL(0 1 2.675e-09 1 2.725e-09 0 4.5e-09 0)
VSETUP_p0300_WEb SETUP_p0300_WEB VSS PWL(0 1 2.675e-09 1 2.725e-09 1 4.5e-09 1)
VSETUP_p0200_CSb SETUP_p0200_CSB VSS PWL(0 1 2.775e-09 1 2.825e-09 0 4.5e-09 0)
VSETUP_p0200_OEb SETUP_p0200_OEB VSS PWL(0 1 2.775e-09 1 2.825e-09 0 4.5e-09 0)
VSETUP_p0200_WEb SETUP_p0200_WEB VSS PWL(0 1 2.775e-09 1 2.825e-09 1 4.5e-09 1)
VSETUP_p0150_CSb SETUP_p0150_CSB VSS PWL(0 1 2.825e-09 1 2.875e-09 0 4.5e-09 0)
VSETUP_p0150_OEb SETUP_p0150_OEB VSS PWL(0 1 2.825e-09 1 2.875e-09 0 4.5e-09 0)
VSETUP_p0150_WEb SETUP_p0150_WEB VSS PWL(0 1 2.825e-09 1 2.875e-09 1 4.5e-09 1)
VSETUP_p0100_CSb SETUP_p0100_CSB VSS PWL(0 1 2.875e-09 1 2.925e-09 0 4.5e-09 0)
VSETUP_p0100_OEb SETUP_p0100_OEB VSS PWL(0 1 2.875e-09 1 2.925e-09 0 4.5e-09 0)
VSETUP_p0100_WEb SETUP_p0100_WEB VSS PWL(0 1 2.875e-09 1 2.925e-09 1 4.5e-09 1)
VSETUP_p0050_CSb SETUP_p0050_CSB VSS PWL(0 1 2.925e-09 1 2.975e-09 0 4.5e-09 0)
VSETUP_p0050_OEb SETUP_p0050_OEB VSS PWL(0 1 2.925e-09 1 2.975e-09 0 4.5e-09 0)
VSETUP_p0050_WEb SETUP_p0050_WEB VSS PWL(0 1 2.925e-09 1 2.975e-09 1 4.5e-09 1)
VSETUP_p0000_CSb SETUP_p0000_CSB VSS PWL(0 1 2.975e-09 1 3.025e-09 0 4.5e-09 0)
VSETUP_p0000_OEb SETUP_p0000_OEB VSS PWL(0 1 2.975e-09 1 3.025e-09 0 4.5e-09 0)
VSETUP_p0000_WEb SETUP_p0000_WEB VSS PWL(0 1 2.975e-09 1 3.025e-09 1 4.5e-09 1)
VSETUP_m0050_CSb SETUP_m0050_CSB VSS PWL(0 1 3.025e-09 1 3.075e-09 0 4.5e-09 0)
VSETUP_m0050_OEb SETUP_m0050_OEB VSS PWL(0 1 3.025e-09 1 3.075e-09 0 4.5e-09 0)
VSETUP_m0050_WEb SETUP_m0050_WEB VSS PWL(0 1 3.025e-09 1 3.075e-09 1 4.5e-09 1)
VHOLD_m0100_CSb HOLD_m0100_CSB VSS PWL(0 1 1.475e-09 1 1.525e-09 0 2.875e-09 0 2.925e-09 0 4.5e-09 0)
VHOLD_m0100_OEb HOLD_m0100_OEB VSS PWL(0 1 1.475e-09 1 1.525e-09 0 2.875e-09 0 2.925e-09 0 4.5e-09 0)
VHOLD_m0100_WEb HOLD_m0100_WEB VSS PWL(0 1 1.475e-09 1 1.525e-09 1 2.875e-09 1 2.925e-09 0 4.5e-09 0)
VHOLD_m0050_CSb HOLD_m0050_CSB VSS PWL(0 1 1.475e-09 1 1.525e-09 0 2.925e-09 0 2.975e-09 0 4.5e-09 0)
VHOLD_m0050_OEb HOLD_m0050_OEB VSS PWL(0 1 1.475e-09 1 1.525e-09 0 2.925e-09 0 2.975e-09 0 4.5e-09 0)
VHOLD_m0050_WEb HOLD_m0050_WEB VSS PWL(0 1 1.475e-09 1 1.525e-09 1 2.925e-09 1 2.975e-09 0 4.5e-09 0)
VHOLD_m0025_CSb HOLD_m0025_CSB VSS PWL(0 1 1.475e-09 1 1.525e-09 0 2.95e-09 0 3e-09 0 4.5e-09 0)
VHOLD_m0025_OEb HOLD_m0025_OEB VSS PWL(0 1 1.475e-09 1 1.525e-09 0 2.95e-09 0 3e-09 0 4.5e-09 0)
VHOLD_m0025_WEb HOLD_m0025_WEB VSS PWL(0 1 1.475e-09 1 1.525e-09 1 2.95e-09 1 3e-09 0 4.5e-09 0)
VHOLD_p0000_CSb HOLD_p0000_CSB VSS PWL(0 1 1.475e-09 1 1.525e-09 0 2.975e-09 0 3.025e-09 0 4.5e-09 0)
VHOLD_p0000_OEb HOLD_p0000_OEB VSS PWL(0 1 1.475e-09 1 1.525e-09 0 2.975e-09 0 3.025e-09 0 4.5e-09 0)
VHOLD_p0000_WEb HOLD_p0000_WEB VSS PWL(0 1 1.475e-09 1 1.525e-09 1 2.975e-09 1 3.025e-09 0 4.5e-09 0)
VHOLD_p0025_CSb HOLD_p0025_CSB VSS PWL(0 1 1.475e-09 1 1.525e-09 0 3e-09 0 3.05e-09 0 4.5e-09 0)
VHOLD_p0025_OEb HOLD_p0025_OEB VSS PWL(0 1 1.475e-09 1 1.525e-09 0 3e-09 0 3.05e-09 0 4.5e-09 0)
VHOLD_p0025_WEb HOLD_p0025_WEB VSS PWL(0 1 1.475e-09 1 1.525e-09 1 3e-09 1 3.05e-09 0 4.5e-09 0)
VHOLD_p0050_CSb HOLD_p0050_CSB VSS PWL(0 1 1.475e-09 1 1.525e-09 0 3.025e-09 0 3.075e-09 0 4.5e-09 0)
VHOLD_p0050_OEb HOLD_p0050_OEB VSS PWL(0 1 1.475e-09 1 1.525e-09 0 3.025e-09 0 3.075e-09 0 4.5e-09 0)
VHOLD_p0050_WEb HOLD_p0050_WEB VSS PWL(0 1 1.475e-09 1 1.525e-09 1 3.025e-09 1 3.075e-09 0 4.5e-09 0)
VHOLD_p0100_CSb HOLD_p0100_CSB VSS PWL(0 1 1.475e-09 1 1.525e-09 0 3.075e-09 0 3.125e-09 0 4.5e-09 0)
VHOLD_p0100_OEb HOLD_p0100_OEB VSS PWL(0 1 1.475e-09 1 1.525e-09 0 3.075e-09 0 3.125e-09 0 4.5e-09 0)
VHOLD_p0100_WEb HOLD_p0100_WEB VSS PWL(0 1 1.475e-09 1 1.525e-09 1 3.075e-09 1 3.125e-09 0 4.5e-09 0)
VHOLD_p0200_CSb HOLD_p0200_CSB VSS PWL(0 1 1.475e-09 1 1.525e-09 0 3.175e-09 0 3.225e-09 0 4.5e-09 0)
VHOLD_p0200_OEb HOLD_p0200_OEB VSS PWL(0 1 1.475e-09 1 1.525e-09 0 3.175e-09 0 3.225e-09 0 4.5e-09 0)
VHOLD_p0200_WEb HOLD_p0200_WEB VSS PWL(0 1 1.475e-09 1 1.525e-09 1 3.175e-09 1 3.225e-09 0 4.5e-09 0)
XSETUP_p0500 CLK SETUP_p0500_CSB SETUP_p0500_OEB SETUP_p0500_WEB VDD VSS D_SETUP_p0500 Q_SETUP_p0500 valid_access_capture
CLOAD_SETUP_p0500 Q_SETUP_p0500 VSS 3.434554f
XSETUP_p0300 CLK SETUP_p0300_CSB SETUP_p0300_OEB SETUP_p0300_WEB VDD VSS D_SETUP_p0300 Q_SETUP_p0300 valid_access_capture
CLOAD_SETUP_p0300 Q_SETUP_p0300 VSS 3.434554f
XSETUP_p0200 CLK SETUP_p0200_CSB SETUP_p0200_OEB SETUP_p0200_WEB VDD VSS D_SETUP_p0200 Q_SETUP_p0200 valid_access_capture
CLOAD_SETUP_p0200 Q_SETUP_p0200 VSS 3.434554f
XSETUP_p0150 CLK SETUP_p0150_CSB SETUP_p0150_OEB SETUP_p0150_WEB VDD VSS D_SETUP_p0150 Q_SETUP_p0150 valid_access_capture
CLOAD_SETUP_p0150 Q_SETUP_p0150 VSS 3.434554f
XSETUP_p0100 CLK SETUP_p0100_CSB SETUP_p0100_OEB SETUP_p0100_WEB VDD VSS D_SETUP_p0100 Q_SETUP_p0100 valid_access_capture
CLOAD_SETUP_p0100 Q_SETUP_p0100 VSS 3.434554f
XSETUP_p0050 CLK SETUP_p0050_CSB SETUP_p0050_OEB SETUP_p0050_WEB VDD VSS D_SETUP_p0050 Q_SETUP_p0050 valid_access_capture
CLOAD_SETUP_p0050 Q_SETUP_p0050 VSS 3.434554f
XSETUP_p0000 CLK SETUP_p0000_CSB SETUP_p0000_OEB SETUP_p0000_WEB VDD VSS D_SETUP_p0000 Q_SETUP_p0000 valid_access_capture
CLOAD_SETUP_p0000 Q_SETUP_p0000 VSS 3.434554f
XSETUP_m0050 CLK SETUP_m0050_CSB SETUP_m0050_OEB SETUP_m0050_WEB VDD VSS D_SETUP_m0050 Q_SETUP_m0050 valid_access_capture
CLOAD_SETUP_m0050 Q_SETUP_m0050 VSS 3.434554f
XHOLD_m0100 CLK HOLD_m0100_CSB HOLD_m0100_OEB HOLD_m0100_WEB VDD VSS D_HOLD_m0100 Q_HOLD_m0100 valid_access_capture
CLOAD_HOLD_m0100 Q_HOLD_m0100 VSS 3.434554f
XHOLD_m0050 CLK HOLD_m0050_CSB HOLD_m0050_OEB HOLD_m0050_WEB VDD VSS D_HOLD_m0050 Q_HOLD_m0050 valid_access_capture
CLOAD_HOLD_m0050 Q_HOLD_m0050 VSS 3.434554f
XHOLD_m0025 CLK HOLD_m0025_CSB HOLD_m0025_OEB HOLD_m0025_WEB VDD VSS D_HOLD_m0025 Q_HOLD_m0025 valid_access_capture
CLOAD_HOLD_m0025 Q_HOLD_m0025 VSS 3.434554f
XHOLD_p0000 CLK HOLD_p0000_CSB HOLD_p0000_OEB HOLD_p0000_WEB VDD VSS D_HOLD_p0000 Q_HOLD_p0000 valid_access_capture
CLOAD_HOLD_p0000 Q_HOLD_p0000 VSS 3.434554f
XHOLD_p0025 CLK HOLD_p0025_CSB HOLD_p0025_OEB HOLD_p0025_WEB VDD VSS D_HOLD_p0025 Q_HOLD_p0025 valid_access_capture
CLOAD_HOLD_p0025 Q_HOLD_p0025 VSS 3.434554f
XHOLD_p0050 CLK HOLD_p0050_CSB HOLD_p0050_OEB HOLD_p0050_WEB VDD VSS D_HOLD_p0050 Q_HOLD_p0050 valid_access_capture
CLOAD_HOLD_p0050 Q_HOLD_p0050 VSS 3.434554f
XHOLD_p0100 CLK HOLD_p0100_CSB HOLD_p0100_OEB HOLD_p0100_WEB VDD VSS D_HOLD_p0100 Q_HOLD_p0100 valid_access_capture
CLOAD_HOLD_p0100 Q_HOLD_p0100 VSS 3.434554f
XHOLD_p0200 CLK HOLD_p0200_CSB HOLD_p0200_OEB HOLD_p0200_WEB VDD VSS D_HOLD_p0200 Q_HOLD_p0200 valid_access_capture
CLOAD_HOLD_p0200 Q_HOLD_p0200 VSS 3.434554f
.save v(CLK) v(D_SETUP_p0500) v(Q_SETUP_p0500) v(D_SETUP_p0300) v(Q_SETUP_p0300) v(D_SETUP_p0200) v(Q_SETUP_p0200) v(D_SETUP_p0150) v(Q_SETUP_p0150) v(D_SETUP_p0100) v(Q_SETUP_p0100) v(D_SETUP_p0050) v(Q_SETUP_p0050) v(D_SETUP_p0000) v(Q_SETUP_p0000) v(D_SETUP_m0050) v(Q_SETUP_m0050) v(D_HOLD_m0100) v(Q_HOLD_m0100) v(D_HOLD_m0050) v(Q_HOLD_m0050) v(D_HOLD_m0025) v(Q_HOLD_m0025) v(D_HOLD_p0000) v(Q_HOLD_p0000) v(D_HOLD_p0025) v(Q_HOLD_p0025) v(D_HOLD_p0050) v(Q_HOLD_p0050) v(D_HOLD_p0100) v(Q_HOLD_p0100) v(D_HOLD_p0200) v(Q_HOLD_p0200)
.control
set noaskquit
tran 2p 4.5n 0 2p
write /work/sims/row_decoder/results/valid_access_setup_hold_tt_ss_ff_v2_20261009/ff/waveform.raw all
quit
.endc
.end
