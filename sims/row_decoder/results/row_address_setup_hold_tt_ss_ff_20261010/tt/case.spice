* row_address_capture setup/hold screen: TT
.lib "/opt/pdks/sky130A/libs.tech/ngspice/sky130.lib.spice" tt
.include "/opt/pdks/sky130A/libs.ref/sky130_fd_sc_hd/spice/sky130_fd_sc_hd.spice"
.include "/work/sims/row_decoder/results/row_address_setup_hold_tt_ss_ff_20261010/xschem/row_address_capture_bit.spice"
.temp 27
.options method=gear reltol=1e-4 vabstol=1e-9 iabstol=1e-12
VSS_SRC VSS 0 0
VDD_SRC VDD VSS 1.8
VCLK CLK VSS PWL(0 0 9.75e-10 0 1.025e-09 1.8 1.975e-09 1.8 2.025e-09 0 2.975e-09 0 3.025e-09 1.8 3.975e-09 1.8 4.025e-09 0 4.5e-09 0)
VA0_RISE_M0500 D_A0_RISE_M0500 VSS PWL(0 0 2.475e-09 0 2.525e-09 1.8 4.5e-09 1.8)
VA0_RISE_M0300 D_A0_RISE_M0300 VSS PWL(0 0 2.675e-09 0 2.725e-09 1.8 4.5e-09 1.8)
VA0_RISE_M0200 D_A0_RISE_M0200 VSS PWL(0 0 2.775e-09 0 2.825e-09 1.8 4.5e-09 1.8)
VA0_RISE_M0150 D_A0_RISE_M0150 VSS PWL(0 0 2.825e-09 0 2.875e-09 1.8 4.5e-09 1.8)
VA0_RISE_M0100 D_A0_RISE_M0100 VSS PWL(0 0 2.875e-09 0 2.925e-09 1.8 4.5e-09 1.8)
VA0_RISE_M0075 D_A0_RISE_M0075 VSS PWL(0 0 2.9e-09 0 2.95e-09 1.8 4.5e-09 1.8)
VA0_RISE_M0050 D_A0_RISE_M0050 VSS PWL(0 0 2.925e-09 0 2.975e-09 1.8 4.5e-09 1.8)
VA0_RISE_M0025 D_A0_RISE_M0025 VSS PWL(0 0 2.95e-09 0 3e-09 1.8 4.5e-09 1.8)
VA0_RISE_P0000 D_A0_RISE_P0000 VSS PWL(0 0 2.975e-09 0 3.025e-09 1.8 4.5e-09 1.8)
VA0_RISE_P0010 D_A0_RISE_P0010 VSS PWL(0 0 2.985e-09 0 3.035e-09 1.8 4.5e-09 1.8)
VA0_RISE_P0025 D_A0_RISE_P0025 VSS PWL(0 0 3e-09 0 3.05e-09 1.8 4.5e-09 1.8)
VA0_RISE_P0050 D_A0_RISE_P0050 VSS PWL(0 0 3.025e-09 0 3.075e-09 1.8 4.5e-09 1.8)
VA0_RISE_P0100 D_A0_RISE_P0100 VSS PWL(0 0 3.075e-09 0 3.125e-09 1.8 4.5e-09 1.8)
VA0_RISE_P0200 D_A0_RISE_P0200 VSS PWL(0 0 3.175e-09 0 3.225e-09 1.8 4.5e-09 1.8)
VA0_FALL_M0500 D_A0_FALL_M0500 VSS PWL(0 1.8 2.475e-09 1.8 2.525e-09 0 4.5e-09 0)
VA0_FALL_M0300 D_A0_FALL_M0300 VSS PWL(0 1.8 2.675e-09 1.8 2.725e-09 0 4.5e-09 0)
VA0_FALL_M0200 D_A0_FALL_M0200 VSS PWL(0 1.8 2.775e-09 1.8 2.825e-09 0 4.5e-09 0)
VA0_FALL_M0150 D_A0_FALL_M0150 VSS PWL(0 1.8 2.825e-09 1.8 2.875e-09 0 4.5e-09 0)
VA0_FALL_M0100 D_A0_FALL_M0100 VSS PWL(0 1.8 2.875e-09 1.8 2.925e-09 0 4.5e-09 0)
VA0_FALL_M0075 D_A0_FALL_M0075 VSS PWL(0 1.8 2.9e-09 1.8 2.95e-09 0 4.5e-09 0)
VA0_FALL_M0050 D_A0_FALL_M0050 VSS PWL(0 1.8 2.925e-09 1.8 2.975e-09 0 4.5e-09 0)
VA0_FALL_M0025 D_A0_FALL_M0025 VSS PWL(0 1.8 2.95e-09 1.8 3e-09 0 4.5e-09 0)
VA0_FALL_P0000 D_A0_FALL_P0000 VSS PWL(0 1.8 2.975e-09 1.8 3.025e-09 0 4.5e-09 0)
VA0_FALL_P0010 D_A0_FALL_P0010 VSS PWL(0 1.8 2.985e-09 1.8 3.035e-09 0 4.5e-09 0)
VA0_FALL_P0025 D_A0_FALL_P0025 VSS PWL(0 1.8 3e-09 1.8 3.05e-09 0 4.5e-09 0)
VA0_FALL_P0050 D_A0_FALL_P0050 VSS PWL(0 1.8 3.025e-09 1.8 3.075e-09 0 4.5e-09 0)
VA0_FALL_P0100 D_A0_FALL_P0100 VSS PWL(0 1.8 3.075e-09 1.8 3.125e-09 0 4.5e-09 0)
VA0_FALL_P0200 D_A0_FALL_P0200 VSS PWL(0 1.8 3.175e-09 1.8 3.225e-09 0 4.5e-09 0)
VA1_RISE_M0500 D_A1_RISE_M0500 VSS PWL(0 0 2.475e-09 0 2.525e-09 1.8 4.5e-09 1.8)
VA1_RISE_M0300 D_A1_RISE_M0300 VSS PWL(0 0 2.675e-09 0 2.725e-09 1.8 4.5e-09 1.8)
VA1_RISE_M0200 D_A1_RISE_M0200 VSS PWL(0 0 2.775e-09 0 2.825e-09 1.8 4.5e-09 1.8)
VA1_RISE_M0150 D_A1_RISE_M0150 VSS PWL(0 0 2.825e-09 0 2.875e-09 1.8 4.5e-09 1.8)
VA1_RISE_M0100 D_A1_RISE_M0100 VSS PWL(0 0 2.875e-09 0 2.925e-09 1.8 4.5e-09 1.8)
VA1_RISE_M0075 D_A1_RISE_M0075 VSS PWL(0 0 2.9e-09 0 2.95e-09 1.8 4.5e-09 1.8)
VA1_RISE_M0050 D_A1_RISE_M0050 VSS PWL(0 0 2.925e-09 0 2.975e-09 1.8 4.5e-09 1.8)
VA1_RISE_M0025 D_A1_RISE_M0025 VSS PWL(0 0 2.95e-09 0 3e-09 1.8 4.5e-09 1.8)
VA1_RISE_P0000 D_A1_RISE_P0000 VSS PWL(0 0 2.975e-09 0 3.025e-09 1.8 4.5e-09 1.8)
VA1_RISE_P0010 D_A1_RISE_P0010 VSS PWL(0 0 2.985e-09 0 3.035e-09 1.8 4.5e-09 1.8)
VA1_RISE_P0025 D_A1_RISE_P0025 VSS PWL(0 0 3e-09 0 3.05e-09 1.8 4.5e-09 1.8)
VA1_RISE_P0050 D_A1_RISE_P0050 VSS PWL(0 0 3.025e-09 0 3.075e-09 1.8 4.5e-09 1.8)
VA1_RISE_P0100 D_A1_RISE_P0100 VSS PWL(0 0 3.075e-09 0 3.125e-09 1.8 4.5e-09 1.8)
VA1_RISE_P0200 D_A1_RISE_P0200 VSS PWL(0 0 3.175e-09 0 3.225e-09 1.8 4.5e-09 1.8)
VA1_FALL_M0500 D_A1_FALL_M0500 VSS PWL(0 1.8 2.475e-09 1.8 2.525e-09 0 4.5e-09 0)
VA1_FALL_M0300 D_A1_FALL_M0300 VSS PWL(0 1.8 2.675e-09 1.8 2.725e-09 0 4.5e-09 0)
VA1_FALL_M0200 D_A1_FALL_M0200 VSS PWL(0 1.8 2.775e-09 1.8 2.825e-09 0 4.5e-09 0)
VA1_FALL_M0150 D_A1_FALL_M0150 VSS PWL(0 1.8 2.825e-09 1.8 2.875e-09 0 4.5e-09 0)
VA1_FALL_M0100 D_A1_FALL_M0100 VSS PWL(0 1.8 2.875e-09 1.8 2.925e-09 0 4.5e-09 0)
VA1_FALL_M0075 D_A1_FALL_M0075 VSS PWL(0 1.8 2.9e-09 1.8 2.95e-09 0 4.5e-09 0)
VA1_FALL_M0050 D_A1_FALL_M0050 VSS PWL(0 1.8 2.925e-09 1.8 2.975e-09 0 4.5e-09 0)
VA1_FALL_M0025 D_A1_FALL_M0025 VSS PWL(0 1.8 2.95e-09 1.8 3e-09 0 4.5e-09 0)
VA1_FALL_P0000 D_A1_FALL_P0000 VSS PWL(0 1.8 2.975e-09 1.8 3.025e-09 0 4.5e-09 0)
VA1_FALL_P0010 D_A1_FALL_P0010 VSS PWL(0 1.8 2.985e-09 1.8 3.035e-09 0 4.5e-09 0)
VA1_FALL_P0025 D_A1_FALL_P0025 VSS PWL(0 1.8 3e-09 1.8 3.05e-09 0 4.5e-09 0)
VA1_FALL_P0050 D_A1_FALL_P0050 VSS PWL(0 1.8 3.025e-09 1.8 3.075e-09 0 4.5e-09 0)
VA1_FALL_P0100 D_A1_FALL_P0100 VSS PWL(0 1.8 3.075e-09 1.8 3.125e-09 0 4.5e-09 0)
VA1_FALL_P0200 D_A1_FALL_P0200 VSS PWL(0 1.8 3.175e-09 1.8 3.225e-09 0 4.5e-09 0)
XA0_RISE_M0500 CLK D_A0_RISE_M0500 VDD VSS Q_A0_RISE_M0500 row_address_capture_bit
CLOAD_A0_RISE_M0500 Q_A0_RISE_M0500 VSS 3.434554f
XA0_RISE_M0300 CLK D_A0_RISE_M0300 VDD VSS Q_A0_RISE_M0300 row_address_capture_bit
CLOAD_A0_RISE_M0300 Q_A0_RISE_M0300 VSS 3.434554f
XA0_RISE_M0200 CLK D_A0_RISE_M0200 VDD VSS Q_A0_RISE_M0200 row_address_capture_bit
CLOAD_A0_RISE_M0200 Q_A0_RISE_M0200 VSS 3.434554f
XA0_RISE_M0150 CLK D_A0_RISE_M0150 VDD VSS Q_A0_RISE_M0150 row_address_capture_bit
CLOAD_A0_RISE_M0150 Q_A0_RISE_M0150 VSS 3.434554f
XA0_RISE_M0100 CLK D_A0_RISE_M0100 VDD VSS Q_A0_RISE_M0100 row_address_capture_bit
CLOAD_A0_RISE_M0100 Q_A0_RISE_M0100 VSS 3.434554f
XA0_RISE_M0075 CLK D_A0_RISE_M0075 VDD VSS Q_A0_RISE_M0075 row_address_capture_bit
CLOAD_A0_RISE_M0075 Q_A0_RISE_M0075 VSS 3.434554f
XA0_RISE_M0050 CLK D_A0_RISE_M0050 VDD VSS Q_A0_RISE_M0050 row_address_capture_bit
CLOAD_A0_RISE_M0050 Q_A0_RISE_M0050 VSS 3.434554f
XA0_RISE_M0025 CLK D_A0_RISE_M0025 VDD VSS Q_A0_RISE_M0025 row_address_capture_bit
CLOAD_A0_RISE_M0025 Q_A0_RISE_M0025 VSS 3.434554f
XA0_RISE_P0000 CLK D_A0_RISE_P0000 VDD VSS Q_A0_RISE_P0000 row_address_capture_bit
CLOAD_A0_RISE_P0000 Q_A0_RISE_P0000 VSS 3.434554f
XA0_RISE_P0010 CLK D_A0_RISE_P0010 VDD VSS Q_A0_RISE_P0010 row_address_capture_bit
CLOAD_A0_RISE_P0010 Q_A0_RISE_P0010 VSS 3.434554f
XA0_RISE_P0025 CLK D_A0_RISE_P0025 VDD VSS Q_A0_RISE_P0025 row_address_capture_bit
CLOAD_A0_RISE_P0025 Q_A0_RISE_P0025 VSS 3.434554f
XA0_RISE_P0050 CLK D_A0_RISE_P0050 VDD VSS Q_A0_RISE_P0050 row_address_capture_bit
CLOAD_A0_RISE_P0050 Q_A0_RISE_P0050 VSS 3.434554f
XA0_RISE_P0100 CLK D_A0_RISE_P0100 VDD VSS Q_A0_RISE_P0100 row_address_capture_bit
CLOAD_A0_RISE_P0100 Q_A0_RISE_P0100 VSS 3.434554f
XA0_RISE_P0200 CLK D_A0_RISE_P0200 VDD VSS Q_A0_RISE_P0200 row_address_capture_bit
CLOAD_A0_RISE_P0200 Q_A0_RISE_P0200 VSS 3.434554f
XA0_FALL_M0500 CLK D_A0_FALL_M0500 VDD VSS Q_A0_FALL_M0500 row_address_capture_bit
CLOAD_A0_FALL_M0500 Q_A0_FALL_M0500 VSS 3.434554f
XA0_FALL_M0300 CLK D_A0_FALL_M0300 VDD VSS Q_A0_FALL_M0300 row_address_capture_bit
CLOAD_A0_FALL_M0300 Q_A0_FALL_M0300 VSS 3.434554f
XA0_FALL_M0200 CLK D_A0_FALL_M0200 VDD VSS Q_A0_FALL_M0200 row_address_capture_bit
CLOAD_A0_FALL_M0200 Q_A0_FALL_M0200 VSS 3.434554f
XA0_FALL_M0150 CLK D_A0_FALL_M0150 VDD VSS Q_A0_FALL_M0150 row_address_capture_bit
CLOAD_A0_FALL_M0150 Q_A0_FALL_M0150 VSS 3.434554f
XA0_FALL_M0100 CLK D_A0_FALL_M0100 VDD VSS Q_A0_FALL_M0100 row_address_capture_bit
CLOAD_A0_FALL_M0100 Q_A0_FALL_M0100 VSS 3.434554f
XA0_FALL_M0075 CLK D_A0_FALL_M0075 VDD VSS Q_A0_FALL_M0075 row_address_capture_bit
CLOAD_A0_FALL_M0075 Q_A0_FALL_M0075 VSS 3.434554f
XA0_FALL_M0050 CLK D_A0_FALL_M0050 VDD VSS Q_A0_FALL_M0050 row_address_capture_bit
CLOAD_A0_FALL_M0050 Q_A0_FALL_M0050 VSS 3.434554f
XA0_FALL_M0025 CLK D_A0_FALL_M0025 VDD VSS Q_A0_FALL_M0025 row_address_capture_bit
CLOAD_A0_FALL_M0025 Q_A0_FALL_M0025 VSS 3.434554f
XA0_FALL_P0000 CLK D_A0_FALL_P0000 VDD VSS Q_A0_FALL_P0000 row_address_capture_bit
CLOAD_A0_FALL_P0000 Q_A0_FALL_P0000 VSS 3.434554f
XA0_FALL_P0010 CLK D_A0_FALL_P0010 VDD VSS Q_A0_FALL_P0010 row_address_capture_bit
CLOAD_A0_FALL_P0010 Q_A0_FALL_P0010 VSS 3.434554f
XA0_FALL_P0025 CLK D_A0_FALL_P0025 VDD VSS Q_A0_FALL_P0025 row_address_capture_bit
CLOAD_A0_FALL_P0025 Q_A0_FALL_P0025 VSS 3.434554f
XA0_FALL_P0050 CLK D_A0_FALL_P0050 VDD VSS Q_A0_FALL_P0050 row_address_capture_bit
CLOAD_A0_FALL_P0050 Q_A0_FALL_P0050 VSS 3.434554f
XA0_FALL_P0100 CLK D_A0_FALL_P0100 VDD VSS Q_A0_FALL_P0100 row_address_capture_bit
CLOAD_A0_FALL_P0100 Q_A0_FALL_P0100 VSS 3.434554f
XA0_FALL_P0200 CLK D_A0_FALL_P0200 VDD VSS Q_A0_FALL_P0200 row_address_capture_bit
CLOAD_A0_FALL_P0200 Q_A0_FALL_P0200 VSS 3.434554f
XA1_RISE_M0500 CLK D_A1_RISE_M0500 VDD VSS Q_A1_RISE_M0500 row_address_capture_bit
CLOAD_A1_RISE_M0500 Q_A1_RISE_M0500 VSS 3.434554f
XA1_RISE_M0300 CLK D_A1_RISE_M0300 VDD VSS Q_A1_RISE_M0300 row_address_capture_bit
CLOAD_A1_RISE_M0300 Q_A1_RISE_M0300 VSS 3.434554f
XA1_RISE_M0200 CLK D_A1_RISE_M0200 VDD VSS Q_A1_RISE_M0200 row_address_capture_bit
CLOAD_A1_RISE_M0200 Q_A1_RISE_M0200 VSS 3.434554f
XA1_RISE_M0150 CLK D_A1_RISE_M0150 VDD VSS Q_A1_RISE_M0150 row_address_capture_bit
CLOAD_A1_RISE_M0150 Q_A1_RISE_M0150 VSS 3.434554f
XA1_RISE_M0100 CLK D_A1_RISE_M0100 VDD VSS Q_A1_RISE_M0100 row_address_capture_bit
CLOAD_A1_RISE_M0100 Q_A1_RISE_M0100 VSS 3.434554f
XA1_RISE_M0075 CLK D_A1_RISE_M0075 VDD VSS Q_A1_RISE_M0075 row_address_capture_bit
CLOAD_A1_RISE_M0075 Q_A1_RISE_M0075 VSS 3.434554f
XA1_RISE_M0050 CLK D_A1_RISE_M0050 VDD VSS Q_A1_RISE_M0050 row_address_capture_bit
CLOAD_A1_RISE_M0050 Q_A1_RISE_M0050 VSS 3.434554f
XA1_RISE_M0025 CLK D_A1_RISE_M0025 VDD VSS Q_A1_RISE_M0025 row_address_capture_bit
CLOAD_A1_RISE_M0025 Q_A1_RISE_M0025 VSS 3.434554f
XA1_RISE_P0000 CLK D_A1_RISE_P0000 VDD VSS Q_A1_RISE_P0000 row_address_capture_bit
CLOAD_A1_RISE_P0000 Q_A1_RISE_P0000 VSS 3.434554f
XA1_RISE_P0010 CLK D_A1_RISE_P0010 VDD VSS Q_A1_RISE_P0010 row_address_capture_bit
CLOAD_A1_RISE_P0010 Q_A1_RISE_P0010 VSS 3.434554f
XA1_RISE_P0025 CLK D_A1_RISE_P0025 VDD VSS Q_A1_RISE_P0025 row_address_capture_bit
CLOAD_A1_RISE_P0025 Q_A1_RISE_P0025 VSS 3.434554f
XA1_RISE_P0050 CLK D_A1_RISE_P0050 VDD VSS Q_A1_RISE_P0050 row_address_capture_bit
CLOAD_A1_RISE_P0050 Q_A1_RISE_P0050 VSS 3.434554f
XA1_RISE_P0100 CLK D_A1_RISE_P0100 VDD VSS Q_A1_RISE_P0100 row_address_capture_bit
CLOAD_A1_RISE_P0100 Q_A1_RISE_P0100 VSS 3.434554f
XA1_RISE_P0200 CLK D_A1_RISE_P0200 VDD VSS Q_A1_RISE_P0200 row_address_capture_bit
CLOAD_A1_RISE_P0200 Q_A1_RISE_P0200 VSS 3.434554f
XA1_FALL_M0500 CLK D_A1_FALL_M0500 VDD VSS Q_A1_FALL_M0500 row_address_capture_bit
CLOAD_A1_FALL_M0500 Q_A1_FALL_M0500 VSS 3.434554f
XA1_FALL_M0300 CLK D_A1_FALL_M0300 VDD VSS Q_A1_FALL_M0300 row_address_capture_bit
CLOAD_A1_FALL_M0300 Q_A1_FALL_M0300 VSS 3.434554f
XA1_FALL_M0200 CLK D_A1_FALL_M0200 VDD VSS Q_A1_FALL_M0200 row_address_capture_bit
CLOAD_A1_FALL_M0200 Q_A1_FALL_M0200 VSS 3.434554f
XA1_FALL_M0150 CLK D_A1_FALL_M0150 VDD VSS Q_A1_FALL_M0150 row_address_capture_bit
CLOAD_A1_FALL_M0150 Q_A1_FALL_M0150 VSS 3.434554f
XA1_FALL_M0100 CLK D_A1_FALL_M0100 VDD VSS Q_A1_FALL_M0100 row_address_capture_bit
CLOAD_A1_FALL_M0100 Q_A1_FALL_M0100 VSS 3.434554f
XA1_FALL_M0075 CLK D_A1_FALL_M0075 VDD VSS Q_A1_FALL_M0075 row_address_capture_bit
CLOAD_A1_FALL_M0075 Q_A1_FALL_M0075 VSS 3.434554f
XA1_FALL_M0050 CLK D_A1_FALL_M0050 VDD VSS Q_A1_FALL_M0050 row_address_capture_bit
CLOAD_A1_FALL_M0050 Q_A1_FALL_M0050 VSS 3.434554f
XA1_FALL_M0025 CLK D_A1_FALL_M0025 VDD VSS Q_A1_FALL_M0025 row_address_capture_bit
CLOAD_A1_FALL_M0025 Q_A1_FALL_M0025 VSS 3.434554f
XA1_FALL_P0000 CLK D_A1_FALL_P0000 VDD VSS Q_A1_FALL_P0000 row_address_capture_bit
CLOAD_A1_FALL_P0000 Q_A1_FALL_P0000 VSS 3.434554f
XA1_FALL_P0010 CLK D_A1_FALL_P0010 VDD VSS Q_A1_FALL_P0010 row_address_capture_bit
CLOAD_A1_FALL_P0010 Q_A1_FALL_P0010 VSS 3.434554f
XA1_FALL_P0025 CLK D_A1_FALL_P0025 VDD VSS Q_A1_FALL_P0025 row_address_capture_bit
CLOAD_A1_FALL_P0025 Q_A1_FALL_P0025 VSS 3.434554f
XA1_FALL_P0050 CLK D_A1_FALL_P0050 VDD VSS Q_A1_FALL_P0050 row_address_capture_bit
CLOAD_A1_FALL_P0050 Q_A1_FALL_P0050 VSS 3.434554f
XA1_FALL_P0100 CLK D_A1_FALL_P0100 VDD VSS Q_A1_FALL_P0100 row_address_capture_bit
CLOAD_A1_FALL_P0100 Q_A1_FALL_P0100 VSS 3.434554f
XA1_FALL_P0200 CLK D_A1_FALL_P0200 VDD VSS Q_A1_FALL_P0200 row_address_capture_bit
CLOAD_A1_FALL_P0200 Q_A1_FALL_P0200 VSS 3.434554f
.save v(CLK) v(D_A0_RISE_M0500) v(Q_A0_RISE_M0500) v(D_A0_RISE_M0300) v(Q_A0_RISE_M0300) v(D_A0_RISE_M0200) v(Q_A0_RISE_M0200) v(D_A0_RISE_M0150) v(Q_A0_RISE_M0150) v(D_A0_RISE_M0100) v(Q_A0_RISE_M0100) v(D_A0_RISE_M0075) v(Q_A0_RISE_M0075) v(D_A0_RISE_M0050) v(Q_A0_RISE_M0050) v(D_A0_RISE_M0025) v(Q_A0_RISE_M0025) v(D_A0_RISE_P0000) v(Q_A0_RISE_P0000) v(D_A0_RISE_P0010) v(Q_A0_RISE_P0010) v(D_A0_RISE_P0025) v(Q_A0_RISE_P0025) v(D_A0_RISE_P0050) v(Q_A0_RISE_P0050) v(D_A0_RISE_P0100) v(Q_A0_RISE_P0100) v(D_A0_RISE_P0200) v(Q_A0_RISE_P0200) v(D_A0_FALL_M0500) v(Q_A0_FALL_M0500) v(D_A0_FALL_M0300) v(Q_A0_FALL_M0300) v(D_A0_FALL_M0200) v(Q_A0_FALL_M0200) v(D_A0_FALL_M0150) v(Q_A0_FALL_M0150) v(D_A0_FALL_M0100) v(Q_A0_FALL_M0100) v(D_A0_FALL_M0075) v(Q_A0_FALL_M0075) v(D_A0_FALL_M0050) v(Q_A0_FALL_M0050) v(D_A0_FALL_M0025) v(Q_A0_FALL_M0025) v(D_A0_FALL_P0000) v(Q_A0_FALL_P0000) v(D_A0_FALL_P0010) v(Q_A0_FALL_P0010) v(D_A0_FALL_P0025) v(Q_A0_FALL_P0025) v(D_A0_FALL_P0050) v(Q_A0_FALL_P0050) v(D_A0_FALL_P0100) v(Q_A0_FALL_P0100) v(D_A0_FALL_P0200) v(Q_A0_FALL_P0200) v(D_A1_RISE_M0500) v(Q_A1_RISE_M0500) v(D_A1_RISE_M0300) v(Q_A1_RISE_M0300) v(D_A1_RISE_M0200) v(Q_A1_RISE_M0200) v(D_A1_RISE_M0150) v(Q_A1_RISE_M0150) v(D_A1_RISE_M0100) v(Q_A1_RISE_M0100) v(D_A1_RISE_M0075) v(Q_A1_RISE_M0075) v(D_A1_RISE_M0050) v(Q_A1_RISE_M0050) v(D_A1_RISE_M0025) v(Q_A1_RISE_M0025) v(D_A1_RISE_P0000) v(Q_A1_RISE_P0000) v(D_A1_RISE_P0010) v(Q_A1_RISE_P0010) v(D_A1_RISE_P0025) v(Q_A1_RISE_P0025) v(D_A1_RISE_P0050) v(Q_A1_RISE_P0050) v(D_A1_RISE_P0100) v(Q_A1_RISE_P0100) v(D_A1_RISE_P0200) v(Q_A1_RISE_P0200) v(D_A1_FALL_M0500) v(Q_A1_FALL_M0500) v(D_A1_FALL_M0300) v(Q_A1_FALL_M0300) v(D_A1_FALL_M0200) v(Q_A1_FALL_M0200) v(D_A1_FALL_M0150) v(Q_A1_FALL_M0150) v(D_A1_FALL_M0100) v(Q_A1_FALL_M0100) v(D_A1_FALL_M0075) v(Q_A1_FALL_M0075) v(D_A1_FALL_M0050) v(Q_A1_FALL_M0050) v(D_A1_FALL_M0025) v(Q_A1_FALL_M0025) v(D_A1_FALL_P0000) v(Q_A1_FALL_P0000) v(D_A1_FALL_P0010) v(Q_A1_FALL_P0010) v(D_A1_FALL_P0025) v(Q_A1_FALL_P0025) v(D_A1_FALL_P0050) v(Q_A1_FALL_P0050) v(D_A1_FALL_P0100) v(Q_A1_FALL_P0100) v(D_A1_FALL_P0200) v(Q_A1_FALL_P0200)
.control
set noaskquit
tran 2p 4.5n 0 2p
write /work/sims/row_decoder/results/row_address_setup_hold_tt_ss_ff_20261010/tt/waveform.raw all
quit
.endc
.end
