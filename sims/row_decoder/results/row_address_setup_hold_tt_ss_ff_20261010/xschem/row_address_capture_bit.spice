* Testbench-only single-bit wrapper derived from row_address_capture.sch
.subckt row_address_capture_bit CLK D VDD VSS Q
XFF CLK D VSS VSS VDD VDD Q sky130_fd_sc_hd__dfxtp_1
.ends row_address_capture_bit
