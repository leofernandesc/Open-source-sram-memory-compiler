** sch_path: /work/sims/row_decoder/tb_row_decoder_sizing.sch
**.subckt tb_row_decoder_sizing
x1 net1 net2 net3 net4 DEC0 DEC1 DEC3 DEC2 GND row_decoder
VDD_SRC net1 GND 1.8
VPCLK net2 GND PWL(0 0 4.975e-09 0 5.025e-09 1.8 9.975e-09 1.8 1.0025e-08 0 1.9975e-08 0 2.0025e-08 1.8 2.4975e-08 1.8 2.5025e-08 0 3e-08 0)
VA0 net3 GND PWL(0 0 1.795e-08 0 1.8e-08 1.8 3e-08 1.8)
VA1 net4 GND PWL(0 0 3e-08 0)
x2 net1 DEC0 net5 GND wl_driver
x3 net1 DEC1 net6 GND wl_driver
x4 net1 DEC3 net8 GND wl_driver
x5 net1 DEC2 net7 GND wl_driver
C_WL0 net5 GND 1.74e-14 m=1
C_WL1 net6 GND 1.74e-14 m=1
C_WL2 net7 GND 1.74e-14 m=1
C_WL3 net8 GND 1.74e-14 m=1
**.ends

* expanding   symbol:  row_decoder.sym # of pins=9
** sym_path: /work/cells/row_decoder/row_decoder.sym
** sch_path: /work/cells/row_decoder/row_decoder.sch
.subckt row_decoder VDD PCLK A0 A1 DEC0 DEC1 DEC3 DEC2 VSS
X0 VSS.t5 N2 DEC2 VSS.t4 sky130_fd_pr__nfet_01v8 ad=0.58 pd=4.58 as=0.58 ps=4.58 w=2 l=0.15
X1 VSS.t19 A1B A1T VSS.t18 sky130_fd_pr__nfet_01v8 ad=0.58 pd=4.58 as=0.58 ps=4.58 w=2 l=0.15
X2 VDD N2 DEC2 VDD sky130_fd_pr__pfet_01v8 ad=0.58 pd=4.58 as=0.58 ps=4.58 w=2 l=0.15
X3 VSS.t15 A1 A1B VSS.t14 sky130_fd_pr__nfet_01v8 ad=0.1218 pd=1.42 as=0.1218 ps=1.42 w=0.42 l=0.15
X4 EVAL_GND A0B net3 VSS.t11 sky130_fd_pr__nfet_01v8 ad=0.58 pd=4.58 as=0.58 ps=4.58 w=2 l=0.15
X5 VSS.t13 A0B A0T VSS.t12 sky130_fd_pr__nfet_01v8 ad=0.58 pd=4.58 as=0.58 ps=4.58 w=2 l=0.15
X6 VDD N3 DEC3 VDD sky130_fd_pr__pfet_01v8 ad=0.58 pd=4.58 as=0.58 ps=4.58 w=2 l=0.15
X7 VSS.t23 A0 A0B VSS.t22 sky130_fd_pr__nfet_01v8 ad=0.1218 pd=1.42 as=0.1218 ps=1.42 w=0.42 l=0.15
X8 VDD PCLK N0 VDD sky130_fd_pr__pfet_01v8 ad=0.58 pd=4.58 as=0.58 ps=4.58 w=2 l=0.15
X9 VDD PCLK N1 VDD sky130_fd_pr__pfet_01v8 ad=0.58 pd=4.58 as=0.58 ps=4.58 w=2 l=0.15
X10 EVAL_GND A0T net2 VSS.t0 sky130_fd_pr__nfet_01v8 ad=0.58 pd=4.58 as=0.58 ps=4.58 w=2 l=0.15
X11 VDD PCLK N2 VDD sky130_fd_pr__pfet_01v8 ad=0.58 pd=4.58 as=0.58 ps=4.58 w=2 l=0.15
X12 net4 A1T N3 VSS.t21 sky130_fd_pr__nfet_01v8 ad=0.58 pd=4.58 as=0.58 ps=4.58 w=2 l=0.15
X13 VDD A1 A1B VDD sky130_fd_pr__pfet_01v8 ad=0.1218 pd=1.42 as=0.1218 ps=1.42 w=0.42 l=0.15
X14 VDD A1B A1T VDD sky130_fd_pr__pfet_01v8 ad=0.58 pd=4.58 as=0.58 ps=4.58 w=2 l=0.15
X15 EVAL_GND A0B net1 VSS.t10 sky130_fd_pr__nfet_01v8 ad=0.58 pd=4.58 as=0.58 ps=4.58 w=2 l=0.15
X16 VSS.t25 PCLK EVAL_GND VSS.t24 sky130_fd_pr__nfet_01v8 ad=0.435 pd=3.58 as=0.435 ps=3.58 w=1.5 l=0.15
X17 VDD N0 DEC0 VDD sky130_fd_pr__pfet_01v8 ad=0.58 pd=4.58 as=0.58 ps=4.58 w=2 l=0.15
X18 net3 A1T N2 VSS.t20 sky130_fd_pr__nfet_01v8 ad=0.58 pd=4.58 as=0.58 ps=4.58 w=2 l=0.15
X19 VDD N1 DEC1 VDD sky130_fd_pr__pfet_01v8 ad=0.58 pd=4.58 as=0.58 ps=4.58 w=2 l=0.15
X20 VSS.t9 N1 DEC1 VSS.t8 sky130_fd_pr__nfet_01v8 ad=0.58 pd=4.58 as=0.58 ps=4.58 w=2 l=0.15
X21 VDD PCLK N3 VDD sky130_fd_pr__pfet_01v8 ad=0.58 pd=4.58 as=0.58 ps=4.58 w=2 l=0.15
X22 VDD A0 A0B VDD sky130_fd_pr__pfet_01v8 ad=0.1218 pd=1.42 as=0.1218 ps=1.42 w=0.42 l=0.15
X23 VSS.t3 N3 DEC3 VSS.t2 sky130_fd_pr__nfet_01v8 ad=0.58 pd=4.58 as=0.58 ps=4.58 w=2 l=0.15
X24 EVAL_GND A0T net4 VSS.t1 sky130_fd_pr__nfet_01v8 ad=0.58 pd=4.58 as=0.58 ps=4.58 w=2 l=0.15
X25 VDD A0B A0T VDD sky130_fd_pr__pfet_01v8 ad=0.58 pd=4.58 as=0.58 ps=4.58 w=2 l=0.15
X26 net1 A1B N0 VSS.t16 sky130_fd_pr__nfet_01v8 ad=0.58 pd=4.58 as=0.58 ps=4.58 w=2 l=0.15
X27 net2 A1B N1 VSS.t17 sky130_fd_pr__nfet_01v8 ad=0.58 pd=4.58 as=0.58 ps=4.58 w=2 l=0.15
X28 VSS.t7 N0 DEC0 VSS.t6 sky130_fd_pr__nfet_01v8 ad=0.58 pd=4.58 as=0.58 ps=4.58 w=2 l=0.15
R0 VSS.n199 VSS.t14 60931.4
R1 VSS.n200 VSS.n199 24380.4
R2 VSS.n41 VSS.n18 2959.06
R3 VSS.n42 VSS.n38 2959.06
R4 VSS.n199 VSS.t10 2951.37
R5 VSS.n37 VSS.n29 2885.47
R6 VSS.n33 VSS.n29 2885.47
R7 VSS.n37 VSS.n28 2885.47
R8 VSS.n103 VSS.n9 2885.47
R9 VSS.n106 VSS.n9 2885.47
R10 VSS.n103 VSS.n8 2885.47
R11 VSS.n106 VSS.n8 2885.47
R12 VSS.n95 VSS.n83 2885.47
R13 VSS.n98 VSS.n83 2885.47
R14 VSS.n95 VSS.n82 2885.47
R15 VSS.n98 VSS.n82 2885.47
R16 VSS.n119 VSS.n74 2885.47
R17 VSS.n123 VSS.n74 2885.47
R18 VSS.n119 VSS.n73 2885.47
R19 VSS.n123 VSS.n73 2885.47
R20 VSS.n134 VSS.n67 2885.47
R21 VSS.n138 VSS.n67 2885.47
R22 VSS.n134 VSS.n66 2885.47
R23 VSS.n138 VSS.n66 2885.47
R24 VSS.n126 VSS.n72 2885.47
R25 VSS.n127 VSS.n126 2885.47
R26 VSS.n72 VSS.n70 2885.47
R27 VSS.n127 VSS.n70 2885.47
R28 VSS.n141 VSS.n63 2885.47
R29 VSS.n145 VSS.n63 2885.47
R30 VSS.n141 VSS.n62 2885.47
R31 VSS.n145 VSS.n62 2885.47
R32 VSS.n156 VSS.n56 2885.47
R33 VSS.n160 VSS.n56 2885.47
R34 VSS.n156 VSS.n55 2885.47
R35 VSS.n160 VSS.n55 2885.47
R36 VSS.n148 VSS.n61 2885.47
R37 VSS.n149 VSS.n148 2885.47
R38 VSS.n61 VSS.n59 2885.47
R39 VSS.n149 VSS.n59 2885.47
R40 VSS.n163 VSS.n52 2885.47
R41 VSS.n167 VSS.n52 2885.47
R42 VSS.n163 VSS.n51 2885.47
R43 VSS.n167 VSS.n51 2885.47
R44 VSS.n180 VSS.n179 2885.47
R45 VSS.n181 VSS.n180 2885.47
R46 VSS.n179 VSS.n177 2885.47
R47 VSS.n181 VSS.n177 2885.47
R48 VSS.n170 VSS.n50 2885.47
R49 VSS.n171 VSS.n170 2885.47
R50 VSS.n50 VSS.n48 2885.47
R51 VSS.n171 VSS.n48 2885.47
R52 VSS.n40 VSS.n26 2885.47
R53 VSS.n43 VSS.n26 2885.47
R54 VSS.n40 VSS.n25 2885.47
R55 VSS.n43 VSS.n25 2885.47
R56 VSS.n190 VSS.n20 2885.47
R57 VSS.n186 VSS.n20 2885.47
R58 VSS.n190 VSS.n19 2885.47
R59 VSS.n186 VSS.n19 2885.47
R60 VSS.n27 VSS.n17 2876.78
R61 VSS.n201 VSS.n4 2846.37
R62 VSS.n191 VSS.n21 2742.68
R63 VSS.n169 VSS.n168 2742.68
R64 VSS.n162 VSS.n161 2742.68
R65 VSS.n147 VSS.n146 2742.68
R66 VSS.n140 VSS.n139 2742.68
R67 VSS.n125 VSS.n124 2742.68
R68 VSS.n118 VSS.n117 2742.68
R69 VSS.n96 VSS.n93 2695.19
R70 VSS.n112 VSS.n78 2595.76
R71 VSS.n116 VSS.n78 2595.76
R72 VSS.n112 VSS.n77 2595.76
R73 VSS.n116 VSS.n77 2595.76
R74 VSS.t10 VSS.n198 1995.36
R75 VSS.n88 VSS.n85 1970
R76 VSS.n92 VSS.n85 1970
R77 VSS.n88 VSS.n84 1970
R78 VSS.n92 VSS.n84 1970
R79 VSS.n6 VSS.n3 1970
R80 VSS.n202 VSS.n3 1970
R81 VSS.n6 VSS.n2 1970
R82 VSS.n202 VSS.n2 1970
R83 VSS.n198 VSS.n197 1662.8
R84 VSS.n197 VSS.n196 1662.8
R85 VSS.n196 VSS.n195 1662.8
R86 VSS.n195 VSS.n194 1662.8
R87 VSS.n194 VSS.n193 1662.8
R88 VSS.n193 VSS.n192 1662.8
R89 VSS.n192 VSS.t2 1430.26
R90 VSS.t12 VSS.n17 1430.26
R91 VSS.n194 VSS.t4 1430.26
R92 VSS.n196 VSS.t8 1430.26
R93 VSS.n198 VSS.t6 1430.26
R94 VSS.n192 VSS.n17 1330.24
R95 VSS.n97 VSS.n10 1078.82
R96 VSS.n111 VSS.n7 1078.82
R97 VSS.n193 VSS.n16 539.409
R98 VSS.n193 VSS.n15 539.409
R99 VSS.n195 VSS.n14 539.409
R100 VSS.n195 VSS.n13 539.409
R101 VSS.n197 VSS.n12 539.409
R102 VSS.n197 VSS.n11 539.409
R103 VSS.n200 VSS.n6 311.115
R104 VSS.n30 VSS.n28 292.5
R105 VSS.t18 VSS.n29 292.5
R106 VSS.n35 VSS.n29 292.5
R107 VSS.t2 VSS.n19 292.5
R108 VSS.n22 VSS.n19 292.5
R109 VSS.t2 VSS.n20 292.5
R110 VSS.n188 VSS.n20 292.5
R111 VSS.t12 VSS.n25 292.5
R112 VSS.n25 VSS.n23 292.5
R113 VSS.t12 VSS.n26 292.5
R114 VSS.n26 VSS.n24 292.5
R115 VSS.t21 VSS.n48 292.5
R116 VSS.n48 VSS.n46 292.5
R117 VSS.n170 VSS.t21 292.5
R118 VSS.n170 VSS.n47 292.5
R119 VSS.t1 VSS.n177 292.5
R120 VSS.n177 VSS.n175 292.5
R121 VSS.n180 VSS.t1 292.5
R122 VSS.n180 VSS.n176 292.5
R123 VSS.n51 VSS.t4 292.5
R124 VSS.n54 VSS.n51 292.5
R125 VSS.n52 VSS.t4 292.5
R126 VSS.n165 VSS.n52 292.5
R127 VSS.t20 VSS.n59 292.5
R128 VSS.n59 VSS.n57 292.5
R129 VSS.n148 VSS.t20 292.5
R130 VSS.n148 VSS.n58 292.5
R131 VSS.n55 VSS.t11 292.5
R132 VSS.n155 VSS.n55 292.5
R133 VSS.n56 VSS.t11 292.5
R134 VSS.n158 VSS.n56 292.5
R135 VSS.n62 VSS.t8 292.5
R136 VSS.n65 VSS.n62 292.5
R137 VSS.n63 VSS.t8 292.5
R138 VSS.n143 VSS.n63 292.5
R139 VSS.t17 VSS.n70 292.5
R140 VSS.n70 VSS.n68 292.5
R141 VSS.n126 VSS.t17 292.5
R142 VSS.n126 VSS.n69 292.5
R143 VSS.n66 VSS.t0 292.5
R144 VSS.n133 VSS.n66 292.5
R145 VSS.n67 VSS.t0 292.5
R146 VSS.n136 VSS.n67 292.5
R147 VSS.n73 VSS.t6 292.5
R148 VSS.n76 VSS.n73 292.5
R149 VSS.n74 VSS.t6 292.5
R150 VSS.n121 VSS.n74 292.5
R151 VSS.t16 VSS.n82 292.5
R152 VSS.n82 VSS.n80 292.5
R153 VSS.t16 VSS.n83 292.5
R154 VSS.n83 VSS.n81 292.5
R155 VSS.t10 VSS.n8 292.5
R156 VSS.n102 VSS.n8 292.5
R157 VSS.t10 VSS.n9 292.5
R158 VSS.n105 VSS.n9 292.5
R159 VSS.n77 VSS.t24 292.5
R160 VSS.n110 VSS.n77 292.5
R161 VSS.n78 VSS.t24 292.5
R162 VSS.n114 VSS.n78 292.5
R163 VSS.t22 VSS.n2 292.5
R164 VSS.n2 VSS.n0 292.5
R165 VSS.t22 VSS.n3 292.5
R166 VSS.n3 VSS.n1 292.5
R167 VSS.n84 VSS.t14 292.5
R168 VSS.n87 VSS.n84 292.5
R169 VSS.n85 VSS.t14 292.5
R170 VSS.n90 VSS.n85 292.5
R171 VSS.n32 VSS.n28 246.404
R172 VSS.n33 VSS.n32 208.341
R173 VSS.n35 VSS.n34 187.482
R174 VSS.n36 VSS.n35 187.482
R175 VSS.n105 VSS.n104 187.482
R176 VSS.n107 VSS.n105 187.482
R177 VSS.n94 VSS.n81 187.482
R178 VSS.n99 VSS.n81 187.482
R179 VSS.n121 VSS.n120 187.482
R180 VSS.n122 VSS.n121 187.482
R181 VSS.n136 VSS.n135 187.482
R182 VSS.n137 VSS.n136 187.482
R183 VSS.n71 VSS.n69 187.482
R184 VSS.n128 VSS.n69 187.482
R185 VSS.n143 VSS.n142 187.482
R186 VSS.n144 VSS.n143 187.482
R187 VSS.n158 VSS.n157 187.482
R188 VSS.n159 VSS.n158 187.482
R189 VSS.n60 VSS.n58 187.482
R190 VSS.n150 VSS.n58 187.482
R191 VSS.n165 VSS.n164 187.482
R192 VSS.n166 VSS.n165 187.482
R193 VSS.n178 VSS.n176 187.482
R194 VSS.n182 VSS.n176 187.482
R195 VSS.n49 VSS.n47 187.482
R196 VSS.n172 VSS.n47 187.482
R197 VSS.n39 VSS.n24 187.482
R198 VSS.n44 VSS.n24 187.482
R199 VSS.n189 VSS.n188 187.482
R200 VSS.n188 VSS.n187 187.482
R201 VSS.n36 VSS.n30 186.353
R202 VSS.n104 VSS.n102 186.353
R203 VSS.n94 VSS.n80 186.353
R204 VSS.n120 VSS.n76 186.353
R205 VSS.n135 VSS.n133 186.353
R206 VSS.n71 VSS.n68 186.353
R207 VSS.n142 VSS.n65 186.353
R208 VSS.n157 VSS.n155 186.353
R209 VSS.n60 VSS.n57 186.353
R210 VSS.n164 VSS.n54 186.353
R211 VSS.n178 VSS.n175 186.353
R212 VSS.n49 VSS.n46 186.353
R213 VSS.n39 VSS.n23 186.353
R214 VSS.n189 VSS.n22 186.353
R215 VSS.t2 VSS.n191 174.192
R216 VSS.t2 VSS.n18 174.192
R217 VSS.t12 VSS.n41 174.192
R218 VSS.n42 VSS.t12 174.192
R219 VSS.n162 VSS.t4 174.192
R220 VSS.n168 VSS.t4 174.192
R221 VSS.n140 VSS.t8 174.192
R222 VSS.n146 VSS.t8 174.192
R223 VSS.n118 VSS.t6 174.192
R224 VSS.n124 VSS.t6 174.192
R225 VSS.n114 VSS.n113 168.66
R226 VSS.n115 VSS.n114 168.66
R227 VSS.n201 VSS.t22 167.559
R228 VSS.t14 VSS.n4 167.559
R229 VSS.n93 VSS.t14 167.559
R230 VSS.n113 VSS.n110 167.53
R231 VSS.t18 VSS.n27 159.861
R232 VSS.n202 VSS.n201 146.25
R233 VSS.n203 VSS.n202 146.25
R234 VSS.n6 VSS.n5 146.25
R235 VSS.n93 VSS.n92 146.25
R236 VSS.n92 VSS.n91 146.25
R237 VSS.n88 VSS.n4 146.25
R238 VSS.n89 VSS.n88 146.25
R239 VSS.t21 VSS.n169 143.964
R240 VSS.t21 VSS.n16 143.964
R241 VSS.t1 VSS.n15 143.964
R242 VSS.t1 VSS.n21 143.964
R243 VSS.t20 VSS.n147 143.964
R244 VSS.t20 VSS.n14 143.964
R245 VSS.t11 VSS.n13 143.964
R246 VSS.n161 VSS.t11 143.964
R247 VSS.t17 VSS.n125 143.964
R248 VSS.t17 VSS.n12 143.964
R249 VSS.t0 VSS.n11 143.964
R250 VSS.n139 VSS.t0 143.964
R251 VSS.t16 VSS.n96 143.964
R252 VSS.n97 VSS.t16 143.964
R253 VSS.t10 VSS.n10 143.964
R254 VSS.t10 VSS.n7 143.964
R255 VSS.n111 VSS.t24 143.964
R256 VSS.n117 VSS.t24 143.964
R257 VSS.n86 VSS.t15 140.359
R258 VSS.t23 VSS.n204 140.359
R259 VSS.n31 VSS.t19 140.225
R260 VSS.n109 VSS.t25 140.135
R261 VSS.n79 VSS.n108 140.03
R262 VSS.n101 VSS.n100 140.03
R263 VSS.n75 VSS.t7 140.03
R264 VSS.n132 VSS.n131 140.03
R265 VSS.n130 VSS.n129 140.03
R266 VSS.n64 VSS.t9 140.03
R267 VSS.n154 VSS.n153 140.03
R268 VSS.n152 VSS.n151 140.03
R269 VSS.n53 VSS.t5 140.03
R270 VSS.n184 VSS.n183 140.03
R271 VSS.n174 VSS.n173 140.03
R272 VSS.t13 VSS.n45 140.03
R273 VSS.n185 VSS.t3 140.03
R274 VSS.n90 VSS.n89 128
R275 VSS.n91 VSS.n90 128
R276 VSS.n5 VSS.n1 128
R277 VSS.n203 VSS.n1 128
R278 VSS.n89 VSS.n87 126.871
R279 VSS.n5 VSS.n0 126.871
R280 VSS.n34 VSS.n31 126.871
R281 VSS.n108 VSS.n107 126.871
R282 VSS.n100 VSS.n99 126.871
R283 VSS.n122 VSS.n75 126.871
R284 VSS.n137 VSS.n132 126.871
R285 VSS.n129 VSS.n128 126.871
R286 VSS.n144 VSS.n64 126.871
R287 VSS.n159 VSS.n154 126.871
R288 VSS.n151 VSS.n150 126.871
R289 VSS.n166 VSS.n53 126.871
R290 VSS.n183 VSS.n182 126.871
R291 VSS.n173 VSS.n172 126.871
R292 VSS.n45 VSS.n44 126.871
R293 VSS.n187 VSS.n185 126.871
R294 VSS.n115 VSS.n109 108.047
R295 VSS.n117 VSS.n116 83.5719
R296 VSS.n116 VSS.n115 83.5719
R297 VSS.n112 VSS.n111 83.5719
R298 VSS.n113 VSS.n112 83.5719
R299 VSS.n34 VSS.n33 73.1255
R300 VSS.n38 VSS.n37 73.1255
R301 VSS.n37 VSS.n36 73.1255
R302 VSS.n186 VSS.n18 73.1255
R303 VSS.n187 VSS.n186 73.1255
R304 VSS.n191 VSS.n190 73.1255
R305 VSS.n190 VSS.n189 73.1255
R306 VSS.n43 VSS.n42 73.1255
R307 VSS.n44 VSS.n43 73.1255
R308 VSS.n41 VSS.n40 73.1255
R309 VSS.n40 VSS.n39 73.1255
R310 VSS.n171 VSS.n16 73.1255
R311 VSS.n172 VSS.n171 73.1255
R312 VSS.n169 VSS.n50 73.1255
R313 VSS.n50 VSS.n49 73.1255
R314 VSS.n181 VSS.n21 73.1255
R315 VSS.n182 VSS.n181 73.1255
R316 VSS.n179 VSS.n15 73.1255
R317 VSS.n179 VSS.n178 73.1255
R318 VSS.n168 VSS.n167 73.1255
R319 VSS.n167 VSS.n166 73.1255
R320 VSS.n163 VSS.n162 73.1255
R321 VSS.n164 VSS.n163 73.1255
R322 VSS.n149 VSS.n14 73.1255
R323 VSS.n150 VSS.n149 73.1255
R324 VSS.n147 VSS.n61 73.1255
R325 VSS.n61 VSS.n60 73.1255
R326 VSS.n161 VSS.n160 73.1255
R327 VSS.n160 VSS.n159 73.1255
R328 VSS.n156 VSS.n13 73.1255
R329 VSS.n157 VSS.n156 73.1255
R330 VSS.n146 VSS.n145 73.1255
R331 VSS.n145 VSS.n144 73.1255
R332 VSS.n141 VSS.n140 73.1255
R333 VSS.n142 VSS.n141 73.1255
R334 VSS.n127 VSS.n12 73.1255
R335 VSS.n128 VSS.n127 73.1255
R336 VSS.n125 VSS.n72 73.1255
R337 VSS.n72 VSS.n71 73.1255
R338 VSS.n139 VSS.n138 73.1255
R339 VSS.n138 VSS.n137 73.1255
R340 VSS.n134 VSS.n11 73.1255
R341 VSS.n135 VSS.n134 73.1255
R342 VSS.n124 VSS.n123 73.1255
R343 VSS.n123 VSS.n122 73.1255
R344 VSS.n119 VSS.n118 73.1255
R345 VSS.n120 VSS.n119 73.1255
R346 VSS.n98 VSS.n97 73.1255
R347 VSS.n99 VSS.n98 73.1255
R348 VSS.n96 VSS.n95 73.1255
R349 VSS.n95 VSS.n94 73.1255
R350 VSS.n106 VSS.n7 73.1255
R351 VSS.n107 VSS.n106 73.1255
R352 VSS.n103 VSS.n10 73.1255
R353 VSS.n104 VSS.n103 73.1255
R354 VSS.n91 VSS.n86 67.3887
R355 VSS.n204 VSS.n203 67.3887
R356 VSS.n31 VSS.n30 50.5605
R357 VSS.n87 VSS.n86 50.5605
R358 VSS.n204 VSS.n0 50.5605
R359 VSS.n110 VSS.n109 50.5605
R360 VSS.n108 VSS.n102 50.5605
R361 VSS.n100 VSS.n80 50.5605
R362 VSS.n76 VSS.n75 50.5605
R363 VSS.n133 VSS.n132 50.5605
R364 VSS.n129 VSS.n68 50.5605
R365 VSS.n65 VSS.n64 50.5605
R366 VSS.n155 VSS.n154 50.5605
R367 VSS.n151 VSS.n57 50.5605
R368 VSS.n54 VSS.n53 50.5605
R369 VSS.n183 VSS.n175 50.5605
R370 VSS.n173 VSS.n46 50.5605
R371 VSS.n45 VSS.n23 50.5605
R372 VSS.n185 VSS.n22 50.5605
R373 VSS.n32 VSS.t18 21.1205
R374 VSS.n38 VSS.n27 14.3327
R375 VSS VSS.t23 2.40298
R376 VSS.n101 VSS.t15 2.3411
R377 VSS.n130 VSS.t7 2.3411
R378 VSS.n152 VSS.t9 2.3411
R379 VSS.n174 VSS.t5 2.3411
R380 VSS.t3 VSS.t13 2.3317
R381 VSS.t3 VSS.n184 2.3317
R382 VSS.n153 VSS.t5 2.3317
R383 VSS.n131 VSS.t9 2.3317
R384 VSS.t25 VSS.t7 2.3317
R385 VSS.t23 VSS.t15 2.3317
R386 VSS.t22 VSS.n200 2.26967
R387 VSS.t13 VSS.t19 2.13743
R388 VSS.n79 VSS.n101 1.1661
R389 VSS.n131 VSS.n130 1.1661
R390 VSS.n153 VSS.n152 1.1661
R391 VSS.n184 VSS.n174 1.1661
R392 VSS.t25 VSS.n79 1.1567
C0 DEC0 EVAL_GND 5.30799f
C1 net3 net1 0.12454f
C2 A1B A0T 5.35124f
C3 PCLK EVAL_GND 0.81349f
C4 VDD EVAL_GND 0.29619f
C5 DEC1 N3 0.12548f
C6 A0T A1T 5.35865f
C7 A0 N1 0.24554f
C8 net1 net2 5.2266f
C9 DEC3 A1B 0.12156f
C10 DEC2 N3 0.13045f
C11 DEC3 A1T 0.12156f
C12 N2 N3 5.4246f
C13 net1 A1 0.11611f
C14 A0B N3 0.2457f
C15 net4 net1 0.12416f
C16 N0 N1 5.40993f
C17 A0 N0 0.24554f
C18 N3 DEC0 0.12596f
C19 net1 DEC1 0.12548f
C20 PCLK N3 0.58097f
C21 VDD N3 2.0714f
C22 DEC3 A0T 0.12179f
C23 EVAL_GND N1 0.30805f
C24 A0 EVAL_GND 0.28412f
C25 DEC2 net1 0.12548f
C26 net3 A1B 0.11676f
C27 net1 N2 0.12505f
C28 net1 A0B 0.70616f
C29 net3 A1T 2.05105f
C30 net1 DEC0 0.12606f
C31 A1B net2 1.95039f
C32 EVAL_GND N0 0.30786f
C33 net2 A1T 0.1227f
C34 PCLK net1 0.11614f
C35 VDD net1 0.12253f
C36 A1 A1B 1.24035f
C37 net3 A0T 0.11676f
C38 net4 A1B 0.11611f
C39 N3 N1 0.24789f
C40 A1 A1T 0.23017f
C41 A0 N3 0.24554f
C42 net4 A1T 2.05105f
C43 net3 DEC3 0.12548f
C44 A0T net2 0.74543f
C45 DEC1 A1B 0.12156f
C46 DEC1 A1T 0.12156f
C47 DEC3 net2 0.12548f
C48 N3 N0 0.24714f
C49 A1 A0T 0.23033f
C50 DEC2 A1B 0.12156f
C51 N2 A1B 0.24582f
C52 net4 A0T 0.7395f
C53 A0B A1B 5.48408f
C54 DEC2 A1T 0.12156f
C55 N2 A1T 0.88607f
C56 net1 N1 0.12438f
C57 A1 DEC3 0.12156f
C58 A0B A1T 0.26774f
C59 A0 net1 0.11611f
C60 DEC1 A0T 0.12176f
C61 net4 DEC3 0.12561f
C62 A1B DEC0 0.12204f
C63 N3 EVAL_GND 0.30826f
C64 DEC0 A1T 0.12204f
C65 PCLK A1B 0.35206f
C66 VDD A1B 1.95476f
C67 DEC3 DEC1 0.12668f
C68 PCLK A1T 0.23012f
C69 VDD A1T 0.78989f
C70 DEC2 A0T 0.12156f
C71 net1 N0 0.33586f
C72 N2 A0T 0.24585f
C73 A0B A0T 1.2307f
C74 net3 net2 5.2266f
C75 DEC2 DEC3 5.22874f
C76 N2 DEC3 0.12156f
C77 DEC0 A0T 0.12204f
C78 A0B DEC3 0.12156f
C79 PCLK A0T 0.23022f
C80 net1 EVAL_GND 0.58345f
C81 net3 A1 0.11611f
C82 VDD A0T 0.78993f
C83 net3 net4 5.2266f
C84 DEC3 DEC0 0.12631f
C85 PCLK DEC3 0.12156f
C86 VDD DEC3 0.67042f
C87 A1 net2 0.11611f
C88 net3 DEC1 0.12563f
C89 A1B N1 0.85261f
C90 net4 net2 0.12454f
C91 A0 A1B 0.36629f
C92 A1T N1 0.24751f
C93 A0 A1T 0.2301f
C94 DEC1 net2 0.12561f
C95 net4 A1 0.11611f
C96 DEC2 net3 0.12561f
C97 net3 N2 0.33586f
C98 net3 A0B 0.70616f
C99 net1 N3 5.22944f
C100 A1B N0 0.86331f
C101 A1 DEC1 0.12156f
C102 DEC2 net2 0.12548f
C103 N0 A1T 5.35295f
C104 A0T N1 0.24692f
C105 net3 DEC0 0.12624f
C106 net4 DEC1 0.12576f
C107 N2 net2 0.12438f
C108 A0 A0T 0.23017f
C109 A0B net2 0.11611f
C110 net3 PCLK 0.11612f
C111 VDD net3 0.12256f
C112 DEC3 N1 0.12156f
C113 DEC2 A1 0.12156f
C114 A1B EVAL_GND 0.29623f
C115 DEC0 net2 0.12611f
C116 N2 A1 0.24554f
C117 A0 DEC3 0.12156f
C118 DEC2 net4 0.12563f
C119 A0B A1 5.45963f
C120 net4 N2 0.12287f
C121 EVAL_GND A1T 0.3081f
C122 PCLK net2 0.11612f
C123 VDD net2 0.12256f
C124 net4 A0B 0.11611f
C125 A0T N0 0.24789f
C126 A1 DEC0 0.12204f
C127 DEC2 DEC1 5.22874f
C128 N2 DEC1 0.13045f
C129 net4 DEC0 0.12661f
C130 A0B DEC1 0.12156f
C131 PCLK A1 0.12331f
C132 VDD A1 1.30081f
C133 DEC3 N0 0.12156f
C134 net4 PCLK 0.11612f
C135 VDD net4 0.12256f
C136 DEC1 DEC0 5.22874f
C137 EVAL_GND A0T 4.06378f
C138 DEC2 N2 1.36331f
C139 DEC2 A0B 0.12176f
C140 PCLK DEC1 0.12156f
C141 VDD DEC1 0.67042f
C142 N2 A0B 0.2457f
C143 N3 A1B 0.24554f
C144 net3 N1 0.12287f
C145 DEC3 EVAL_GND 0.25943f
C146 A0 net3 0.11611f
C147 N3 A1T 0.88619f
C148 DEC2 DEC0 0.12668f
C149 N2 DEC0 0.12596f
C150 A0B DEC0 0.12204f
C151 DEC2 PCLK 0.12156f
C152 DEC2 VDD 0.67042f
C153 net2 N1 0.34836f
C154 PCLK N2 0.58112f
C155 VDD N2 2.0714f
C156 PCLK A0B 0.35732f
C157 A0 net2 0.11611f
C158 VDD A0B 1.95615f
C159 net3 N0 0.1227f
C160 PCLK DEC0 0.12909f
C161 A1 N1 0.24554f
C162 VDD DEC0 0.67042f
C163 N3 A0T 0.28897f
C164 A0 A1 5.22461f
C165 net4 N1 0.1227f
C166 net1 A1B 1.95105f
C167 VDD PCLK 5.42893f
C168 A0 net4 0.11611f
C169 N0 net2 0.12287f
C170 net1 A1T 0.12287f
C171 DEC3 N3 1.40379f
C172 DEC1 N1 1.32283f
C173 net3 EVAL_GND 0.61147f
C174 A0 DEC1 0.12156f
C175 A1 N0 0.26731f
C176 net4 N0 0.1227f
C177 EVAL_GND net2 0.57229f
C178 DEC2 N1 0.12156f
C179 N2 N1 5.41708f
C180 DEC2 A0 0.12156f
C181 net1 A0T 0.1227f
C182 A0B N1 0.24582f
C183 A0 N2 0.24554f
C184 A0 A0B 1.19949f
C185 DEC1 N0 0.12156f
C186 A1 EVAL_GND 0.28412f
C187 DEC0 N1 0.13093f
C188 net4 EVAL_GND 5.70321f
C189 net1 DEC3 0.12548f
C190 A0 DEC0 0.12204f
C191 PCLK N1 0.58112f
C192 VDD N1 2.0714f
C193 net3 N3 0.12438f
C194 DEC2 N0 0.12156f
C195 A0 PCLK 5.22872f
C196 VDD A0 1.30178f
C197 N2 N0 0.24751f
C198 DEC1 EVAL_GND 0.26051f
C199 A0B N0 0.24628f
C200 N3 net2 0.12505f
C201 DEC0 N0 1.28284f
C202 A1B A1T 1.27148f
C203 DEC2 EVAL_GND 0.25971f
C204 PCLK N0 0.58128f
C205 N2 EVAL_GND 0.30805f
C206 VDD N0 2.0714f
C207 A0B EVAL_GND 3.85222f
C208 A1 N3 0.24554f
C209 net4 N3 0.34836f
C210 DEC3 VSS 31.46128f
C211 DEC2 VSS 18.43815f
C212 DEC1 VSS 18.11735f
C213 DEC0 VSS 21.8834f
C214 VDD VSS 85.82187f
C215 net4 VSS 20.87525f
C216 net3 VSS 19.51783f
C217 net2 VSS 16.2877f
C218 EVAL_GND VSS 36.42005f
C219 net1 VSS 11.96649f
C220 N2 VSS 1.02113f
C221 VSS.t23 VSS 4.01511f
C222 VSS.t15 VSS 4.08453f
C223 VSS.t5 VSS 7.34695f
C224 VSS.t3 VSS 5.25772f
C225 VSS.t19 VSS 8.3732f
.ends row_decoder

* expanding   symbol:  wl_driver.sym # of pins=4
** sym_path: /work/cells/wordline_driver/wl_driver.sym
** sch_path: /work/cells/wordline_driver/wl_driver.sch
.subckt wl_driver VDD WL_IN WL VSS
*.iopin VDD
*.iopin VSS
*.iopin WL_IN
*.iopin WL
XMP1 WL_N WL_IN VDD VDD sky130_fd_pr__pfet_01v8 L=0.15 W=0.42 nf=1 ad='int((nf+1)/2) * W/nf * 0.29' as='int((nf+2)/2) * W/nf * 0.29'
+ pd='2*int((nf+1)/2) * (W/nf + 0.29)' ps='2*int((nf+2)/2) * (W/nf + 0.29)' nrd='0.29 / W' nrs='0.29 / W' sa=0 sb=0 sd=0 mult=1 m=1
XMN1 WL_N WL_IN VSS VSS sky130_fd_pr__nfet_01v8 L=0.15 W=0.42 nf=1 ad='int((nf+1)/2) * W/nf * 0.29' as='int((nf+2)/2) * W/nf * 0.29'
+ pd='2*int((nf+1)/2) * (W/nf + 0.29)' ps='2*int((nf+2)/2) * (W/nf + 0.29)' nrd='0.29 / W' nrs='0.29 / W' sa=0 sb=0 sd=0 mult=1 m=1
XMP2 WL WL_N VDD VDD sky130_fd_pr__pfet_01v8 L=0.15 W=0.84 nf=1 ad='int((nf+1)/2) * W/nf * 0.29' as='int((nf+2)/2) * W/nf * 0.29' pd='2*int((nf+1)/2) * (W/nf + 0.29)'
+ ps='2*int((nf+2)/2) * (W/nf + 0.29)' nrd='0.29 / W' nrs='0.29 / W' sa=0 sb=0 sd=0 mult=1 m=1
XMN2 WL WL_N VSS VSS sky130_fd_pr__nfet_01v8 L=0.15 W=0.84 nf=1 ad='int((nf+1)/2) * W/nf * 0.29' as='int((nf+2)/2) * W/nf * 0.29' pd='2*int((nf+1)/2) * (W/nf + 0.29)'
+ ps='2*int((nf+2)/2) * (W/nf + 0.29)' nrd='0.29 / W' nrs='0.29 / W' sa=0 sb=0 sd=0 mult=1 m=1
.ends

.GLOBAL GND

.lib "/opt/pdks/sky130A/libs.tech/combined/continuous/sky130.lib.spice" tt
.temp 27
.options method=gear
.save v(dec0) v(dec1) v(dec2) v(dec3) v(net1) v(net2) v(net3) v(net4) v(net5) v(net6) v(net7) v(net8) v(x1.a0b) v(x1.a0t) v(x1.a1b) v(x1.a1t) v(x1.eval_gnd) v(x1.n0) v(x1.n1) v(x1.n2) v(x1.n3) v(x1.net1) v(x1.net2) v(x1.net3) v(x1.net4) v(x1.vss.t0) v(x1.vss.t1) v(x1.vss.t10) v(x1.vss.t11) v(x1.vss.t12) v(x1.vss.t13) v(x1.vss.t14) v(x1.vss.t15) v(x1.vss.t16) v(x1.vss.t17) v(x1.vss.t18) v(x1.vss.t19) v(x1.vss.t2) v(x1.vss.t20) v(x1.vss.t21) v(x1.vss.t22) v(x1.vss.t23) v(x1.vss.t24) v(x1.vss.t25) v(x1.vss.t3) v(x1.vss.t4) v(x1.vss.t5) v(x1.vss.t6) v(x1.vss.t7) v(x1.vss.t8) v(x1.vss.t9) v(x2.wl_n) v(x3.wl_n) v(x4.wl_n) v(x5.wl_n) i(VDD_SRC) i(VPCLK) i(VA0) i(VA1) v(x1.n0) v(x1.n1) v(x1.n2) v(x1.n3)
.tran 5p 3e-08 0 5e-12 uic
.control
set num_threads=1
run
write waveform.raw
quit 0
.endc
.end
