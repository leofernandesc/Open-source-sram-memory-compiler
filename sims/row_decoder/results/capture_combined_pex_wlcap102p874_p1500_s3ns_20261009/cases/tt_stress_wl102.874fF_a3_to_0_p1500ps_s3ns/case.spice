** sch_path: /work/sims/row_decoder/tb_row_decoder_sizing.sch
**.subckt tb_row_decoder_sizing
x1 net1 net2 net3 net4 DEC0 DEC1 DEC3 DEC2 GND row_decoder
VDD_SRC net1 GND 1.8
VPCLK net2 GND PWL(0 0 4.9875e-09 0 5.0125e-09 1.8 9.9875e-09 1.8 1.00125e-08 0 1.64875e-08 0 1.65125e-08 1.8 1.99875e-08 1.8 2.00125e-08 0 2.5e-08 0)
VA0 net3 GND PWL(0 1.8 1.5275554449321e-08 1.8 1.5364082942535e-08 0 2.5e-08 0)
VA1 net4 GND PWL(0 1.8 1.5275554449321e-08 1.8 1.5364082942535e-08 0 2.5e-08 0)
x2 net1 DEC0 net5 GND wl_driver
x3 net1 DEC1 net6 GND wl_driver
x4 net1 DEC3 net8 GND wl_driver
x5 net1 DEC2 net7 GND wl_driver
C_WL0 net5 GND 1.02873935496e-13 m=1
C_WL1 net6 GND 1.02873935496e-13 m=1
C_WL2 net7 GND 1.02873935496e-13 m=1
C_WL3 net8 GND 1.02873935496e-13 m=1
**.ends

* expanding   symbol:  row_decoder.sym # of pins=9
** sym_path: /work/cells/row_decoder/row_decoder.sym
** sch_path: /work/cells/row_decoder/row_decoder.sch
.subckt row_decoder VDD PCLK A0 A1 DEC0 DEC1 DEC3 DEC2 VSS
X0 VSS.t25 PCLK.t0 EVAL_GND.t4 VSS.t24 sky130_fd_pr__nfet_01v8 ad=0.435 pd=3.58 as=0.435 ps=3.58 w=1.5 l=0.15
X1 net4.t1 A1T.t2 N3.t0 VSS.t13 sky130_fd_pr__nfet_01v8 ad=0.58 pd=4.58 as=0.58 ps=4.58 w=2 l=0.15
X2 VDD.t11 N3.t3 DEC3.t0 VDD.t10 sky130_fd_pr__pfet_01v8 ad=0.87 pd=6.58 as=0.87 ps=6.58 w=3 l=0.15
X3 net1.t1 A1B.t3 N0.t0 VSS.t8 sky130_fd_pr__nfet_01v8 ad=0.58 pd=4.58 as=0.58 ps=4.58 w=2 l=0.15
X4 VSS.t23 A0.t0 A0B.t1 VSS.t22 sky130_fd_pr__nfet_01v8 ad=0.2436 pd=2.26 as=0.2436 ps=2.26 w=0.84 l=0.15
X5 VDD.t3 N1.t3 DEC1.t1 VDD.t2 sky130_fd_pr__pfet_01v8 ad=0.87 pd=6.58 as=0.87 ps=6.58 w=3 l=0.15
X6 VSS.t17 N2.t2 DEC2.t1 VSS.t16 sky130_fd_pr__nfet_01v8 ad=0.58 pd=4.58 as=0.58 ps=4.58 w=2 l=0.15
X7 VSS.t10 A1B.t4 A1T.t0 VSS.t9 sky130_fd_pr__nfet_01v8 ad=0.58 pd=4.58 as=0.58 ps=4.58 w=2 l=0.15
X8 EVAL_GND.t1 A0B.t2 net3.t0 VSS.t1 sky130_fd_pr__nfet_01v8 ad=0.58 pd=4.58 as=0.58 ps=4.58 w=2 l=0.15
X9 VDD.t17 PCLK.t2 N2.t1 VDD.t16 sky130_fd_pr__pfet_01v8 ad=0.3625 pd=3.08 as=0.3625 ps=3.08 w=1.25 l=0.15
X10 VDD.t13 A1.t1 A1B.t0 VDD.t12 sky130_fd_pr__pfet_01v8 ad=0.2436 pd=2.26 as=0.2436 ps=2.26 w=0.84 l=0.15
X11 VDD.t7 A1B.t5 A1T.t1 VDD.t6 sky130_fd_pr__pfet_01v8 ad=0.58 pd=4.58 as=0.58 ps=4.58 w=2 l=0.15
X12 VDD.t21 PCLK.t4 N0.t1 VDD.t20 sky130_fd_pr__pfet_01v8 ad=0.3625 pd=3.08 as=0.3625 ps=3.08 w=1.25 l=0.15
X13 net3.t1 A1T.t3 N2.t0 VSS.t6 sky130_fd_pr__nfet_01v8 ad=0.58 pd=4.58 as=0.58 ps=4.58 w=2 l=0.15
X14 VDD.t15 A0.t1 A0B.t0 VDD.t14 sky130_fd_pr__pfet_01v8 ad=0.2436 pd=2.26 as=0.2436 ps=2.26 w=0.84 l=0.15
X15 VSS.t15 A0B.t4 A0T.t1 VSS.t14 sky130_fd_pr__nfet_01v8 ad=0.58 pd=4.58 as=0.58 ps=4.58 w=2 l=0.15
X16 VDD.t9 A0B.t5 A0T.t0 VDD.t8 sky130_fd_pr__pfet_01v8 ad=0.58 pd=4.58 as=0.58 ps=4.58 w=2 l=0.15
X17 VDD.t19 PCLK.t3 N1.t1 VDD.t18 sky130_fd_pr__pfet_01v8 ad=0.3625 pd=3.08 as=0.3625 ps=3.08 w=1.25 l=0.15
X18 VSS.t3 N1.t2 DEC1.t0 VSS.t2 sky130_fd_pr__nfet_01v8 ad=0.58 pd=4.58 as=0.58 ps=4.58 w=2 l=0.15
X19 net2.t0 A1B.t2 N1.t0 VSS.t7 sky130_fd_pr__nfet_01v8 ad=0.58 pd=4.58 as=0.58 ps=4.58 w=2 l=0.15
X20 VDD.t23 PCLK.t1 N3.t1 VDD.t22 sky130_fd_pr__pfet_01v8 ad=0.3625 pd=3.08 as=0.3625 ps=3.08 w=1.25 l=0.15
X21 VSS.t21 N3.t2 DEC3.t1 VSS.t20 sky130_fd_pr__nfet_01v8 ad=0.58 pd=4.58 as=0.58 ps=4.58 w=2 l=0.15
X22 EVAL_GND.t3 A0T.t3 net2.t1 VSS.t12 sky130_fd_pr__nfet_01v8 ad=0.58 pd=4.58 as=0.58 ps=4.58 w=2 l=0.15
X23 VSS.t5 N0.t2 DEC0.t0 VSS.t4 sky130_fd_pr__nfet_01v8 ad=0.58 pd=4.58 as=0.58 ps=4.58 w=2 l=0.15
X24 VDD.t5 N0.t3 DEC0.t1 VDD.t4 sky130_fd_pr__pfet_01v8 ad=0.87 pd=6.58 as=0.87 ps=6.58 w=3 l=0.15
X25 VSS.t19 A1.t0 A1B.t1 VSS.t18 sky130_fd_pr__nfet_01v8 ad=0.2436 pd=2.26 as=0.2436 ps=2.26 w=0.84 l=0.15
X26 EVAL_GND.t2 A0T.t2 net4.t0 VSS.t11 sky130_fd_pr__nfet_01v8 ad=0.58 pd=4.58 as=0.58 ps=4.58 w=2 l=0.15
X27 VDD.t1 N2.t3 DEC2.t0 VDD.t0 sky130_fd_pr__pfet_01v8 ad=0.87 pd=6.58 as=0.87 ps=6.58 w=3 l=0.15
X28 EVAL_GND.t0 A0B.t3 net1.t0 VSS.t0 sky130_fd_pr__nfet_01v8 ad=0.58 pd=4.58 as=0.58 ps=4.58 w=2 l=0.15
R0 DEC3.n0 DEC3.t0 88.9801
R1 DEC3.n0 DEC3.t1 50.6916
R2 DEC3 DEC3.n0 7.45705
R3 DEC2.n0 DEC2.t0 88.9801
R4 DEC2.n0 DEC2.t1 50.6916
R5 DEC2 DEC2.n0 7.45705
R6 DEC1.n0 DEC1.t1 88.9801
R7 DEC1.n0 DEC1.t0 50.6916
R8 DEC1 DEC1.n0 7.45705
R9 DEC0.n0 DEC0.t1 88.9801
R10 DEC0.n0 DEC0.t0 50.6916
R11 DEC0 DEC0.n0 7.45705
R12 PCLK.n1 PCLK.t0 245.213
R13 PCLK.n0 PCLK.t1 230.785
R14 PCLK.n3 PCLK.t4 228.208
R15 PCLK.n2 PCLK.t3 228.208
R16 PCLK.n0 PCLK.t2 228.208
R17 PCLK PCLK.n3 4.36288
R18 PCLK.n3 PCLK.n2 2.5761
R19 PCLK.n2 PCLK.n1 2.3411
R20 PCLK.n1 PCLK.n0 1.08777
R21 A1.n0 A1.t1 191.999
R22 A1.n0 A1.t0 186.636
R23 A1 A1.n0 2.40455
R24 A0.n0 A0.t1 192.624
R25 A0.n0 A0.t0 186.011
R26 A0 A0.n0 0.681217
R27 VDD.n5 VDD.n3 2142.35
R28 VDD.n8 VDD.n7 2142.35
R29 VDD.n30 VDD.n28 2142.35
R30 VDD.n33 VDD.n32 2142.35
R31 VDD.n56 VDD.n54 2142.35
R32 VDD.n59 VDD.n58 2142.35
R33 VDD.n82 VDD.n80 2142.35
R34 VDD.n85 VDD.n84 2142.35
R35 VDD.n108 VDD.n106 1789.41
R36 VDD.n111 VDD.n110 1789.41
R37 VDD.n134 VDD.n132 1789.41
R38 VDD.n137 VDD.n136 1789.41
R39 VDD.n17 VDD.n15 1524.71
R40 VDD.n20 VDD.n19 1524.71
R41 VDD.n43 VDD.n41 1524.71
R42 VDD.n46 VDD.n45 1524.71
R43 VDD.n69 VDD.n67 1524.71
R44 VDD.n72 VDD.n71 1524.71
R45 VDD.n95 VDD.n93 1524.71
R46 VDD.n98 VDD.n97 1524.71
R47 VDD.n121 VDD.n119 1380
R48 VDD.n124 VDD.n123 1380
R49 VDD.n147 VDD.n145 1380
R50 VDD.n150 VDD.n149 1380
R51 VDD.n128 VDD.t13 341.161
R52 VDD.n154 VDD.t15 341.161
R53 VDD.n24 VDD.t23 230.952
R54 VDD.n50 VDD.t17 230.952
R55 VDD.n76 VDD.t19 230.952
R56 VDD.n102 VDD.t21 230.952
R57 VDD.n4 VDD.n0 228.518
R58 VDD.n4 VDD.n1 228.518
R59 VDD.n29 VDD.n25 228.518
R60 VDD.n29 VDD.n26 228.518
R61 VDD.n55 VDD.n51 228.518
R62 VDD.n55 VDD.n52 228.518
R63 VDD.n81 VDD.n77 228.518
R64 VDD.n81 VDD.n78 228.518
R65 VDD.n9 VDD.n1 227.388
R66 VDD.n34 VDD.n26 227.388
R67 VDD.n60 VDD.n52 227.388
R68 VDD.n86 VDD.n78 227.388
R69 VDD.n123 VDD.n122 223.581
R70 VDD.n119 VDD.n118 223.581
R71 VDD.n149 VDD.n148 223.581
R72 VDD.n145 VDD.n144 223.581
R73 VDD.n19 VDD.n18 203.438
R74 VDD.n15 VDD.n14 203.438
R75 VDD.n45 VDD.n44 203.438
R76 VDD.n41 VDD.n40 203.438
R77 VDD.n71 VDD.n70 203.438
R78 VDD.n67 VDD.n66 203.438
R79 VDD.n97 VDD.n96 203.438
R80 VDD.n93 VDD.n92 203.438
R81 VDD.n107 VDD.n103 190.871
R82 VDD.n107 VDD.n104 190.871
R83 VDD.n133 VDD.n129 190.871
R84 VDD.n133 VDD.n130 190.871
R85 VDD.n112 VDD.n104 189.742
R86 VDD.n138 VDD.n130 189.742
R87 VDD.n110 VDD.n109 173.642
R88 VDD.n106 VDD.n105 173.642
R89 VDD.n136 VDD.n135 173.642
R90 VDD.n132 VDD.n131 173.642
R91 VDD.n10 VDD.n0 167.906
R92 VDD.n35 VDD.n25 167.906
R93 VDD.n61 VDD.n51 167.906
R94 VDD.n87 VDD.n77 167.906
R95 VDD.n16 VDD.n12 162.636
R96 VDD.n16 VDD.n13 162.636
R97 VDD.n42 VDD.n38 162.636
R98 VDD.n42 VDD.n39 162.636
R99 VDD.n68 VDD.n64 162.636
R100 VDD.n68 VDD.n65 162.636
R101 VDD.n94 VDD.n90 162.636
R102 VDD.n94 VDD.n91 162.636
R103 VDD.n21 VDD.n13 161.506
R104 VDD.n47 VDD.n39 161.506
R105 VDD.n73 VDD.n65 161.506
R106 VDD.n99 VDD.n91 161.506
R107 VDD.n120 VDD.n116 147.201
R108 VDD.n120 VDD.n117 147.201
R109 VDD.n146 VDD.n142 147.201
R110 VDD.n146 VDD.n143 147.201
R111 VDD.n125 VDD.n117 146.071
R112 VDD.n151 VDD.n143 146.071
R113 VDD.n7 VDD.n6 144.319
R114 VDD.n3 VDD.n2 144.319
R115 VDD.n32 VDD.n31 144.319
R116 VDD.n28 VDD.n27 144.319
R117 VDD.n58 VDD.n57 144.319
R118 VDD.n54 VDD.n53 144.319
R119 VDD.n84 VDD.n83 144.319
R120 VDD.n80 VDD.n79 144.319
R121 VDD.n113 VDD.n103 130.26
R122 VDD.n139 VDD.n129 130.26
R123 VDD.n127 VDD.n126 124.421
R124 VDD.n153 VDD.n152 124.421
R125 VDD.n23 VDD.n22 124.335
R126 VDD.n49 VDD.n48 124.335
R127 VDD.n75 VDD.n74 124.335
R128 VDD.n101 VDD.n100 124.335
R129 VDD.n114 VDD.n113 124.178
R130 VDD.n140 VDD.n139 124.178
R131 VDD.n11 VDD.n10 124.165
R132 VDD.n36 VDD.n35 123.971
R133 VDD.n62 VDD.n61 123.971
R134 VDD.n88 VDD.n87 123.971
R135 VDD.n115 VDD.t7 123.638
R136 VDD.n141 VDD.t9 123.638
R137 VDD.n22 VDD.n12 102.025
R138 VDD.n48 VDD.n38 102.025
R139 VDD.n74 VDD.n64 102.025
R140 VDD.n100 VDD.n90 102.025
R141 VDD.n11 VDD.t11 93.8026
R142 VDD.n37 VDD.t1 93.8026
R143 VDD.n63 VDD.t3 93.8026
R144 VDD.n89 VDD.t5 93.8026
R145 VDD.n9 VDD.n8 92.5005
R146 VDD.n5 VDD.n4 92.5005
R147 VDD.n21 VDD.n20 92.5005
R148 VDD.n17 VDD.n16 92.5005
R149 VDD.n34 VDD.n33 92.5005
R150 VDD.n30 VDD.n29 92.5005
R151 VDD.n47 VDD.n46 92.5005
R152 VDD.n43 VDD.n42 92.5005
R153 VDD.n60 VDD.n59 92.5005
R154 VDD.n56 VDD.n55 92.5005
R155 VDD.n73 VDD.n72 92.5005
R156 VDD.n69 VDD.n68 92.5005
R157 VDD.n86 VDD.n85 92.5005
R158 VDD.n82 VDD.n81 92.5005
R159 VDD.n99 VDD.n98 92.5005
R160 VDD.n95 VDD.n94 92.5005
R161 VDD.n112 VDD.n111 92.5005
R162 VDD.n108 VDD.n107 92.5005
R163 VDD.n125 VDD.n124 92.5005
R164 VDD.n121 VDD.n120 92.5005
R165 VDD.n138 VDD.n137 92.5005
R166 VDD.n134 VDD.n133 92.5005
R167 VDD.n151 VDD.n150 92.5005
R168 VDD.n147 VDD.n146 92.5005
R169 VDD.n126 VDD.n116 86.5887
R170 VDD.n152 VDD.n142 86.5887
R171 VDD.n6 VDD.n5 82.6992
R172 VDD.n8 VDD.n2 82.6992
R173 VDD.n31 VDD.n30 82.6992
R174 VDD.n33 VDD.n27 82.6992
R175 VDD.n57 VDD.n56 82.6992
R176 VDD.n59 VDD.n53 82.6992
R177 VDD.n83 VDD.n82 82.6992
R178 VDD.n85 VDD.n79 82.6992
R179 VDD.n109 VDD.n108 79.4196
R180 VDD.n111 VDD.n105 79.4196
R181 VDD.n135 VDD.n134 79.4196
R182 VDD.n137 VDD.n131 79.4196
R183 VDD.n18 VDD.n17 75.5742
R184 VDD.n20 VDD.n14 75.5742
R185 VDD.n44 VDD.n43 75.5742
R186 VDD.n46 VDD.n40 75.5742
R187 VDD.n70 VDD.n69 75.5742
R188 VDD.n72 VDD.n66 75.5742
R189 VDD.n96 VDD.n95 75.5742
R190 VDD.n98 VDD.n92 75.5742
R191 VDD.n122 VDD.n121 72.6454
R192 VDD.n124 VDD.n118 72.6454
R193 VDD.n148 VDD.n147 72.6454
R194 VDD.n150 VDD.n144 72.6454
R195 VDD.n10 VDD.n9 50.5605
R196 VDD.n22 VDD.n21 50.5605
R197 VDD.n35 VDD.n34 50.5605
R198 VDD.n48 VDD.n47 50.5605
R199 VDD.n61 VDD.n60 50.5605
R200 VDD.n74 VDD.n73 50.5605
R201 VDD.n87 VDD.n86 50.5605
R202 VDD.n100 VDD.n99 50.5605
R203 VDD.n113 VDD.n112 50.5605
R204 VDD.n126 VDD.n125 50.5605
R205 VDD.n139 VDD.n138 50.5605
R206 VDD.n152 VDD.n151 50.5605
R207 VDD.n119 VDD.n116 37.0005
R208 VDD.n123 VDD.n117 37.0005
R209 VDD.n145 VDD.n142 37.0005
R210 VDD.n149 VDD.n143 37.0005
R211 VDD.n15 VDD.n12 30.8338
R212 VDD.n19 VDD.n13 30.8338
R213 VDD.n41 VDD.n38 30.8338
R214 VDD.n45 VDD.n39 30.8338
R215 VDD.n67 VDD.n64 30.8338
R216 VDD.n71 VDD.n65 30.8338
R217 VDD.n93 VDD.n90 30.8338
R218 VDD.n97 VDD.n91 30.8338
R219 VDD.n106 VDD.n103 23.1255
R220 VDD.n110 VDD.n104 23.1255
R221 VDD.n132 VDD.n129 23.1255
R222 VDD.n136 VDD.n130 23.1255
R223 VDD.n3 VDD.n0 16.8187
R224 VDD.n7 VDD.n1 16.8187
R225 VDD.n28 VDD.n25 16.8187
R226 VDD.n32 VDD.n26 16.8187
R227 VDD.n54 VDD.n51 16.8187
R228 VDD.n58 VDD.n52 16.8187
R229 VDD.n80 VDD.n77 16.8187
R230 VDD.n84 VDD.n78 16.8187
R231 VDD.t12 VDD.n118 14.9873
R232 VDD.n122 VDD.t12 14.9873
R233 VDD.t14 VDD.n144 14.9873
R234 VDD.n148 VDD.t14 14.9873
R235 VDD.t22 VDD.n14 12.343
R236 VDD.n18 VDD.t22 12.343
R237 VDD.t16 VDD.n40 12.343
R238 VDD.n44 VDD.t16 12.343
R239 VDD.t18 VDD.n66 12.343
R240 VDD.n70 VDD.t18 12.343
R241 VDD.t20 VDD.n92 12.343
R242 VDD.n96 VDD.t20 12.343
R243 VDD.t6 VDD.n105 8.97701
R244 VDD.n109 VDD.t6 8.97701
R245 VDD.t8 VDD.n131 8.97701
R246 VDD.n135 VDD.t8 8.97701
R247 VDD.t10 VDD.n2 6.23219
R248 VDD.n6 VDD.t10 6.23219
R249 VDD.t0 VDD.n27 6.23219
R250 VDD.n31 VDD.t0 6.23219
R251 VDD.t2 VDD.n53 6.23219
R252 VDD.n57 VDD.t2 6.23219
R253 VDD.t4 VDD.n79 6.23219
R254 VDD.n83 VDD.t4 6.23219
R255 VDD.n101 VDD.n89 1.51077
R256 VDD.n75 VDD.n63 1.51077
R257 VDD.n62 VDD.n50 1.51077
R258 VDD.n49 VDD.n37 1.51077
R259 VDD.n23 VDD.n11 1.51077
R260 VDD VDD.n154 1.03372
R261 VDD.n153 VDD.n141 0.6491
R262 VDD.n140 VDD.n128 0.6491
R263 VDD.n127 VDD.n115 0.6491
R264 VDD.n114 VDD.n102 0.6491
R265 VDD.n88 VDD.n76 0.6491
R266 VDD.n36 VDD.n24 0.6491
R267 VDD.n154 VDD.n153 0.194767
R268 VDD.n141 VDD.n140 0.194767
R269 VDD.n128 VDD.n127 0.194767
R270 VDD.n115 VDD.n114 0.194767
R271 VDD.n102 VDD.n101 0.194767
R272 VDD.n89 VDD.n88 0.194767
R273 VDD.n76 VDD.n75 0.194767
R274 VDD.n63 VDD.n62 0.194767
R275 VDD.n50 VDD.n49 0.194767
R276 VDD.n37 VDD.n36 0.194767
R277 VDD.n24 VDD.n23 0.194767
R278 VSS.n209 VSS.n208 68998.2
R279 VSS.n209 VSS.t0 33969.3
R280 VSS.n111 VSS.n62 32122
R281 VSS.n161 VSS.n6 32122
R282 VSS.n61 VSS.t24 29359.7
R283 VSS.n61 VSS.t1 29359.7
R284 VSS.n213 VSS.n210 28983.9
R285 VSS.n210 VSS.t18 22828.4
R286 VSS.t11 VSS.n62 15531.2
R287 VSS.t12 VSS.n6 15531.2
R288 VSS.n90 VSS.n62 11244.8
R289 VSS.n61 VSS.n6 4108.66
R290 VSS.n62 VSS.n61 4108.66
R291 VSS.n209 VSS.n6 3485.34
R292 VSS.n95 VSS.n72 2885.47
R293 VSS.n91 VSS.n72 2885.47
R294 VSS.n95 VSS.n71 2885.47
R295 VSS.n91 VSS.n71 2885.47
R296 VSS.n202 VSS.n9 2885.47
R297 VSS.n206 VSS.n9 2885.47
R298 VSS.n202 VSS.n8 2885.47
R299 VSS.n206 VSS.n8 2885.47
R300 VSS.n188 VSS.n17 2885.47
R301 VSS.n192 VSS.n17 2885.47
R302 VSS.n188 VSS.n16 2885.47
R303 VSS.n192 VSS.n16 2885.47
R304 VSS.n174 VSS.n26 2885.47
R305 VSS.n170 VSS.n26 2885.47
R306 VSS.n174 VSS.n25 2885.47
R307 VSS.n170 VSS.n25 2885.47
R308 VSS.n24 VSS.n23 2885.47
R309 VSS.n177 VSS.n24 2885.47
R310 VSS.n23 VSS.n21 2885.47
R311 VSS.n177 VSS.n21 2885.47
R312 VSS.n167 VSS.n30 2885.47
R313 VSS.n163 VSS.n30 2885.47
R314 VSS.n167 VSS.n29 2885.47
R315 VSS.n163 VSS.n29 2885.47
R316 VSS.n152 VSS.n38 2885.47
R317 VSS.n148 VSS.n38 2885.47
R318 VSS.n152 VSS.n37 2885.47
R319 VSS.n148 VSS.n37 2885.47
R320 VSS.n159 VSS.n34 2885.47
R321 VSS.n155 VSS.n34 2885.47
R322 VSS.n159 VSS.n33 2885.47
R323 VSS.n155 VSS.n33 2885.47
R324 VSS.n145 VSS.n42 2885.47
R325 VSS.n141 VSS.n42 2885.47
R326 VSS.n145 VSS.n41 2885.47
R327 VSS.n141 VSS.n41 2885.47
R328 VSS.n124 VSS.n54 2885.47
R329 VSS.n120 VSS.n54 2885.47
R330 VSS.n124 VSS.n53 2885.47
R331 VSS.n120 VSS.n53 2885.47
R332 VSS.n131 VSS.n50 2885.47
R333 VSS.n127 VSS.n50 2885.47
R334 VSS.n131 VSS.n49 2885.47
R335 VSS.n127 VSS.n49 2885.47
R336 VSS.n117 VSS.n58 2885.47
R337 VSS.n113 VSS.n58 2885.47
R338 VSS.n117 VSS.n57 2885.47
R339 VSS.n113 VSS.n57 2885.47
R340 VSS.n102 VSS.n68 2885.47
R341 VSS.n98 VSS.n68 2885.47
R342 VSS.n102 VSS.n67 2885.47
R343 VSS.n98 VSS.n67 2885.47
R344 VSS.n109 VSS.n64 2885.47
R345 VSS.n105 VSS.n64 2885.47
R346 VSS.n109 VSS.n63 2885.47
R347 VSS.n105 VSS.n63 2885.47
R348 VSS.n210 VSS.n209 2865.26
R349 VSS.n138 VSS.n46 2595.76
R350 VSS.n134 VSS.n46 2595.76
R351 VSS.n138 VSS.n45 2595.76
R352 VSS.n134 VSS.n45 2595.76
R353 VSS.n195 VSS.n13 2213.35
R354 VSS.n199 VSS.n13 2213.35
R355 VSS.n195 VSS.n12 2213.35
R356 VSS.n199 VSS.n12 2213.35
R357 VSS.n212 VSS.n4 2213.35
R358 VSS.n215 VSS.n4 2213.35
R359 VSS.n212 VSS.n3 2213.35
R360 VSS.n215 VSS.n3 2213.35
R361 VSS.n214 VSS.n5 1484.98
R362 VSS.n194 VSS.n193 1484.98
R363 VSS.n201 VSS.n200 1484.98
R364 VSS.n97 VSS.n96 1446.19
R365 VSS.n119 VSS.n118 1446.19
R366 VSS.n140 VSS.n139 1446.19
R367 VSS.n147 VSS.n146 1446.19
R368 VSS.n169 VSS.n168 1446.19
R369 VSS.n104 VSS.n103 1438.53
R370 VSS.n133 VSS.n132 1438.53
R371 VSS.n126 VSS.n125 1438.53
R372 VSS.n154 VSS.n153 1438.53
R373 VSS.n176 VSS.n175 1438.53
R374 VSS.n112 VSS.n111 726.923
R375 VSS.n162 VSS.n161 726.923
R376 VSS.n208 VSS.n207 722.407
R377 VSS.n111 VSS.n110 719.266
R378 VSS.n161 VSS.n160 719.266
R379 VSS.n208 VSS.n7 719.266
R380 VSS.n96 VSS.t20 312.731
R381 VSS.n90 VSS.t20 312.731
R382 VSS.n118 VSS.t16 312.731
R383 VSS.n112 VSS.t16 312.731
R384 VSS.n146 VSS.t2 312.731
R385 VSS.n140 VSS.t2 312.731
R386 VSS.n168 VSS.t4 312.731
R387 VSS.n162 VSS.t4 312.731
R388 VSS.t22 VSS.n213 299.269
R389 VSS.n214 VSS.t22 299.269
R390 VSS.t14 VSS.n5 299.269
R391 VSS.n193 VSS.t14 299.269
R392 VSS.n194 VSS.t18 299.269
R393 VSS.n200 VSS.t18 299.269
R394 VSS.n201 VSS.t9 299.269
R395 VSS.n207 VSS.t9 299.269
R396 VSS.n71 VSS.t20 292.5
R397 VSS.n73 VSS.n71 292.5
R398 VSS.n72 VSS.t20 292.5
R399 VSS.n93 VSS.n72 292.5
R400 VSS.n63 VSS.t13 292.5
R401 VSS.n65 VSS.n63 292.5
R402 VSS.n64 VSS.t13 292.5
R403 VSS.n107 VSS.n64 292.5
R404 VSS.n67 VSS.t11 292.5
R405 VSS.n69 VSS.n67 292.5
R406 VSS.n68 VSS.t11 292.5
R407 VSS.n100 VSS.n68 292.5
R408 VSS.n57 VSS.t16 292.5
R409 VSS.n59 VSS.n57 292.5
R410 VSS.n58 VSS.t16 292.5
R411 VSS.n115 VSS.n58 292.5
R412 VSS.n49 VSS.t6 292.5
R413 VSS.n51 VSS.n49 292.5
R414 VSS.n50 VSS.t6 292.5
R415 VSS.n129 VSS.n50 292.5
R416 VSS.n45 VSS.t24 292.5
R417 VSS.n47 VSS.n45 292.5
R418 VSS.n46 VSS.t24 292.5
R419 VSS.n136 VSS.n46 292.5
R420 VSS.n53 VSS.t1 292.5
R421 VSS.n55 VSS.n53 292.5
R422 VSS.n54 VSS.t1 292.5
R423 VSS.n122 VSS.n54 292.5
R424 VSS.n41 VSS.t2 292.5
R425 VSS.n43 VSS.n41 292.5
R426 VSS.n42 VSS.t2 292.5
R427 VSS.n143 VSS.n42 292.5
R428 VSS.n33 VSS.t7 292.5
R429 VSS.n35 VSS.n33 292.5
R430 VSS.n34 VSS.t7 292.5
R431 VSS.n157 VSS.n34 292.5
R432 VSS.n37 VSS.t12 292.5
R433 VSS.n39 VSS.n37 292.5
R434 VSS.n38 VSS.t12 292.5
R435 VSS.n150 VSS.n38 292.5
R436 VSS.n29 VSS.t4 292.5
R437 VSS.n31 VSS.n29 292.5
R438 VSS.n30 VSS.t4 292.5
R439 VSS.n165 VSS.n30 292.5
R440 VSS.t8 VSS.n21 292.5
R441 VSS.n21 VSS.n19 292.5
R442 VSS.t8 VSS.n24 292.5
R443 VSS.n24 VSS.n20 292.5
R444 VSS.n25 VSS.t0 292.5
R445 VSS.n27 VSS.n25 292.5
R446 VSS.n26 VSS.t0 292.5
R447 VSS.n172 VSS.n26 292.5
R448 VSS.n16 VSS.t14 292.5
R449 VSS.n187 VSS.n16 292.5
R450 VSS.n17 VSS.t14 292.5
R451 VSS.n190 VSS.n17 292.5
R452 VSS.t22 VSS.n3 292.5
R453 VSS.n3 VSS.n1 292.5
R454 VSS.t22 VSS.n4 292.5
R455 VSS.n4 VSS.n2 292.5
R456 VSS.n8 VSS.t9 292.5
R457 VSS.n11 VSS.n8 292.5
R458 VSS.n9 VSS.t9 292.5
R459 VSS.n204 VSS.n9 292.5
R460 VSS.n12 VSS.t18 292.5
R461 VSS.n15 VSS.n12 292.5
R462 VSS.n13 VSS.t18 292.5
R463 VSS.n197 VSS.n13 292.5
R464 VSS.n110 VSS.t13 289.909
R465 VSS.n104 VSS.t13 289.909
R466 VSS.n103 VSS.t11 289.909
R467 VSS.n97 VSS.t11 289.909
R468 VSS.n139 VSS.t24 289.909
R469 VSS.n133 VSS.t24 289.909
R470 VSS.n132 VSS.t6 289.909
R471 VSS.n126 VSS.t6 289.909
R472 VSS.n125 VSS.t1 289.909
R473 VSS.n119 VSS.t1 289.909
R474 VSS.n160 VSS.t7 289.909
R475 VSS.n154 VSS.t7 289.909
R476 VSS.n153 VSS.t12 289.909
R477 VSS.n147 VSS.t12 289.909
R478 VSS.t8 VSS.n7 289.909
R479 VSS.n176 VSS.t8 289.909
R480 VSS.n175 VSS.t0 289.909
R481 VSS.n169 VSS.t0 289.909
R482 VSS.n93 VSS.n92 187.482
R483 VSS.n94 VSS.n93 187.482
R484 VSS.n204 VSS.n203 187.482
R485 VSS.n205 VSS.n204 187.482
R486 VSS.n190 VSS.n189 187.482
R487 VSS.n191 VSS.n190 187.482
R488 VSS.n173 VSS.n172 187.482
R489 VSS.n172 VSS.n171 187.482
R490 VSS.n22 VSS.n20 187.482
R491 VSS.n178 VSS.n20 187.482
R492 VSS.n166 VSS.n165 187.482
R493 VSS.n165 VSS.n164 187.482
R494 VSS.n151 VSS.n150 187.482
R495 VSS.n150 VSS.n149 187.482
R496 VSS.n158 VSS.n157 187.482
R497 VSS.n157 VSS.n156 187.482
R498 VSS.n144 VSS.n143 187.482
R499 VSS.n143 VSS.n142 187.482
R500 VSS.n123 VSS.n122 187.482
R501 VSS.n122 VSS.n121 187.482
R502 VSS.n130 VSS.n129 187.482
R503 VSS.n129 VSS.n128 187.482
R504 VSS.n116 VSS.n115 187.482
R505 VSS.n115 VSS.n114 187.482
R506 VSS.n101 VSS.n100 187.482
R507 VSS.n100 VSS.n99 187.482
R508 VSS.n108 VSS.n107 187.482
R509 VSS.n107 VSS.n106 187.482
R510 VSS.n94 VSS.n73 186.353
R511 VSS.n203 VSS.n11 186.353
R512 VSS.n189 VSS.n187 186.353
R513 VSS.n173 VSS.n27 186.353
R514 VSS.n22 VSS.n19 186.353
R515 VSS.n166 VSS.n31 186.353
R516 VSS.n151 VSS.n39 186.353
R517 VSS.n158 VSS.n35 186.353
R518 VSS.n144 VSS.n43 186.353
R519 VSS.n123 VSS.n55 186.353
R520 VSS.n130 VSS.n51 186.353
R521 VSS.n116 VSS.n59 186.353
R522 VSS.n101 VSS.n69 186.353
R523 VSS.n108 VSS.n65 186.353
R524 VSS.n137 VSS.n136 168.66
R525 VSS.n136 VSS.n135 168.66
R526 VSS.n137 VSS.n47 167.53
R527 VSS.n197 VSS.n196 143.812
R528 VSS.n198 VSS.n197 143.812
R529 VSS.n211 VSS.n2 143.812
R530 VSS.n216 VSS.n2 143.812
R531 VSS.n196 VSS.n15 142.683
R532 VSS.n211 VSS.n1 142.683
R533 VSS.n219 VSS.t23 127.987
R534 VSS.n184 VSS.t19 127.871
R535 VSS.n92 VSS.n89 126.871
R536 VSS.n205 VSS.n10 126.871
R537 VSS.n191 VSS.n186 126.871
R538 VSS.n171 VSS.n28 126.871
R539 VSS.n179 VSS.n178 126.871
R540 VSS.n164 VSS.n32 126.871
R541 VSS.n149 VSS.n40 126.871
R542 VSS.n156 VSS.n36 126.871
R543 VSS.n142 VSS.n44 126.871
R544 VSS.n121 VSS.n56 126.871
R545 VSS.n128 VSS.n52 126.871
R546 VSS.n114 VSS.n60 126.871
R547 VSS.n99 VSS.n70 126.871
R548 VSS.n106 VSS.n66 126.871
R549 VSS.n89 VSS.n88 125.879
R550 VSS.n181 VSS.n10 125.684
R551 VSS.n186 VSS.n185 125.684
R552 VSS.n28 VSS.n18 125.684
R553 VSS.n180 VSS.n179 125.684
R554 VSS.n75 VSS.n32 125.684
R555 VSS.n77 VSS.n40 125.684
R556 VSS.n76 VSS.n36 125.684
R557 VSS.n79 VSS.n44 125.684
R558 VSS.n83 VSS.n56 125.684
R559 VSS.n82 VSS.n52 125.684
R560 VSS.n85 VSS.n60 125.684
R561 VSS.n87 VSS.n70 125.684
R562 VSS.n86 VSS.n66 125.684
R563 VSS.n81 VSS.n48 125.581
R564 VSS.n183 VSS.n14 125.444
R565 VSS.n218 VSS.n217 125.444
R566 VSS.n215 VSS.n214 117.001
R567 VSS.n216 VSS.n215 117.001
R568 VSS.n213 VSS.n212 117.001
R569 VSS.n212 VSS.n211 117.001
R570 VSS.n200 VSS.n199 117.001
R571 VSS.n199 VSS.n198 117.001
R572 VSS.n195 VSS.n194 117.001
R573 VSS.n196 VSS.n195 117.001
R574 VSS.n135 VSS.n48 108.047
R575 VSS.n134 VSS.n133 83.5719
R576 VSS.n135 VSS.n134 83.5719
R577 VSS.n139 VSS.n138 83.5719
R578 VSS.n138 VSS.n137 83.5719
R579 VSS.n198 VSS.n14 83.2005
R580 VSS.n217 VSS.n216 83.2005
R581 VSS.n91 VSS.n90 73.1255
R582 VSS.n92 VSS.n91 73.1255
R583 VSS.n96 VSS.n95 73.1255
R584 VSS.n95 VSS.n94 73.1255
R585 VSS.n105 VSS.n104 73.1255
R586 VSS.n106 VSS.n105 73.1255
R587 VSS.n110 VSS.n109 73.1255
R588 VSS.n109 VSS.n108 73.1255
R589 VSS.n98 VSS.n97 73.1255
R590 VSS.n99 VSS.n98 73.1255
R591 VSS.n103 VSS.n102 73.1255
R592 VSS.n102 VSS.n101 73.1255
R593 VSS.n113 VSS.n112 73.1255
R594 VSS.n114 VSS.n113 73.1255
R595 VSS.n118 VSS.n117 73.1255
R596 VSS.n117 VSS.n116 73.1255
R597 VSS.n127 VSS.n126 73.1255
R598 VSS.n128 VSS.n127 73.1255
R599 VSS.n132 VSS.n131 73.1255
R600 VSS.n131 VSS.n130 73.1255
R601 VSS.n120 VSS.n119 73.1255
R602 VSS.n121 VSS.n120 73.1255
R603 VSS.n125 VSS.n124 73.1255
R604 VSS.n124 VSS.n123 73.1255
R605 VSS.n141 VSS.n140 73.1255
R606 VSS.n142 VSS.n141 73.1255
R607 VSS.n146 VSS.n145 73.1255
R608 VSS.n145 VSS.n144 73.1255
R609 VSS.n155 VSS.n154 73.1255
R610 VSS.n156 VSS.n155 73.1255
R611 VSS.n160 VSS.n159 73.1255
R612 VSS.n159 VSS.n158 73.1255
R613 VSS.n148 VSS.n147 73.1255
R614 VSS.n149 VSS.n148 73.1255
R615 VSS.n153 VSS.n152 73.1255
R616 VSS.n152 VSS.n151 73.1255
R617 VSS.n163 VSS.n162 73.1255
R618 VSS.n164 VSS.n163 73.1255
R619 VSS.n168 VSS.n167 73.1255
R620 VSS.n167 VSS.n166 73.1255
R621 VSS.n177 VSS.n176 73.1255
R622 VSS.n178 VSS.n177 73.1255
R623 VSS.n23 VSS.n7 73.1255
R624 VSS.n23 VSS.n22 73.1255
R625 VSS.n170 VSS.n169 73.1255
R626 VSS.n171 VSS.n170 73.1255
R627 VSS.n175 VSS.n174 73.1255
R628 VSS.n174 VSS.n173 73.1255
R629 VSS.n193 VSS.n192 73.1255
R630 VSS.n192 VSS.n191 73.1255
R631 VSS.n188 VSS.n5 73.1255
R632 VSS.n189 VSS.n188 73.1255
R633 VSS.n207 VSS.n206 73.1255
R634 VSS.n206 VSS.n205 73.1255
R635 VSS.n202 VSS.n201 73.1255
R636 VSS.n203 VSS.n202 73.1255
R637 VSS.n80 VSS.t25 70.1732
R638 VSS.n88 VSS.t21 51.3891
R639 VSS.n84 VSS.t17 51.3891
R640 VSS.n78 VSS.t3 51.3891
R641 VSS.n74 VSS.t5 51.3891
R642 VSS.n182 VSS.t10 51.3891
R643 VSS.n0 VSS.t15 51.3891
R644 VSS.n89 VSS.n73 50.5605
R645 VSS.n15 VSS.n14 50.5605
R646 VSS.n11 VSS.n10 50.5605
R647 VSS.n217 VSS.n1 50.5605
R648 VSS.n187 VSS.n186 50.5605
R649 VSS.n28 VSS.n27 50.5605
R650 VSS.n179 VSS.n19 50.5605
R651 VSS.n32 VSS.n31 50.5605
R652 VSS.n40 VSS.n39 50.5605
R653 VSS.n36 VSS.n35 50.5605
R654 VSS.n44 VSS.n43 50.5605
R655 VSS.n56 VSS.n55 50.5605
R656 VSS.n48 VSS.n47 50.5605
R657 VSS.n52 VSS.n51 50.5605
R658 VSS.n60 VSS.n59 50.5605
R659 VSS.n70 VSS.n69 50.5605
R660 VSS.n66 VSS.n65 50.5605
R661 VSS VSS.n219 1.03372
R662 VSS.n181 VSS.n180 0.852767
R663 VSS.n180 VSS.n18 0.852767
R664 VSS.n76 VSS.n75 0.852767
R665 VSS.n77 VSS.n76 0.852767
R666 VSS.n82 VSS.n81 0.852767
R667 VSS.n83 VSS.n82 0.852767
R668 VSS.n86 VSS.n85 0.852767
R669 VSS.n87 VSS.n86 0.852767
R670 VSS.n218 VSS.n0 0.6491
R671 VSS.n185 VSS.n184 0.6491
R672 VSS.n183 VSS.n182 0.6491
R673 VSS.n74 VSS.n18 0.6491
R674 VSS.n78 VSS.n77 0.6491
R675 VSS.n80 VSS.n79 0.6491
R676 VSS.n84 VSS.n83 0.6491
R677 VSS.n88 VSS.n87 0.6491
R678 VSS.n219 VSS.n218 0.194767
R679 VSS.n185 VSS.n0 0.194767
R680 VSS.n184 VSS.n183 0.194767
R681 VSS.n182 VSS.n181 0.194767
R682 VSS.n75 VSS.n74 0.194767
R683 VSS.n79 VSS.n78 0.194767
R684 VSS.n81 VSS.n80 0.194767
R685 VSS.n85 VSS.n84 0.194767
R686 net4.n0 net4.t1 43.6291
R687 net4.n0 net4.t0 42.0666
R688 net4 net4.n0 14.7632
R689 net3.n0 net3.t1 43.6291
R690 net3.n0 net3.t0 42.0666
R691 net3 net3.n0 14.7632
R692 net2.n0 net2.t0 43.6291
R693 net2.n0 net2.t1 42.0666
R694 net2 net2.n0 14.7632
R695 EVAL_GND.n1 EVAL_GND.t4 70.7982
R696 EVAL_GND.n0 EVAL_GND.t2 54.5897
R697 EVAL_GND.n2 EVAL_GND.t3 52.0141
R698 EVAL_GND.n0 EVAL_GND.t1 52.0141
R699 EVAL_GND EVAL_GND.t0 52.0141
R700 EVAL_GND EVAL_GND.n2 2.5761
R701 EVAL_GND.n1 EVAL_GND.n0 2.18443
R702 EVAL_GND.n2 EVAL_GND.n1 1.24443
R703 net1.n0 net1.t1 43.6291
R704 net1.n0 net1.t0 42.0666
R705 net1 net1.n0 14.7632
R706 N3.n0 N3.t3 366.336
R707 N3.n0 N3.t2 282.827
R708 N3.n1 N3.t1 226.13
R709 N3.n1 N3.t0 50.6916
R710 N3 N3.n1 5.448
R711 N3 N3.n0 1.83193
R712 N2.n0 N2.t3 366.336
R713 N2.n0 N2.t2 282.827
R714 N2.n1 N2.t1 226.13
R715 N2.n1 N2.t0 50.6916
R716 N2 N2.n1 5.448
R717 N2 N2.n0 1.83193
R718 N1.n0 N1.t3 366.336
R719 N1.n0 N1.t2 282.827
R720 N1.n1 N1.t1 226.13
R721 N1.n1 N1.t0 50.6916
R722 N1 N1.n1 5.448
R723 N1 N1.n0 1.83193
R724 N0.n0 N0.t3 366.336
R725 N0.n0 N0.t2 282.827
R726 N0.n1 N0.t1 226.13
R727 N0.n1 N0.t0 50.6916
R728 N0 N0.n1 5.448
R729 N0 N0.n0 1.83193
R730 A1T.n0 A1T.t2 292.902
R731 A1T.n0 A1T.t3 290.327
R732 A1T.n1 A1T.t1 118.816
R733 A1T.n1 A1T.t0 50.6916
R734 A1T A1T.n1 12.948
R735 A1T A1T.n0 7.00193
R736 A1B.n3 A1B.t0 336.339
R737 A1B.n1 A1B.t5 290.88
R738 A1B.n0 A1B.t2 290.402
R739 A1B.n0 A1B.t3 287.827
R740 A1B.n2 A1B.t4 287.827
R741 A1B.n3 A1B.t1 127.172
R742 A1B A1B.n3 10.448
R743 A1B A1B.n2 0.970267
R744 A1B.n1 A1B.n0 0.617767
R745 A1B.n2 A1B.n1 0.2261
R746 A0T.n0 A0T.t2 295.099
R747 A0T.n0 A0T.t3 289.077
R748 A0T.n1 A0T.t0 118.816
R749 A0T.n1 A0T.t1 50.6916
R750 A0T A0T.n1 11.698
R751 A0T A0T.n0 6.14027
R752 A0B.n3 A0B.t0 336.339
R753 A0B.n0 A0B.t2 292.599
R754 A0B.n1 A0B.t5 289.63
R755 A0B.n0 A0B.t3 286.577
R756 A0B.n2 A0B.t4 286.577
R757 A0B.n3 A0B.t1 127.172
R758 A0B A0B.n3 9.198
R759 A0B.n1 A0B.n0 3.20277
R760 A0B A0B.n2 0.970267
R761 A0B.n2 A0B.n1 0.2261
C0 A1T A0T 0.23554f
C1 PCLK net3 0.04024f
C2 net4 m1_160_n1740# 0.00615f
C3 PCLK net2 0.0402f
C4 VDD A0T 0.63817f
C5 DEC2 PCLK 0.06771f
C6 A0B A1 0.15515f
C7 DEC1 PCLK 0.08569f
C8 A1B A1 0.55817f
C9 DEC3 EVAL_GND 0.04421f
C10 m1_160_n1740# A0T 4.21801f
C11 net4 A0T 0.76077f
C12 A0B net3 0.76081f
C13 N3 PCLK 0.11923f
C14 A1T A1 0.05911f
C15 A0B A0 0.51553f
C16 net3 EVAL_GND 0.24542f
C17 A1T net3 0.09048f
C18 A0B net2 0
C19 A1B net2 0.09048f
C20 VDD DEC3 0.599f
C21 DEC2 A0B 0.06914f
C22 DEC1 A0B 0
C23 DEC0 N1 0.0012f
C24 VDD A1 0.78278f
C25 m1_160_n1740# DEC3 0.04282f
C26 net4 DEC3 0
C27 net2 EVAL_GND 0.24542f
C28 PCLK N2 0.23665f
C29 DEC2 EVAL_GND 0.11185f
C30 m1_160_n1740# A1 0.00456f
C31 DEC1 EVAL_GND 0.11187f
C32 VDD net3 0.1317f
C33 A1T DEC2 0.01841f
C34 A1T DEC1 0
C35 m1_160_n1740# net3 0
C36 N3 EVAL_GND 0.06895f
C37 VDD A0 0.5738f
C38 PCLK N1 0.19891f
C39 N3 A1T 0.83934f
C40 m1_160_n1740# A0 0.00794f
C41 DEC3 A0T 0.06914f
C42 VDD net2 0.13178f
C43 VDD DEC2 0.60061f
C44 A1 A0T 0.0717f
C45 VDD DEC1 0.60141f
C46 m1_160_n1740# net2 0
C47 A0B N2 0.06555f
C48 PCLK DEC0 0.06771f
C49 DEC2 m1_160_n1740# 0
C50 DEC1 m1_160_n1740# 0
C51 VDD N3 1.74036f
C52 EVAL_GND N2 0.14383f
C53 A1T N2 0.8449f
C54 N3 m1_160_n1740# 0.03493f
C55 A0 A0T 0.06275f
C56 N0 N1 0.06254f
C57 N3 net4 0.2514f
C58 A1B N1 0.83934f
C59 N1 EVAL_GND 0.161f
C60 net2 A0T 0.76077f
C61 DEC2 A0T 0
C62 DEC1 A0T 0.06914f
C63 N0 DEC0 0.99369f
C64 A0B DEC0 0.0692f
C65 VDD N2 1.67206f
C66 A1B DEC0 0.01841f
C67 N3 A0T 0.06583f
C68 m1_160_n1740# N2 0
C69 DEC0 EVAL_GND 0.11185f
C70 A0 A1 0.21908f
C71 VDD N1 1.74036f
C72 N0 PCLK 0.16365f
C73 A0B PCLK 0.38093f
C74 A1B PCLK 0.76415f
C75 m1_160_n1740# N1 0
C76 DEC0 net1 0
C77 PCLK EVAL_GND 0.43002f
C78 A1T PCLK 0.66526f
C79 VDD DEC0 0.60061f
C80 N3 DEC3 0.99369f
C81 m1_160_n1740# DEC0 0
C82 DEC2 net3 0
C83 PCLK net1 0.0402f
C84 N0 A0B 0.06555f
C85 N1 A0T 0.06555f
C86 N0 A1B 0.90223f
C87 A1B A0B 0.44394f
C88 VDD PCLK 3.22314f
C89 N0 EVAL_GND 0.0757f
C90 A0B EVAL_GND 0.30343f
C91 m1_160_n1740# PCLK 1.93989f
C92 net4 PCLK 0.032f
C93 DEC1 net2 0
C94 A1B EVAL_GND 0.06861f
C95 N0 A1T 0
C96 A1T A0B 0.13727f
C97 A1T A1B 1.37238f
C98 DEC0 A0T 0
C99 A1T EVAL_GND 0.13715f
C100 N3 DEC2 0.0012f
C101 N0 net1 0.2514f
C102 A0B net1 0.76081f
C103 A1B net1 0.09048f
C104 net3 N2 0.2514f
C105 VDD N0 1.74673f
C106 net1 EVAL_GND 0.17565f
C107 VDD A0B 1.41632f
C108 PCLK A0T 0.18488f
C109 VDD A1B 1.6531f
C110 N0 m1_160_n1740# 0
C111 m1_160_n1740# A0B 3.54674f
C112 m1_160_n1740# A1B 1.94209f
C113 VDD EVAL_GND 0.10507f
C114 VDD A1T 0.80047f
C115 DEC2 N2 0.99369f
C116 net4 EVAL_GND 0.24542f
C117 A1T m1_160_n1740# 2.19149f
C118 A1T net4 0.09048f
C119 N3 N2 0.06254f
C120 VDD net1 0.13177f
C121 net2 N1 0.2514f
C122 m1_160_n1740# net1 0
C123 DEC1 N1 0.99369f
C124 A0B A0T 1.32151f
C125 A1B A0T 0.04768f
C126 VDD m1_160_n1740# 0.06508f
C127 EVAL_GND A0T 0.36987f
C128 VDD net4 0.13178f
C129 DEC3 VSS 1.94483f
C130 DEC2 VSS 1.88892f
C131 DEC1 VSS 1.88971f
C132 DEC0 VSS 1.88893f
C133 PCLK VSS 7.19133f
C134 A1 VSS 2.27951f
C135 A0 VSS 1.55459f
C136 VDD VSS 27.24516f
C137 m1_160_n1740# VSS 13.3375f ; **FLOATING
C138 net4 VSS 1.88133f
C139 net3 VSS 1.87812f
C140 net2 VSS 1.87814f
C141 EVAL_GND VSS 7.58353f
C142 net1 VSS 1.85494f
C143 N3 VSS 3.15544f
C144 N2 VSS 3.0694f
C145 N1 VSS 3.01477f
C146 N0 VSS 2.98667f
C147 A1T VSS 10.71547f
C148 A1B VSS 7.67092f
C149 A0T VSS 8.56598f
C150 A0B VSS 8.06175f
C151 A0B.n0 VSS 4.99996f
C152 A0B.n1 VSS 1.42999f
C153 A0B.n2 VSS 1.54102f
C154 A0B.t1 VSS 0.07827f
C155 A0B.t0 VSS 0.06358f
C156 A0B.n3 VSS 1.17047f
C157 A0T.n0 VSS 5.79935f
C158 A0T.t1 VSS 0.17805f
C159 A0T.t0 VSS 0.12494f
C160 A0T.n1 VSS 1.39758f
C161 A1B.n0 VSS 3.81621f
C162 A1B.n1 VSS 1.16086f
C163 A1B.n2 VSS 1.65659f
C164 A1B.t1 VSS 0.07793f
C165 A1B.t0 VSS 0.06069f
C166 A1B.n3 VSS 1.23511f
C167 A1T.n0 VSS 4.52919f
C168 A1T.t0 VSS 0.16429f
C169 A1T.t1 VSS 0.11579f
C170 A1T.n1 VSS 1.28101f
C171 N0.n0 VSS 2.24328f
C172 N0.t0 VSS 0.21491f
C173 N0.t1 VSS 0.10081f
C174 N0.n1 VSS 1.19171f
C175 N1.n0 VSS 2.27086f
C176 N1.t0 VSS 0.22527f
C177 N1.t1 VSS 0.10166f
C178 N1.n1 VSS 1.20637f
C179 N2.n0 VSS 2.24803f
C180 N2.t0 VSS 0.21532f
C181 N2.t1 VSS 0.10096f
C182 N2.n1 VSS 1.19424f
C183 N3.n0 VSS 2.19893f
C184 N3.t0 VSS 0.21974f
C185 N3.t1 VSS 0.10601f
C186 N3.n1 VSS 1.16816f
C187 net1.t0 VSS 0.1272f
C188 net1.t1 VSS 0.13794f
C189 net1.n0 VSS 0.79886f
C190 EVAL_GND.t2 VSS 0.18469f
C191 EVAL_GND.t1 VSS 0.15379f
C192 EVAL_GND.n0 VSS 1.12788f
C193 EVAL_GND.t4 VSS 0.10376f
C194 EVAL_GND.n1 VSS 0.54207f
C195 EVAL_GND.t3 VSS 0.13669f
C196 EVAL_GND.n2 VSS 0.58512f
C197 EVAL_GND.t0 VSS 0.13026f
C198 net2.t1 VSS 0.13753f
C199 net2.t0 VSS 0.15052f
C200 net2.n0 VSS 0.83729f
C201 net3.t0 VSS 0.15463f
C202 net3.t1 VSS 0.14225f
C203 net3.n0 VSS 0.83727f
C204 net4.t0 VSS 0.1627f
C205 net4.t1 VSS 0.15016f
C206 net4.n0 VSS 0.83611f
C207 VSS.t15 VSS 0.04612f
C208 VSS.t5 VSS 0.04395f
C209 VSS.t3 VSS 0.04449f
C210 VSS.t25 VSS 0.04397f
C211 VSS.t17 VSS 0.04404f
C212 VSS.t21 VSS 0.04308f
C213 VSS.t10 VSS 0.04944f
C214 VSS.t19 VSS 0.02764f
C215 VSS.t23 VSS 0.02739f
C216 VDD.n0 VSS 0.03773f
C217 VDD.n1 VSS 0.04366f
C218 VDD.t10 VSS 0.40249f
C219 VDD.n3 VSS 0.30033f
C220 VDD.n4 VSS 0.04493f
C221 VDD.n5 VSS 0.04493f
C222 VDD.n7 VSS 0.30033f
C223 VDD.n8 VSS 0.04493f
C224 VDD.n9 VSS 0.02942f
C225 VDD.n10 VSS 0.04277f
C226 VDD.t11 VSS 0.12559f
C227 VDD.n11 VSS 0.48786f
C228 VDD.n12 VSS 0.02542f
C229 VDD.n13 VSS 0.03148f
C230 VDD.t22 VSS 0.27423f
C231 VDD.n15 VSS 0.19791f
C232 VDD.n16 VSS 0.03223f
C233 VDD.n17 VSS 0.03223f
C234 VDD.n19 VSS 0.19791f
C235 VDD.n20 VSS 0.03223f
C236 VDD.n21 VSS 0.02308f
C237 VDD.n22 VSS 0.03722f
C238 VDD.n23 VSS 0.25079f
C239 VDD.t23 VSS 0.07174f
C240 VDD.n24 VSS 0.24538f
C241 VDD.n25 VSS 0.03773f
C242 VDD.n26 VSS 0.04366f
C243 VDD.t0 VSS 0.40249f
C244 VDD.n28 VSS 0.30033f
C245 VDD.n29 VSS 0.04493f
C246 VDD.n30 VSS 0.04493f
C247 VDD.n32 VSS 0.30033f
C248 VDD.n33 VSS 0.04493f
C249 VDD.n34 VSS 0.02942f
C250 VDD.n35 VSS 0.04257f
C251 VDD.n36 VSS 0.16073f
C252 VDD.t1 VSS 0.12647f
C253 VDD.n37 VSS 0.36244f
C254 VDD.n38 VSS 0.02542f
C255 VDD.n39 VSS 0.03148f
C256 VDD.t16 VSS 0.27423f
C257 VDD.n41 VSS 0.19791f
C258 VDD.n42 VSS 0.03223f
C259 VDD.n43 VSS 0.03223f
C260 VDD.n45 VSS 0.19791f
C261 VDD.n46 VSS 0.03223f
C262 VDD.n47 VSS 0.02308f
C263 VDD.n48 VSS 0.03722f
C264 VDD.n49 VSS 0.25079f
C265 VDD.t17 VSS 0.06518f
C266 VDD.n50 VSS 0.31436f
C267 VDD.n51 VSS 0.03773f
C268 VDD.n52 VSS 0.04366f
C269 VDD.t2 VSS 0.40249f
C270 VDD.n54 VSS 0.30033f
C271 VDD.n55 VSS 0.04493f
C272 VDD.n56 VSS 0.04493f
C273 VDD.n58 VSS 0.30033f
C274 VDD.n59 VSS 0.04493f
C275 VDD.n60 VSS 0.02942f
C276 VDD.n61 VSS 0.04257f
C277 VDD.n62 VSS 0.22971f
C278 VDD.t3 VSS 0.12688f
C279 VDD.n63 VSS 0.36244f
C280 VDD.n64 VSS 0.02542f
C281 VDD.n65 VSS 0.03148f
C282 VDD.t18 VSS 0.27423f
C283 VDD.n67 VSS 0.19791f
C284 VDD.n68 VSS 0.03223f
C285 VDD.n69 VSS 0.03223f
C286 VDD.n71 VSS 0.19791f
C287 VDD.n72 VSS 0.03223f
C288 VDD.n73 VSS 0.02308f
C289 VDD.n74 VSS 0.03722f
C290 VDD.n75 VSS 0.25079f
C291 VDD.t19 VSS 0.06518f
C292 VDD.n76 VSS 0.24538f
C293 VDD.n77 VSS 0.03773f
C294 VDD.n78 VSS 0.04366f
C295 VDD.t4 VSS 0.40249f
C296 VDD.n80 VSS 0.30033f
C297 VDD.n81 VSS 0.04493f
C298 VDD.n82 VSS 0.04493f
C299 VDD.n84 VSS 0.30033f
C300 VDD.n85 VSS 0.04493f
C301 VDD.n86 VSS 0.02942f
C302 VDD.n87 VSS 0.04257f
C303 VDD.n88 VSS 0.16073f
C304 VDD.t5 VSS 0.12638f
C305 VDD.n89 VSS 0.36244f
C306 VDD.n90 VSS 0.02542f
C307 VDD.n91 VSS 0.03148f
C308 VDD.t20 VSS 0.27423f
C309 VDD.n93 VSS 0.19791f
C310 VDD.n94 VSS 0.03223f
C311 VDD.n95 VSS 0.03223f
C312 VDD.n97 VSS 0.19791f
C313 VDD.n98 VSS 0.03223f
C314 VDD.n99 VSS 0.02308f
C315 VDD.n100 VSS 0.03722f
C316 VDD.n101 VSS 0.25079f
C317 VDD.t21 VSS 0.06518f
C318 VDD.n102 VSS 0.24538f
C319 VDD.n103 VSS 0.03069f
C320 VDD.n104 VSS 0.03668f
C321 VDD.t6 VSS 0.32964f
C322 VDD.n106 VSS 0.24156f
C323 VDD.n107 VSS 0.0377f
C324 VDD.n108 VSS 0.0377f
C325 VDD.n110 VSS 0.24156f
C326 VDD.n111 VSS 0.0377f
C327 VDD.n112 VSS 0.02581f
C328 VDD.n113 VSS 0.0395f
C329 VDD.n114 VSS 0.17279f
C330 VDD.t7 VSS 0.09379f
C331 VDD.n115 VSS 0.26592f
C332 VDD.n116 VSS 0.02256f
C333 VDD.n117 VSS 0.02866f
C334 VDD.t12 VSS 0.2436f
C335 VDD.n119 VSS 0.17424f
C336 VDD.n120 VSS 0.02923f
C337 VDD.n121 VSS 0.02923f
C338 VDD.n123 VSS 0.17424f
C339 VDD.n124 VSS 0.02923f
C340 VDD.n125 VSS 0.02157f
C341 VDD.n126 VSS 0.03597f
C342 VDD.n127 VSS 0.18675f
C343 VDD.t13 VSS 0.04542f
C344 VDD.n128 VSS 0.23301f
C345 VDD.n129 VSS 0.03069f
C346 VDD.n130 VSS 0.03668f
C347 VDD.t8 VSS 0.32964f
C348 VDD.n132 VSS 0.24156f
C349 VDD.n133 VSS 0.0377f
C350 VDD.n134 VSS 0.0377f
C351 VDD.n136 VSS 0.24156f
C352 VDD.n137 VSS 0.0377f
C353 VDD.n138 VSS 0.02581f
C354 VDD.n139 VSS 0.0395f
C355 VDD.n140 VSS 0.17279f
C356 VDD.t9 VSS 0.09135f
C357 VDD.n141 VSS 0.26592f
C358 VDD.n142 VSS 0.02256f
C359 VDD.n143 VSS 0.02866f
C360 VDD.t14 VSS 0.2436f
C361 VDD.n145 VSS 0.17424f
C362 VDD.n146 VSS 0.02923f
C363 VDD.n147 VSS 0.02923f
C364 VDD.n149 VSS 0.17424f
C365 VDD.n150 VSS 0.02923f
C366 VDD.n151 VSS 0.02157f
C367 VDD.n152 VSS 0.03597f
C368 VDD.n153 VSS 0.18675f
C369 VDD.t15 VSS 0.04788f
C370 VDD.n154 VSS 0.26378f
C371 A0.n0 VSS 1.15263f
C372 A1.n0 VSS 1.36641f
C373 PCLK.n0 VSS 2.4947f
C374 PCLK.n1 VSS 1.76838f
C375 PCLK.n2 VSS 1.52781f
C376 PCLK.n3 VSS 1.8434f
C377 DEC0.t0 VSS 0.18262f
C378 DEC0.t1 VSS 0.18509f
C379 DEC0.n0 VSS 1.22486f
C380 DEC1.t0 VSS 0.1831f
C381 DEC1.t1 VSS 0.18552f
C382 DEC1.n0 VSS 1.22433f
C383 DEC2.t1 VSS 0.18271f
C384 DEC2.t0 VSS 0.18517f
C385 DEC2.n0 VSS 1.22482f
C386 DEC3.t1 VSS 0.17327f
C387 DEC3.t0 VSS 0.17543f
C388 DEC3.n0 VSS 1.14991f
.ends row_decoder

* expanding   symbol:  wl_driver.sym # of pins=4
** sym_path: /work/cells/wordline_driver/wl_driver.sym
** sch_path: /work/cells/wordline_driver/wl_driver.sch
.subckt wl_driver VDD WL_IN WL VSS
X0 VSS.t3 WL_IN.t0 a_227_n1042.t0 VSS.t2 sky130_fd_pr__nfet_01v8 ad=0.1218 pd=1.42 as=0.1218 ps=1.42 w=0.42 l=0.15
X1 VDD.t1 WL_IN.t1 a_227_n1042.t1 VDD.t0 sky130_fd_pr__pfet_01v8 ad=0.1218 pd=1.42 as=0.1218 ps=1.42 w=0.42 l=0.15
X2 VSS.t1 a_227_n1042.t2 WL.t0 VSS.t0 sky130_fd_pr__nfet_01v8 ad=0.2436 pd=2.26 as=0.2436 ps=2.26 w=0.84 l=0.15
X3 VDD.t3 a_227_n1042.t3 WL.t1 VDD.t2 sky130_fd_pr__pfet_01v8 ad=0.2436 pd=2.26 as=0.2436 ps=2.26 w=0.84 l=0.15
C0 VDD WL_IN 2.02518f
C1 VDD WL 0.24883f
C2 WL_IN WL 0.1678f
R0 WL.n0 WL.t1 341.731
R1 WL.n0 WL.t0 127.841
R2 WL WL.n0 1.27812
R3 WL_IN.n0 WL_IN.t1 311.418
R4 WL_IN.n0 WL_IN.t0 301.378
R5 WL_IN WL_IN.n0 0.43525
R6 VDD.n8 VDD.n7 1380
R7 VDD.n5 VDD.n3 1380
R8 VDD.n20 VDD.n19 1231.76
R9 VDD.n17 VDD.n15 1231.76
R10 VDD.n24 VDD.t1 671.861
R11 VDD.n11 VDD.t3 340.688
R12 VDD.n15 VDD.n14 247.977
R13 VDD.n19 VDD.n18 247.977
R14 VDD.n3 VDD.n2 223.581
R15 VDD.n7 VDD.n6 223.581
R16 VDD.n11 VDD.n10 189.012
R17 VDD.n4 VDD.n1 147.201
R18 VDD.n4 VDD.n0 147.201
R19 VDD.n9 VDD.n1 146.071
R20 VDD.n16 VDD.n13 131.388
R21 VDD.n16 VDD.n12 131.388
R22 VDD.n23 VDD.n22 131
R23 VDD.n21 VDD.n13 130.26
R24 VDD.n17 VDD.n16 92.5005
R25 VDD.n21 VDD.n20 92.5005
R26 VDD.n5 VDD.n4 92.5005
R27 VDD.n9 VDD.n8 92.5005
R28 VDD.n10 VDD.n0 86.5887
R29 VDD.n8 VDD.n2 72.6454
R30 VDD.n6 VDD.n5 72.6454
R31 VDD.n22 VDD.n12 70.777
R32 VDD.n20 VDD.n14 68.7187
R33 VDD.n18 VDD.n17 68.7187
R34 VDD.n22 VDD.n21 50.5605
R35 VDD.n10 VDD.n9 50.5605
R36 VDD.n19 VDD.n13 46.2505
R37 VDD.n15 VDD.n12 46.2505
R38 VDD.n7 VDD.n1 37.0005
R39 VDD.n3 VDD.n0 37.0005
R40 VDD.n18 VDD.t0 18.6229
R41 VDD.t0 VDD.n14 18.6229
R42 VDD.n6 VDD.t2 14.9873
R43 VDD.t2 VDD.n2 14.9873
R44 VDD.n23 VDD.n11 0.5833
R45 VDD VDD.n24 0.532383
R46 VDD.n24 VDD.n23 0.3577
R47 VSS.n18 VSS.n15 40639.1
R48 VSS.n14 VSS.n6 2213.35
R49 VSS.n10 VSS.n6 2213.35
R50 VSS.n14 VSS.n7 2213.35
R51 VSS.n10 VSS.n7 2213.35
R52 VSS.n20 VSS.n3 1970
R53 VSS.n17 VSS.n3 1970
R54 VSS.n20 VSS.n4 1970
R55 VSS.n17 VSS.n4 1970
R56 VSS.n19 VSS.n5 1671.51
R57 VSS.n15 VSS.t0 298.755
R58 VSS.t0 VSS.n5 298.755
R59 VSS.n19 VSS.t2 298.755
R60 VSS.t2 VSS.n18 298.755
R61 VSS.n4 VSS.n2 292.5
R62 VSS.t2 VSS.n4 292.5
R63 VSS.n3 VSS.n1 292.5
R64 VSS.t2 VSS.n3 292.5
R65 VSS.n12 VSS.n7 292.5
R66 VSS.n7 VSS.t0 292.5
R67 VSS.n9 VSS.n6 292.5
R68 VSS.n6 VSS.t0 292.5
R69 VSS.n24 VSS.t3 245.071
R70 VSS.n17 VSS.n16 146.25
R71 VSS.n18 VSS.n17 146.25
R72 VSS.n21 VSS.n20 146.25
R73 VSS.n20 VSS.n19 146.25
R74 VSS.n12 VSS.n11 143.812
R75 VSS.n13 VSS.n12 143.812
R76 VSS.n11 VSS.n9 142.683
R77 VSS.n21 VSS.n2 128
R78 VSS.n16 VSS.n2 128
R79 VSS.n0 VSS.t1 127.189
R80 VSS.n16 VSS.n1 126.871
R81 VSS.n11 VSS.n10 117.001
R82 VSS.n10 VSS.n5 117.001
R83 VSS.n14 VSS.n13 117.001
R84 VSS.n15 VSS.n14 117.001
R85 VSS.n8 VSS.n0 93.5908
R86 VSS.n23 VSS.n22 86.8401
R87 VSS.n13 VSS.n8 83.2005
R88 VSS.n22 VSS.n21 67.3887
R89 VSS.n22 VSS.n1 50.5605
R90 VSS.n9 VSS.n8 50.5605
R91 VSS VSS.n24 0.767383
R92 VSS.n23 VSS.n0 0.692967
R93 VSS.n24 VSS.n23 0.248033
R94 a_227_n1042.t0 a_227_n1042.n1 245.904
R95 a_227_n1042.n1 a_227_n1042.n0 0.802633
R96 a_227_n1042.n0 a_227_n1042.t2 365.646
R97 a_227_n1042.n0 a_227_n1042.t3 380.469
R98 a_227_n1042.n1 a_227_n1042.t1 672.721
C3 WL VSS 1.85772f
C4 WL_IN VSS 1.70777f
C5 VDD VSS 4.23566f
C6 a_227_n1042.t0 VSS 0.03981f $ **FLOATING
C7 a_227_n1042.t1 VSS 0.03437f $ **FLOATING
C8 a_227_n1042.t3 VSS 0.08695f $ **FLOATING
C9 a_227_n1042.n0 VSS 1.59251f $ **FLOATING
C10 a_227_n1042.t2 VSS 0.08353f $ **FLOATING
C11 a_227_n1042.n1 VSS 1.56012f $ **FLOATING
C12 VDD.n0 VSS 0.02758f $ **FLOATING
C13 VDD.n1 VSS 0.03505f $ **FLOATING
C14 VDD.t2 VSS 0.2979f $ **FLOATING
C15 VDD.n3 VSS 0.21308f $ **FLOATING
C16 VDD.n4 VSS 0.03574f $ **FLOATING
C17 VDD.n5 VSS 0.03574f $ **FLOATING
C18 VDD.n7 VSS 0.21308f $ **FLOATING
C19 VDD.n8 VSS 0.03574f $ **FLOATING
C20 VDD.n9 VSS 0.02638f $ **FLOATING
C21 VDD.n10 VSS 0.05172f $ **FLOATING
C22 VDD.t3 VSS 0.02598f $ **FLOATING
C23 VDD.n11 VSS 0.49379f $ **FLOATING
C24 VDD.n12 VSS 0.024f $ **FLOATING
C25 VDD.n13 VSS 0.03155f $ **FLOATING
C26 VDD.t0 VSS 0.25964f $ **FLOATING
C27 VDD.n15 VSS 0.1834f $ **FLOATING
C28 VDD.n16 VSS 0.03195f $ **FLOATING
C29 VDD.n17 VSS 0.03195f $ **FLOATING
C30 VDD.n19 VSS 0.1834f $ **FLOATING
C31 VDD.n20 VSS 0.03195f $ **FLOATING
C32 VDD.n21 VSS 0.02448f $ **FLOATING
C33 VDD.n22 VSS 0.04163f $ **FLOATING
C34 VDD.n23 VSS 0.21286f $ **FLOATING
C35 VDD.t1 VSS 0.01276f $ **FLOATING
C36 VDD.n24 VSS 0.23313f $ **FLOATING
C37 WL_IN.t0 VSS 0.1015f $ **FLOATING
C38 WL_IN.t1 VSS 0.08221f $ **FLOATING
C39 WL_IN.n0 VSS 2.57087f $ **FLOATING
C40 WL.t0 VSS 0.08067f $ **FLOATING
C41 WL.t1 VSS 0.07112f $ **FLOATING
C42 WL.n0 VSS 1.88168f $ **FLOATING
.ends wl_driver

.GLOBAL GND

VCAPCLK CAPCLK GND PWL(0 0 1.4955722583333e-08 0 1.5044277416667e-08 1.8 1.9955722583333e-08 1.8 2.0044277416667e-08 0 2.5e-08 0)
.lib "/opt/pdks/sky130A/libs.tech/combined/continuous/sky130.lib.spice" tt
.temp 27
.options method=gear minbreak=1e-15 chgtol=1e-18
.save v(dec0) v(dec1) v(dec2) v(dec3) v(net2) v(net5) v(net6) v(net7) v(net8) v(x1.a0.t0) v(x1.a0.t1) v(x1.a0b.t0) v(x1.a0b.t1) v(x1.a0b.t2) v(x1.a0b.t3) v(x1.a0b.t4) v(x1.a0b.t5) v(x1.a0t.t0) v(x1.a0t.t1) v(x1.a0t.t2) v(x1.a0t.t3) v(x1.a1.t0) v(x1.a1.t1) v(x1.a1b.t0) v(x1.a1b.t1) v(x1.a1b.t2) v(x1.a1b.t3) v(x1.a1b.t4) v(x1.a1b.t5) v(x1.a1t.t0) v(x1.a1t.t1) v(x1.a1t.t2) v(x1.a1t.t3) v(x1.dec0.t0) v(x1.dec0.t1) v(x1.dec1.t0) v(x1.dec1.t1) v(x1.dec2.t0) v(x1.dec2.t1) v(x1.dec3.t0) v(x1.dec3.t1) v(x1.eval_gnd.t0) v(x1.eval_gnd.t1) v(x1.eval_gnd.t2) v(x1.eval_gnd.t3) v(x1.eval_gnd.t4) v(x1.n0.t0) v(x1.n0.t1) v(x1.n0.t2) v(x1.n0.t3) v(x1.n1.t0) v(x1.n1.t1) v(x1.n1.t2) v(x1.n1.t3) v(x1.n2.t0) v(x1.n2.t1) v(x1.n2.t2) v(x1.n2.t3) v(x1.n3.t0) v(x1.n3.t1) v(x1.n3.t2) v(x1.n3.t3) v(x1.net1.t0) v(x1.net1.t1) v(x1.net2.t0) v(x1.net2.t1) v(x1.net3.t0) v(x1.net3.t1) v(x1.net4.t0) v(x1.net4.t1) v(x1.pclk.t0) v(x1.pclk.t1) v(x1.pclk.t2) v(x1.pclk.t3) v(x1.pclk.t4) v(x1.vdd.t0) v(x1.vdd.t1) v(x1.vdd.t10) v(x1.vdd.t11) v(x1.vdd.t12) v(x1.vdd.t13) v(x1.vdd.t14) v(x1.vdd.t15) v(x1.vdd.t16) v(x1.vdd.t17) v(x1.vdd.t18) v(x1.vdd.t19) v(x1.vdd.t2) v(x1.vdd.t20) v(x1.vdd.t21) v(x1.vdd.t22) v(x1.vdd.t23) v(x1.vdd.t3) v(x1.vdd.t4) v(x1.vdd.t5) v(x1.vdd.t6) v(x1.vdd.t7) v(x1.vdd.t8) v(x1.vdd.t9) v(x1.vss.t0) v(x1.vss.t1) v(x1.vss.t10) v(x1.vss.t11) v(x1.vss.t12) v(x1.vss.t13) v(x1.vss.t14) v(x1.vss.t15) v(x1.vss.t16) v(x1.vss.t17) v(x1.vss.t18) v(x1.vss.t19) v(x1.vss.t2) v(x1.vss.t20) v(x1.vss.t21) v(x1.vss.t22) v(x1.vss.t23) v(x1.vss.t24) v(x1.vss.t25) v(x1.vss.t3) v(x1.vss.t4) v(x1.vss.t5) v(x1.vss.t6) v(x1.vss.t7) v(x1.vss.t8) v(x1.vss.t9) v(x2.a_227_n1042.t0) v(x2.a_227_n1042.t1) v(x2.a_227_n1042.t2) v(x2.a_227_n1042.t3) v(x2.vdd.t0) v(x2.vdd.t1) v(x2.vdd.t2) v(x2.vdd.t3) v(x2.vss.t0) v(x2.vss.t1) v(x2.vss.t2) v(x2.vss.t3) v(x2.wl.t0) v(x2.wl.t1) v(x2.wl_in.t0) v(x2.wl_in.t1) v(x3.a_227_n1042.t0) v(x3.a_227_n1042.t1) v(x3.a_227_n1042.t2) v(x3.a_227_n1042.t3) v(x3.vdd.t0) v(x3.vdd.t1) v(x3.vdd.t2) v(x3.vdd.t3) v(x3.vss.t0) v(x3.vss.t1) v(x3.vss.t2) v(x3.vss.t3) v(x3.wl.t0) v(x3.wl.t1) v(x3.wl_in.t0) v(x3.wl_in.t1) v(x4.a_227_n1042.t0) v(x4.a_227_n1042.t1) v(x4.a_227_n1042.t2) v(x4.a_227_n1042.t3) v(x4.vdd.t0) v(x4.vdd.t1) v(x4.vdd.t2) v(x4.vdd.t3) v(x4.vss.t0) v(x4.vss.t1) v(x4.vss.t2) v(x4.vss.t3) v(x4.wl.t0) v(x4.wl.t1) v(x4.wl_in.t0) v(x4.wl_in.t1) v(x5.a_227_n1042.t0) v(x5.a_227_n1042.t1) v(x5.a_227_n1042.t2) v(x5.a_227_n1042.t3) v(x5.vdd.t0) v(x5.vdd.t1) v(x5.vdd.t2) v(x5.vdd.t3) v(x5.vss.t0) v(x5.vss.t1) v(x5.vss.t2) v(x5.vss.t3) v(x5.wl.t0) v(x5.wl.t1) v(x5.wl_in.t0) v(x5.wl_in.t1) i(VDD_SRC) i(VPCLK) i(VA0) i(VA1) v(dec0) v(dec1) v(dec2) v(dec3) v(net1) v(net2) v(net3) v(net4) v(x1.n0) v(x1.n0.n0) v(x1.n0.n1) v(x1.n0.t0) v(x1.n0.t1) v(x1.n0.t2) v(x1.n0.t3) v(x1.n1) v(x1.n1.n0) v(x1.n1.n1) v(x1.n1.t0) v(x1.n1.t1) v(x1.n1.t2) v(x1.n1.t3) v(x1.n2) v(x1.n2.n0) v(x1.n2.n1) v(x1.n2.t0) v(x1.n2.t1) v(x1.n2.t2) v(x1.n2.t3) v(x1.n3) v(x1.n3.n0) v(x1.n3.n1) v(x1.n3.t0) v(x1.n3.t1) v(x1.n3.t2) v(x1.n3.t3) v(CAPCLK)
.tran 5p 2.5e-08 0 1e-12 uic
.control
set num_threads=1
run
write waveform.raw
quit 0
.endc
.end
