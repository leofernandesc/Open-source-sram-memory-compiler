Off-state envelope references, not model validation
.lib "/opt/pdks/sky130A/libs.tech/ngspice/sky130.lib.spice" ff
.temp -40
Vv0_off_drain_high_d v0_off_drain_high_d 0 1.8
Vv0_off_drain_high_g v0_off_drain_high_g 0 0
Vv0_off_drain_high_s v0_off_drain_high_s 0 0
Vv0_off_drain_high_b v0_off_drain_high_b 0 0
Xv0_off_drain_high v0_off_drain_high_d v0_off_drain_high_g v0_off_drain_high_s v0_off_drain_high_b sky130_fd_pr__nfet_01v8 ad=0.435 pd=3.58 as=0.435 ps=3.58 w=1.5 l=0.15
Vv0_off_source_high_d v0_off_source_high_d 0 0
Vv0_off_source_high_g v0_off_source_high_g 0 0
Vv0_off_source_high_s v0_off_source_high_s 0 1.8
Vv0_off_source_high_b v0_off_source_high_b 0 0
Xv0_off_source_high v0_off_source_high_d v0_off_source_high_g v0_off_source_high_s v0_off_source_high_b sky130_fd_pr__nfet_01v8 ad=0.435 pd=3.58 as=0.435 ps=3.58 w=1.5 l=0.15
Vv0_gate_on_zero_vds_d v0_gate_on_zero_vds_d 0 0
Vv0_gate_on_zero_vds_g v0_gate_on_zero_vds_g 0 1.8
Vv0_gate_on_zero_vds_s v0_gate_on_zero_vds_s 0 0
Vv0_gate_on_zero_vds_b v0_gate_on_zero_vds_b 0 0
Xv0_gate_on_zero_vds v0_gate_on_zero_vds_d v0_gate_on_zero_vds_g v0_gate_on_zero_vds_s v0_gate_on_zero_vds_b sky130_fd_pr__nfet_01v8 ad=0.435 pd=3.58 as=0.435 ps=3.58 w=1.5 l=0.15
Vv1_off_drain_high_d v1_off_drain_high_d 0 1.8
Vv1_off_drain_high_g v1_off_drain_high_g 0 0
Vv1_off_drain_high_s v1_off_drain_high_s 0 0
Vv1_off_drain_high_b v1_off_drain_high_b 0 0
Xv1_off_drain_high v1_off_drain_high_d v1_off_drain_high_g v1_off_drain_high_s v1_off_drain_high_b sky130_fd_pr__nfet_01v8 ad=0.58 pd=4.58 as=0.58 ps=4.58 w=2 l=0.15
Vv1_off_source_high_d v1_off_source_high_d 0 0
Vv1_off_source_high_g v1_off_source_high_g 0 0
Vv1_off_source_high_s v1_off_source_high_s 0 1.8
Vv1_off_source_high_b v1_off_source_high_b 0 0
Xv1_off_source_high v1_off_source_high_d v1_off_source_high_g v1_off_source_high_s v1_off_source_high_b sky130_fd_pr__nfet_01v8 ad=0.58 pd=4.58 as=0.58 ps=4.58 w=2 l=0.15
Vv1_gate_on_zero_vds_d v1_gate_on_zero_vds_d 0 0
Vv1_gate_on_zero_vds_g v1_gate_on_zero_vds_g 0 1.8
Vv1_gate_on_zero_vds_s v1_gate_on_zero_vds_s 0 0
Vv1_gate_on_zero_vds_b v1_gate_on_zero_vds_b 0 0
Xv1_gate_on_zero_vds v1_gate_on_zero_vds_d v1_gate_on_zero_vds_g v1_gate_on_zero_vds_s v1_gate_on_zero_vds_b sky130_fd_pr__nfet_01v8 ad=0.58 pd=4.58 as=0.58 ps=4.58 w=2 l=0.15
Vv2_off_drain_high_d v2_off_drain_high_d 0 0
Vv2_off_drain_high_g v2_off_drain_high_g 0 1.8
Vv2_off_drain_high_s v2_off_drain_high_s 0 1.8
Vv2_off_drain_high_b v2_off_drain_high_b 0 1.8
Xv2_off_drain_high v2_off_drain_high_d v2_off_drain_high_g v2_off_drain_high_s v2_off_drain_high_b sky130_fd_pr__pfet_01v8 ad=0.87 pd=6.58 as=0.87 ps=6.58 w=3 l=0.15
Vv2_off_source_high_d v2_off_source_high_d 0 1.8
Vv2_off_source_high_g v2_off_source_high_g 0 1.8
Vv2_off_source_high_s v2_off_source_high_s 0 0
Vv2_off_source_high_b v2_off_source_high_b 0 1.8
Xv2_off_source_high v2_off_source_high_d v2_off_source_high_g v2_off_source_high_s v2_off_source_high_b sky130_fd_pr__pfet_01v8 ad=0.87 pd=6.58 as=0.87 ps=6.58 w=3 l=0.15
Vv2_gate_on_zero_vds_d v2_gate_on_zero_vds_d 0 1.8
Vv2_gate_on_zero_vds_g v2_gate_on_zero_vds_g 0 0
Vv2_gate_on_zero_vds_s v2_gate_on_zero_vds_s 0 1.8
Vv2_gate_on_zero_vds_b v2_gate_on_zero_vds_b 0 1.8
Xv2_gate_on_zero_vds v2_gate_on_zero_vds_d v2_gate_on_zero_vds_g v2_gate_on_zero_vds_s v2_gate_on_zero_vds_b sky130_fd_pr__pfet_01v8 ad=0.87 pd=6.58 as=0.87 ps=6.58 w=3 l=0.15
Vv2_restore_at_n90_d v2_restore_at_n90_d 0 1.62
Vv2_restore_at_n90_g v2_restore_at_n90_g 0 0
Vv2_restore_at_n90_s v2_restore_at_n90_s 0 1.8
Vv2_restore_at_n90_b v2_restore_at_n90_b 0 1.8
Xv2_restore_at_n90 v2_restore_at_n90_d v2_restore_at_n90_g v2_restore_at_n90_s v2_restore_at_n90_b sky130_fd_pr__pfet_01v8 ad=0.87 pd=6.58 as=0.87 ps=6.58 w=3 l=0.15
Vv3_off_drain_high_d v3_off_drain_high_d 0 1.8
Vv3_off_drain_high_g v3_off_drain_high_g 0 0
Vv3_off_drain_high_s v3_off_drain_high_s 0 0
Vv3_off_drain_high_b v3_off_drain_high_b 0 0
Xv3_off_drain_high v3_off_drain_high_d v3_off_drain_high_g v3_off_drain_high_s v3_off_drain_high_b sky130_fd_pr__nfet_01v8 ad=0.2436 pd=2.26 as=0.2436 ps=2.26 w=0.84 l=0.15
Vv3_off_source_high_d v3_off_source_high_d 0 0
Vv3_off_source_high_g v3_off_source_high_g 0 0
Vv3_off_source_high_s v3_off_source_high_s 0 1.8
Vv3_off_source_high_b v3_off_source_high_b 0 0
Xv3_off_source_high v3_off_source_high_d v3_off_source_high_g v3_off_source_high_s v3_off_source_high_b sky130_fd_pr__nfet_01v8 ad=0.2436 pd=2.26 as=0.2436 ps=2.26 w=0.84 l=0.15
Vv3_gate_on_zero_vds_d v3_gate_on_zero_vds_d 0 0
Vv3_gate_on_zero_vds_g v3_gate_on_zero_vds_g 0 1.8
Vv3_gate_on_zero_vds_s v3_gate_on_zero_vds_s 0 0
Vv3_gate_on_zero_vds_b v3_gate_on_zero_vds_b 0 0
Xv3_gate_on_zero_vds v3_gate_on_zero_vds_d v3_gate_on_zero_vds_g v3_gate_on_zero_vds_s v3_gate_on_zero_vds_b sky130_fd_pr__nfet_01v8 ad=0.2436 pd=2.26 as=0.2436 ps=2.26 w=0.84 l=0.15
Vv4_off_drain_high_d v4_off_drain_high_d 0 0
Vv4_off_drain_high_g v4_off_drain_high_g 0 1.8
Vv4_off_drain_high_s v4_off_drain_high_s 0 1.8
Vv4_off_drain_high_b v4_off_drain_high_b 0 1.8
Xv4_off_drain_high v4_off_drain_high_d v4_off_drain_high_g v4_off_drain_high_s v4_off_drain_high_b sky130_fd_pr__pfet_01v8 ad=0.3625 pd=3.08 as=0.3625 ps=3.08 w=1.25 l=0.15
Vv4_off_source_high_d v4_off_source_high_d 0 1.8
Vv4_off_source_high_g v4_off_source_high_g 0 1.8
Vv4_off_source_high_s v4_off_source_high_s 0 0
Vv4_off_source_high_b v4_off_source_high_b 0 1.8
Xv4_off_source_high v4_off_source_high_d v4_off_source_high_g v4_off_source_high_s v4_off_source_high_b sky130_fd_pr__pfet_01v8 ad=0.3625 pd=3.08 as=0.3625 ps=3.08 w=1.25 l=0.15
Vv4_gate_on_zero_vds_d v4_gate_on_zero_vds_d 0 1.8
Vv4_gate_on_zero_vds_g v4_gate_on_zero_vds_g 0 0
Vv4_gate_on_zero_vds_s v4_gate_on_zero_vds_s 0 1.8
Vv4_gate_on_zero_vds_b v4_gate_on_zero_vds_b 0 1.8
Xv4_gate_on_zero_vds v4_gate_on_zero_vds_d v4_gate_on_zero_vds_g v4_gate_on_zero_vds_s v4_gate_on_zero_vds_b sky130_fd_pr__pfet_01v8 ad=0.3625 pd=3.08 as=0.3625 ps=3.08 w=1.25 l=0.15
Vv4_restore_at_n90_d v4_restore_at_n90_d 0 1.62
Vv4_restore_at_n90_g v4_restore_at_n90_g 0 0
Vv4_restore_at_n90_s v4_restore_at_n90_s 0 1.8
Vv4_restore_at_n90_b v4_restore_at_n90_b 0 1.8
Xv4_restore_at_n90 v4_restore_at_n90_d v4_restore_at_n90_g v4_restore_at_n90_s v4_restore_at_n90_b sky130_fd_pr__pfet_01v8 ad=0.3625 pd=3.08 as=0.3625 ps=3.08 w=1.25 l=0.15
Vv5_off_drain_high_d v5_off_drain_high_d 0 0
Vv5_off_drain_high_g v5_off_drain_high_g 0 1.8
Vv5_off_drain_high_s v5_off_drain_high_s 0 1.8
Vv5_off_drain_high_b v5_off_drain_high_b 0 1.8
Xv5_off_drain_high v5_off_drain_high_d v5_off_drain_high_g v5_off_drain_high_s v5_off_drain_high_b sky130_fd_pr__pfet_01v8 ad=0.2436 pd=2.26 as=0.2436 ps=2.26 w=0.84 l=0.15
Vv5_off_source_high_d v5_off_source_high_d 0 1.8
Vv5_off_source_high_g v5_off_source_high_g 0 1.8
Vv5_off_source_high_s v5_off_source_high_s 0 0
Vv5_off_source_high_b v5_off_source_high_b 0 1.8
Xv5_off_source_high v5_off_source_high_d v5_off_source_high_g v5_off_source_high_s v5_off_source_high_b sky130_fd_pr__pfet_01v8 ad=0.2436 pd=2.26 as=0.2436 ps=2.26 w=0.84 l=0.15
Vv5_gate_on_zero_vds_d v5_gate_on_zero_vds_d 0 1.8
Vv5_gate_on_zero_vds_g v5_gate_on_zero_vds_g 0 0
Vv5_gate_on_zero_vds_s v5_gate_on_zero_vds_s 0 1.8
Vv5_gate_on_zero_vds_b v5_gate_on_zero_vds_b 0 1.8
Xv5_gate_on_zero_vds v5_gate_on_zero_vds_d v5_gate_on_zero_vds_g v5_gate_on_zero_vds_s v5_gate_on_zero_vds_b sky130_fd_pr__pfet_01v8 ad=0.2436 pd=2.26 as=0.2436 ps=2.26 w=0.84 l=0.15
Vv5_restore_at_n90_d v5_restore_at_n90_d 0 1.62
Vv5_restore_at_n90_g v5_restore_at_n90_g 0 0
Vv5_restore_at_n90_s v5_restore_at_n90_s 0 1.8
Vv5_restore_at_n90_b v5_restore_at_n90_b 0 1.8
Xv5_restore_at_n90 v5_restore_at_n90_d v5_restore_at_n90_g v5_restore_at_n90_s v5_restore_at_n90_b sky130_fd_pr__pfet_01v8 ad=0.2436 pd=2.26 as=0.2436 ps=2.26 w=0.84 l=0.15
Vv6_off_drain_high_d v6_off_drain_high_d 0 0
Vv6_off_drain_high_g v6_off_drain_high_g 0 1.8
Vv6_off_drain_high_s v6_off_drain_high_s 0 1.8
Vv6_off_drain_high_b v6_off_drain_high_b 0 1.8
Xv6_off_drain_high v6_off_drain_high_d v6_off_drain_high_g v6_off_drain_high_s v6_off_drain_high_b sky130_fd_pr__pfet_01v8 ad=0.58 pd=4.58 as=0.58 ps=4.58 w=2 l=0.15
Vv6_off_source_high_d v6_off_source_high_d 0 1.8
Vv6_off_source_high_g v6_off_source_high_g 0 1.8
Vv6_off_source_high_s v6_off_source_high_s 0 0
Vv6_off_source_high_b v6_off_source_high_b 0 1.8
Xv6_off_source_high v6_off_source_high_d v6_off_source_high_g v6_off_source_high_s v6_off_source_high_b sky130_fd_pr__pfet_01v8 ad=0.58 pd=4.58 as=0.58 ps=4.58 w=2 l=0.15
Vv6_gate_on_zero_vds_d v6_gate_on_zero_vds_d 0 1.8
Vv6_gate_on_zero_vds_g v6_gate_on_zero_vds_g 0 0
Vv6_gate_on_zero_vds_s v6_gate_on_zero_vds_s 0 1.8
Vv6_gate_on_zero_vds_b v6_gate_on_zero_vds_b 0 1.8
Xv6_gate_on_zero_vds v6_gate_on_zero_vds_d v6_gate_on_zero_vds_g v6_gate_on_zero_vds_s v6_gate_on_zero_vds_b sky130_fd_pr__pfet_01v8 ad=0.58 pd=4.58 as=0.58 ps=4.58 w=2 l=0.15
Vv6_restore_at_n90_d v6_restore_at_n90_d 0 1.62
Vv6_restore_at_n90_g v6_restore_at_n90_g 0 0
Vv6_restore_at_n90_s v6_restore_at_n90_s 0 1.8
Vv6_restore_at_n90_b v6_restore_at_n90_b 0 1.8
Xv6_restore_at_n90 v6_restore_at_n90_d v6_restore_at_n90_g v6_restore_at_n90_s v6_restore_at_n90_b sky130_fd_pr__pfet_01v8 ad=0.58 pd=4.58 as=0.58 ps=4.58 w=2 l=0.15
Vv7_off_drain_high_d v7_off_drain_high_d 0 1.8
Vv7_off_drain_high_g v7_off_drain_high_g 0 0
Vv7_off_drain_high_s v7_off_drain_high_s 0 0
Vv7_off_drain_high_b v7_off_drain_high_b 0 0
Xv7_off_drain_high v7_off_drain_high_d v7_off_drain_high_g v7_off_drain_high_s v7_off_drain_high_b sky130_fd_pr__nfet_01v8 ad=1.4616 pd=10.66 as=1.4616 ps=10.66 w=5.04 l=0.15
Vv7_off_source_high_d v7_off_source_high_d 0 0
Vv7_off_source_high_g v7_off_source_high_g 0 0
Vv7_off_source_high_s v7_off_source_high_s 0 1.8
Vv7_off_source_high_b v7_off_source_high_b 0 0
Xv7_off_source_high v7_off_source_high_d v7_off_source_high_g v7_off_source_high_s v7_off_source_high_b sky130_fd_pr__nfet_01v8 ad=1.4616 pd=10.66 as=1.4616 ps=10.66 w=5.04 l=0.15
Vv7_gate_on_zero_vds_d v7_gate_on_zero_vds_d 0 0
Vv7_gate_on_zero_vds_g v7_gate_on_zero_vds_g 0 1.8
Vv7_gate_on_zero_vds_s v7_gate_on_zero_vds_s 0 0
Vv7_gate_on_zero_vds_b v7_gate_on_zero_vds_b 0 0
Xv7_gate_on_zero_vds v7_gate_on_zero_vds_d v7_gate_on_zero_vds_g v7_gate_on_zero_vds_s v7_gate_on_zero_vds_b sky130_fd_pr__nfet_01v8 ad=1.4616 pd=10.66 as=1.4616 ps=10.66 w=5.04 l=0.15
Vv8_off_drain_high_d v8_off_drain_high_d 0 1.8
Vv8_off_drain_high_g v8_off_drain_high_g 0 0
Vv8_off_drain_high_s v8_off_drain_high_s 0 0
Vv8_off_drain_high_b v8_off_drain_high_b 0 0
Xv8_off_drain_high v8_off_drain_high_d v8_off_drain_high_g v8_off_drain_high_s v8_off_drain_high_b sky130_fd_pr__nfet_01v8 ad=0.4872 pd=3.94 as=0.4872 ps=3.94 w=1.68 l=0.15
Vv8_off_source_high_d v8_off_source_high_d 0 0
Vv8_off_source_high_g v8_off_source_high_g 0 0
Vv8_off_source_high_s v8_off_source_high_s 0 1.8
Vv8_off_source_high_b v8_off_source_high_b 0 0
Xv8_off_source_high v8_off_source_high_d v8_off_source_high_g v8_off_source_high_s v8_off_source_high_b sky130_fd_pr__nfet_01v8 ad=0.4872 pd=3.94 as=0.4872 ps=3.94 w=1.68 l=0.15
Vv8_gate_on_zero_vds_d v8_gate_on_zero_vds_d 0 0
Vv8_gate_on_zero_vds_g v8_gate_on_zero_vds_g 0 1.8
Vv8_gate_on_zero_vds_s v8_gate_on_zero_vds_s 0 0
Vv8_gate_on_zero_vds_b v8_gate_on_zero_vds_b 0 0
Xv8_gate_on_zero_vds v8_gate_on_zero_vds_d v8_gate_on_zero_vds_g v8_gate_on_zero_vds_s v8_gate_on_zero_vds_b sky130_fd_pr__nfet_01v8 ad=0.4872 pd=3.94 as=0.4872 ps=3.94 w=1.68 l=0.15
Vv9_off_drain_high_d v9_off_drain_high_d 0 0
Vv9_off_drain_high_g v9_off_drain_high_g 0 1.8
Vv9_off_drain_high_s v9_off_drain_high_s 0 1.8
Vv9_off_drain_high_b v9_off_drain_high_b 0 1.8
Xv9_off_drain_high v9_off_drain_high_d v9_off_drain_high_g v9_off_drain_high_s v9_off_drain_high_b sky130_fd_pr__pfet_01v8 ad=1.4616 pd=10.66 as=1.4616 ps=10.66 w=5.04 l=0.15
Vv9_off_source_high_d v9_off_source_high_d 0 1.8
Vv9_off_source_high_g v9_off_source_high_g 0 1.8
Vv9_off_source_high_s v9_off_source_high_s 0 0
Vv9_off_source_high_b v9_off_source_high_b 0 1.8
Xv9_off_source_high v9_off_source_high_d v9_off_source_high_g v9_off_source_high_s v9_off_source_high_b sky130_fd_pr__pfet_01v8 ad=1.4616 pd=10.66 as=1.4616 ps=10.66 w=5.04 l=0.15
Vv9_gate_on_zero_vds_d v9_gate_on_zero_vds_d 0 1.8
Vv9_gate_on_zero_vds_g v9_gate_on_zero_vds_g 0 0
Vv9_gate_on_zero_vds_s v9_gate_on_zero_vds_s 0 1.8
Vv9_gate_on_zero_vds_b v9_gate_on_zero_vds_b 0 1.8
Xv9_gate_on_zero_vds v9_gate_on_zero_vds_d v9_gate_on_zero_vds_g v9_gate_on_zero_vds_s v9_gate_on_zero_vds_b sky130_fd_pr__pfet_01v8 ad=1.4616 pd=10.66 as=1.4616 ps=10.66 w=5.04 l=0.15
Vv9_restore_at_n90_d v9_restore_at_n90_d 0 1.62
Vv9_restore_at_n90_g v9_restore_at_n90_g 0 0
Vv9_restore_at_n90_s v9_restore_at_n90_s 0 1.8
Vv9_restore_at_n90_b v9_restore_at_n90_b 0 1.8
Xv9_restore_at_n90 v9_restore_at_n90_d v9_restore_at_n90_g v9_restore_at_n90_s v9_restore_at_n90_b sky130_fd_pr__pfet_01v8 ad=1.4616 pd=10.66 as=1.4616 ps=10.66 w=5.04 l=0.15
Vv10_off_drain_high_d v10_off_drain_high_d 0 0
Vv10_off_drain_high_g v10_off_drain_high_g 0 1.8
Vv10_off_drain_high_s v10_off_drain_high_s 0 1.8
Vv10_off_drain_high_b v10_off_drain_high_b 0 1.8
Xv10_off_drain_high v10_off_drain_high_d v10_off_drain_high_g v10_off_drain_high_s v10_off_drain_high_b sky130_fd_pr__pfet_01v8 ad=0.4872 pd=3.94 as=0.4872 ps=3.94 w=1.68 l=0.15
Vv10_off_source_high_d v10_off_source_high_d 0 1.8
Vv10_off_source_high_g v10_off_source_high_g 0 1.8
Vv10_off_source_high_s v10_off_source_high_s 0 0
Vv10_off_source_high_b v10_off_source_high_b 0 1.8
Xv10_off_source_high v10_off_source_high_d v10_off_source_high_g v10_off_source_high_s v10_off_source_high_b sky130_fd_pr__pfet_01v8 ad=0.4872 pd=3.94 as=0.4872 ps=3.94 w=1.68 l=0.15
Vv10_gate_on_zero_vds_d v10_gate_on_zero_vds_d 0 1.8
Vv10_gate_on_zero_vds_g v10_gate_on_zero_vds_g 0 0
Vv10_gate_on_zero_vds_s v10_gate_on_zero_vds_s 0 1.8
Vv10_gate_on_zero_vds_b v10_gate_on_zero_vds_b 0 1.8
Xv10_gate_on_zero_vds v10_gate_on_zero_vds_d v10_gate_on_zero_vds_g v10_gate_on_zero_vds_s v10_gate_on_zero_vds_b sky130_fd_pr__pfet_01v8 ad=0.4872 pd=3.94 as=0.4872 ps=3.94 w=1.68 l=0.15
Vv10_restore_at_n90_d v10_restore_at_n90_d 0 1.62
Vv10_restore_at_n90_g v10_restore_at_n90_g 0 0
Vv10_restore_at_n90_s v10_restore_at_n90_s 0 1.8
Vv10_restore_at_n90_b v10_restore_at_n90_b 0 1.8
Xv10_restore_at_n90 v10_restore_at_n90_d v10_restore_at_n90_g v10_restore_at_n90_s v10_restore_at_n90_b sky130_fd_pr__pfet_01v8 ad=0.4872 pd=3.94 as=0.4872 ps=3.94 w=1.68 l=0.15
Vv11_off_drain_high_d v11_off_drain_high_d 0 0
Vv11_off_drain_high_g v11_off_drain_high_g 0 1.8
Vv11_off_drain_high_s v11_off_drain_high_s 0 1.8
Vv11_off_drain_high_b v11_off_drain_high_b 0 1.8
Xv11_off_drain_high v11_off_drain_high_d v11_off_drain_high_g v11_off_drain_high_s v11_off_drain_high_b sky130_fd_pr__pfet_01v8 w=0.42 l=0.15 ad=0.1218 as=0.1218 pd=1.42 ps=1.42 nrd=0.690476 nrs=0.690476
Vv11_off_source_high_d v11_off_source_high_d 0 1.8
Vv11_off_source_high_g v11_off_source_high_g 0 1.8
Vv11_off_source_high_s v11_off_source_high_s 0 0
Vv11_off_source_high_b v11_off_source_high_b 0 1.8
Xv11_off_source_high v11_off_source_high_d v11_off_source_high_g v11_off_source_high_s v11_off_source_high_b sky130_fd_pr__pfet_01v8 w=0.42 l=0.15 ad=0.1218 as=0.1218 pd=1.42 ps=1.42 nrd=0.690476 nrs=0.690476
Vv11_gate_on_zero_vds_d v11_gate_on_zero_vds_d 0 1.8
Vv11_gate_on_zero_vds_g v11_gate_on_zero_vds_g 0 0
Vv11_gate_on_zero_vds_s v11_gate_on_zero_vds_s 0 1.8
Vv11_gate_on_zero_vds_b v11_gate_on_zero_vds_b 0 1.8
Xv11_gate_on_zero_vds v11_gate_on_zero_vds_d v11_gate_on_zero_vds_g v11_gate_on_zero_vds_s v11_gate_on_zero_vds_b sky130_fd_pr__pfet_01v8 w=0.42 l=0.15 ad=0.1218 as=0.1218 pd=1.42 ps=1.42 nrd=0.690476 nrs=0.690476
Vv11_restore_at_n90_d v11_restore_at_n90_d 0 1.62
Vv11_restore_at_n90_g v11_restore_at_n90_g 0 0
Vv11_restore_at_n90_s v11_restore_at_n90_s 0 1.8
Vv11_restore_at_n90_b v11_restore_at_n90_b 0 1.8
Xv11_restore_at_n90 v11_restore_at_n90_d v11_restore_at_n90_g v11_restore_at_n90_s v11_restore_at_n90_b sky130_fd_pr__pfet_01v8 w=0.42 l=0.15 ad=0.1218 as=0.1218 pd=1.42 ps=1.42 nrd=0.690476 nrs=0.690476
Vv12_off_drain_high_d v12_off_drain_high_d 0 0
Vv12_off_drain_high_g v12_off_drain_high_g 0 1.8
Vv12_off_drain_high_s v12_off_drain_high_s 0 1.8
Vv12_off_drain_high_b v12_off_drain_high_b 0 1.8
Xv12_off_drain_high v12_off_drain_high_d v12_off_drain_high_g v12_off_drain_high_s v12_off_drain_high_b sky130_fd_pr__pfet_01v8 w=0.84 l=0.15 ad=0.2436 as=0.2436 pd=2.26 ps=2.26 nrd=0.345238 nrs=0.345238
Vv12_off_source_high_d v12_off_source_high_d 0 1.8
Vv12_off_source_high_g v12_off_source_high_g 0 1.8
Vv12_off_source_high_s v12_off_source_high_s 0 0
Vv12_off_source_high_b v12_off_source_high_b 0 1.8
Xv12_off_source_high v12_off_source_high_d v12_off_source_high_g v12_off_source_high_s v12_off_source_high_b sky130_fd_pr__pfet_01v8 w=0.84 l=0.15 ad=0.2436 as=0.2436 pd=2.26 ps=2.26 nrd=0.345238 nrs=0.345238
Vv12_gate_on_zero_vds_d v12_gate_on_zero_vds_d 0 1.8
Vv12_gate_on_zero_vds_g v12_gate_on_zero_vds_g 0 0
Vv12_gate_on_zero_vds_s v12_gate_on_zero_vds_s 0 1.8
Vv12_gate_on_zero_vds_b v12_gate_on_zero_vds_b 0 1.8
Xv12_gate_on_zero_vds v12_gate_on_zero_vds_d v12_gate_on_zero_vds_g v12_gate_on_zero_vds_s v12_gate_on_zero_vds_b sky130_fd_pr__pfet_01v8 w=0.84 l=0.15 ad=0.2436 as=0.2436 pd=2.26 ps=2.26 nrd=0.345238 nrs=0.345238
Vv12_restore_at_n90_d v12_restore_at_n90_d 0 1.62
Vv12_restore_at_n90_g v12_restore_at_n90_g 0 0
Vv12_restore_at_n90_s v12_restore_at_n90_s 0 1.8
Vv12_restore_at_n90_b v12_restore_at_n90_b 0 1.8
Xv12_restore_at_n90 v12_restore_at_n90_d v12_restore_at_n90_g v12_restore_at_n90_s v12_restore_at_n90_b sky130_fd_pr__pfet_01v8 w=0.84 l=0.15 ad=0.2436 as=0.2436 pd=2.26 ps=2.26 nrd=0.345238 nrs=0.345238
.save i(Vv0_off_drain_high_d) i(Vv0_off_drain_high_g) i(Vv0_off_drain_high_s) i(Vv0_off_drain_high_b) i(Vv0_off_source_high_d) i(Vv0_off_source_high_g) i(Vv0_off_source_high_s) i(Vv0_off_source_high_b) i(Vv0_gate_on_zero_vds_d) i(Vv0_gate_on_zero_vds_g) i(Vv0_gate_on_zero_vds_s) i(Vv0_gate_on_zero_vds_b) i(Vv1_off_drain_high_d) i(Vv1_off_drain_high_g) i(Vv1_off_drain_high_s) i(Vv1_off_drain_high_b) i(Vv1_off_source_high_d) i(Vv1_off_source_high_g) i(Vv1_off_source_high_s) i(Vv1_off_source_high_b) i(Vv1_gate_on_zero_vds_d) i(Vv1_gate_on_zero_vds_g) i(Vv1_gate_on_zero_vds_s) i(Vv1_gate_on_zero_vds_b) i(Vv2_off_drain_high_d) i(Vv2_off_drain_high_g) i(Vv2_off_drain_high_s) i(Vv2_off_drain_high_b) i(Vv2_off_source_high_d) i(Vv2_off_source_high_g) i(Vv2_off_source_high_s) i(Vv2_off_source_high_b) i(Vv2_gate_on_zero_vds_d) i(Vv2_gate_on_zero_vds_g) i(Vv2_gate_on_zero_vds_s) i(Vv2_gate_on_zero_vds_b) i(Vv2_restore_at_n90_d) i(Vv2_restore_at_n90_g) i(Vv2_restore_at_n90_s) i(Vv2_restore_at_n90_b) i(Vv3_off_drain_high_d) i(Vv3_off_drain_high_g) i(Vv3_off_drain_high_s) i(Vv3_off_drain_high_b) i(Vv3_off_source_high_d) i(Vv3_off_source_high_g) i(Vv3_off_source_high_s) i(Vv3_off_source_high_b) i(Vv3_gate_on_zero_vds_d) i(Vv3_gate_on_zero_vds_g) i(Vv3_gate_on_zero_vds_s) i(Vv3_gate_on_zero_vds_b) i(Vv4_off_drain_high_d) i(Vv4_off_drain_high_g) i(Vv4_off_drain_high_s) i(Vv4_off_drain_high_b) i(Vv4_off_source_high_d) i(Vv4_off_source_high_g) i(Vv4_off_source_high_s) i(Vv4_off_source_high_b) i(Vv4_gate_on_zero_vds_d) i(Vv4_gate_on_zero_vds_g) i(Vv4_gate_on_zero_vds_s) i(Vv4_gate_on_zero_vds_b) i(Vv4_restore_at_n90_d) i(Vv4_restore_at_n90_g) i(Vv4_restore_at_n90_s) i(Vv4_restore_at_n90_b) i(Vv5_off_drain_high_d) i(Vv5_off_drain_high_g) i(Vv5_off_drain_high_s) i(Vv5_off_drain_high_b) i(Vv5_off_source_high_d) i(Vv5_off_source_high_g) i(Vv5_off_source_high_s) i(Vv5_off_source_high_b) i(Vv5_gate_on_zero_vds_d) i(Vv5_gate_on_zero_vds_g) i(Vv5_gate_on_zero_vds_s) i(Vv5_gate_on_zero_vds_b) i(Vv5_restore_at_n90_d) i(Vv5_restore_at_n90_g) i(Vv5_restore_at_n90_s) i(Vv5_restore_at_n90_b) i(Vv6_off_drain_high_d) i(Vv6_off_drain_high_g) i(Vv6_off_drain_high_s) i(Vv6_off_drain_high_b) i(Vv6_off_source_high_d) i(Vv6_off_source_high_g) i(Vv6_off_source_high_s) i(Vv6_off_source_high_b) i(Vv6_gate_on_zero_vds_d) i(Vv6_gate_on_zero_vds_g) i(Vv6_gate_on_zero_vds_s) i(Vv6_gate_on_zero_vds_b) i(Vv6_restore_at_n90_d) i(Vv6_restore_at_n90_g) i(Vv6_restore_at_n90_s) i(Vv6_restore_at_n90_b) i(Vv7_off_drain_high_d) i(Vv7_off_drain_high_g) i(Vv7_off_drain_high_s) i(Vv7_off_drain_high_b) i(Vv7_off_source_high_d) i(Vv7_off_source_high_g) i(Vv7_off_source_high_s) i(Vv7_off_source_high_b) i(Vv7_gate_on_zero_vds_d) i(Vv7_gate_on_zero_vds_g) i(Vv7_gate_on_zero_vds_s) i(Vv7_gate_on_zero_vds_b) i(Vv8_off_drain_high_d) i(Vv8_off_drain_high_g) i(Vv8_off_drain_high_s) i(Vv8_off_drain_high_b) i(Vv8_off_source_high_d) i(Vv8_off_source_high_g) i(Vv8_off_source_high_s) i(Vv8_off_source_high_b) i(Vv8_gate_on_zero_vds_d) i(Vv8_gate_on_zero_vds_g) i(Vv8_gate_on_zero_vds_s) i(Vv8_gate_on_zero_vds_b) i(Vv9_off_drain_high_d) i(Vv9_off_drain_high_g) i(Vv9_off_drain_high_s) i(Vv9_off_drain_high_b) i(Vv9_off_source_high_d) i(Vv9_off_source_high_g) i(Vv9_off_source_high_s) i(Vv9_off_source_high_b) i(Vv9_gate_on_zero_vds_d) i(Vv9_gate_on_zero_vds_g) i(Vv9_gate_on_zero_vds_s) i(Vv9_gate_on_zero_vds_b) i(Vv9_restore_at_n90_d) i(Vv9_restore_at_n90_g) i(Vv9_restore_at_n90_s) i(Vv9_restore_at_n90_b) i(Vv10_off_drain_high_d) i(Vv10_off_drain_high_g) i(Vv10_off_drain_high_s) i(Vv10_off_drain_high_b) i(Vv10_off_source_high_d) i(Vv10_off_source_high_g) i(Vv10_off_source_high_s) i(Vv10_off_source_high_b) i(Vv10_gate_on_zero_vds_d) i(Vv10_gate_on_zero_vds_g) i(Vv10_gate_on_zero_vds_s) i(Vv10_gate_on_zero_vds_b) i(Vv10_restore_at_n90_d) i(Vv10_restore_at_n90_g) i(Vv10_restore_at_n90_s) i(Vv10_restore_at_n90_b) i(Vv11_off_drain_high_d) i(Vv11_off_drain_high_g) i(Vv11_off_drain_high_s) i(Vv11_off_drain_high_b) i(Vv11_off_source_high_d) i(Vv11_off_source_high_g) i(Vv11_off_source_high_s) i(Vv11_off_source_high_b) i(Vv11_gate_on_zero_vds_d) i(Vv11_gate_on_zero_vds_g) i(Vv11_gate_on_zero_vds_s) i(Vv11_gate_on_zero_vds_b) i(Vv11_restore_at_n90_d) i(Vv11_restore_at_n90_g) i(Vv11_restore_at_n90_s) i(Vv11_restore_at_n90_b) i(Vv12_off_drain_high_d) i(Vv12_off_drain_high_g) i(Vv12_off_drain_high_s) i(Vv12_off_drain_high_b) i(Vv12_off_source_high_d) i(Vv12_off_source_high_g) i(Vv12_off_source_high_s) i(Vv12_off_source_high_b) i(Vv12_gate_on_zero_vds_d) i(Vv12_gate_on_zero_vds_g) i(Vv12_gate_on_zero_vds_s) i(Vv12_gate_on_zero_vds_b) i(Vv12_restore_at_n90_d) i(Vv12_restore_at_n90_g) i(Vv12_restore_at_n90_s) i(Vv12_restore_at_n90_b)
.control
set num_threads=1
set filetype=binary
op
write currents.raw
quit
.endc
.end
