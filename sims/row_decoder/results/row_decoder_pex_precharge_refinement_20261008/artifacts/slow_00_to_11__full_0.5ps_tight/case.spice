** sch_path: /work/sims/row_decoder/tb_row_decoder_sizing.sch
**.subckt tb_row_decoder_sizing
x1 net1 net2 net3 net4 DEC0 DEC1 DEC3 DEC2 GND row_decoder
VDD_SRC net1 GND 1.62
VPCLK net2 GND PWL(0 0 4.975e-09 0 5.025e-09 1.62 9.975e-09 1.62 1.0025e-08 0 1.9975e-08 0 2.0025e-08 1.62 2.4975e-08 1.62 2.5025e-08 0 3e-08 0)
VA0 net3 GND PWL(0 0 1.795e-08 0 1.8e-08 1.62 3e-08 1.62)
VA1 net4 GND PWL(0 0 1.795e-08 0 1.8e-08 1.62 3e-08 1.62)
x2 net1 DEC0 net5 GND wl_driver
x3 net1 DEC1 net6 GND wl_driver
x4 net1 DEC3 net8 GND wl_driver
x5 net1 DEC2 net7 GND wl_driver
C_WL0 net5 GND 1.74e-14 m=1
C_WL1 net6 GND 1.74e-14 m=1
C_WL2 net7 GND 1.74e-14 m=1
C_WL3 net8 GND 1.74e-14 m=1
**.ends

* expanding   symbol:  row_decoder.sym # of pins=9
** sym_path: /work/cells/row_decoder/row_decoder.sym
** sch_path: /work/cells/row_decoder/row_decoder.sch
.subckt row_decoder VDD PCLK A0 A1 DEC0 DEC1 DEC3 DEC2 VSS
X0 VSS.t5 N2 DEC2 VSS.t4 sky130_fd_pr__nfet_01v8 ad=0.58 pd=4.58 as=0.58 ps=4.58 w=2 l=0.15
X1 VSS.t19 A1B A1T VSS.t18 sky130_fd_pr__nfet_01v8 ad=0.58 pd=4.58 as=0.58 ps=4.58 w=2 l=0.15
X2 VSS.t15 A1 A1B VSS.t14 sky130_fd_pr__nfet_01v8 ad=0.1218 pd=1.42 as=0.1218 ps=1.42 w=0.42 l=0.15
X3 EVAL_GND A0B net3 VSS.t11 sky130_fd_pr__nfet_01v8 ad=0.58 pd=4.58 as=0.58 ps=4.58 w=2 l=0.15
X4 VSS.t13 A0B A0T VSS.t12 sky130_fd_pr__nfet_01v8 ad=0.58 pd=4.58 as=0.58 ps=4.58 w=2 l=0.15
X5 VSS.t23 A0 A0B VSS.t22 sky130_fd_pr__nfet_01v8 ad=0.1218 pd=1.42 as=0.1218 ps=1.42 w=0.42 l=0.15
X6 VDD PCLK N0 VDD sky130_fd_pr__pfet_01v8 ad=0.58 pd=4.58 as=0.58 ps=4.58 w=2 l=0.15
X7 VDD PCLK N1 VDD sky130_fd_pr__pfet_01v8 ad=0.58 pd=4.58 as=0.58 ps=4.58 w=2 l=0.15
X8 EVAL_GND A0T net2 VSS.t0 sky130_fd_pr__nfet_01v8 ad=0.58 pd=4.58 as=0.58 ps=4.58 w=2 l=0.15
X9 VDD PCLK N2 VDD sky130_fd_pr__pfet_01v8 ad=0.58 pd=4.58 as=0.58 ps=4.58 w=2 l=0.15
X10 VDD N2 DEC2 VDD sky130_fd_pr__pfet_01v8 ad=0.87 pd=6.58 as=0.87 ps=6.58 w=3 l=0.15
X11 net4 A1T N3 VSS.t21 sky130_fd_pr__nfet_01v8 ad=0.58 pd=4.58 as=0.58 ps=4.58 w=2 l=0.15
X12 VDD N3 DEC3 VDD sky130_fd_pr__pfet_01v8 ad=0.87 pd=6.58 as=0.87 ps=6.58 w=3 l=0.15
X13 VDD A1 A1B VDD sky130_fd_pr__pfet_01v8 ad=0.1218 pd=1.42 as=0.1218 ps=1.42 w=0.42 l=0.15
X14 VDD A1B A1T VDD sky130_fd_pr__pfet_01v8 ad=0.58 pd=4.58 as=0.58 ps=4.58 w=2 l=0.15
X15 EVAL_GND A0B net1 VSS.t10 sky130_fd_pr__nfet_01v8 ad=0.58 pd=4.58 as=0.58 ps=4.58 w=2 l=0.15
X16 VSS.t25 PCLK EVAL_GND VSS.t24 sky130_fd_pr__nfet_01v8 ad=0.435 pd=3.58 as=0.435 ps=3.58 w=1.5 l=0.15
X17 net3 A1T N2 VSS.t20 sky130_fd_pr__nfet_01v8 ad=0.58 pd=4.58 as=0.58 ps=4.58 w=2 l=0.15
X18 VSS.t9 N1 DEC1 VSS.t8 sky130_fd_pr__nfet_01v8 ad=0.58 pd=4.58 as=0.58 ps=4.58 w=2 l=0.15
X19 VDD PCLK N3 VDD sky130_fd_pr__pfet_01v8 ad=0.58 pd=4.58 as=0.58 ps=4.58 w=2 l=0.15
X20 VDD A0 A0B VDD sky130_fd_pr__pfet_01v8 ad=0.1218 pd=1.42 as=0.1218 ps=1.42 w=0.42 l=0.15
X21 VSS.t3 N3 DEC3 VSS.t2 sky130_fd_pr__nfet_01v8 ad=0.58 pd=4.58 as=0.58 ps=4.58 w=2 l=0.15
X22 EVAL_GND A0T net4 VSS.t1 sky130_fd_pr__nfet_01v8 ad=0.58 pd=4.58 as=0.58 ps=4.58 w=2 l=0.15
X23 VDD A0B A0T VDD sky130_fd_pr__pfet_01v8 ad=0.58 pd=4.58 as=0.58 ps=4.58 w=2 l=0.15
X24 VDD N0 DEC0 VDD sky130_fd_pr__pfet_01v8 ad=0.87 pd=6.58 as=0.87 ps=6.58 w=3 l=0.15
X25 net1 A1B N0 VSS.t16 sky130_fd_pr__nfet_01v8 ad=0.58 pd=4.58 as=0.58 ps=4.58 w=2 l=0.15
X26 net2 A1B N1 VSS.t17 sky130_fd_pr__nfet_01v8 ad=0.58 pd=4.58 as=0.58 ps=4.58 w=2 l=0.15
X27 VDD N1 DEC1 VDD sky130_fd_pr__pfet_01v8 ad=0.87 pd=6.58 as=0.87 ps=6.58 w=3 l=0.15
X28 VSS.t7 N0 DEC0 VSS.t6 sky130_fd_pr__nfet_01v8 ad=0.58 pd=4.58 as=0.58 ps=4.58 w=2 l=0.15
R0 VSS.n59 VSS.n49 127231
R1 VSS.n100 VSS.t2 127050
R2 VSS.n101 VSS.t4 100430
R3 VSS.n36 VSS.t8 100430
R4 VSS.t6 VSS.n8 100430
R5 VSS.n102 VSS.n101 66000
R6 VSS.n124 VSS.n36 66000
R7 VSS.n146 VSS.n8 66000
R8 VSS.n197 VSS.t14 60931.4
R9 VSS.n200 VSS.n197 24380.4
R10 VSS.n100 VSS.n49 6380
R11 VSS.n101 VSS.n100 3630.46
R12 VSS.n36 VSS.n8 3359.46
R13 VSS.n101 VSS.n36 3359.46
R14 VSS.t10 VSS.n8 3010.93
R15 VSS.n73 VSS.n50 2959.06
R16 VSS.n74 VSS.n70 2959.06
R17 VSS.n197 VSS.t10 2951.37
R18 VSS.n69 VSS.n61 2885.47
R19 VSS.n65 VSS.n61 2885.47
R20 VSS.n69 VSS.n60 2885.47
R21 VSS.n195 VSS.n11 2885.47
R22 VSS.n191 VSS.n11 2885.47
R23 VSS.n195 VSS.n10 2885.47
R24 VSS.n191 VSS.n10 2885.47
R25 VSS.n185 VSS.n173 2885.47
R26 VSS.n186 VSS.n185 2885.47
R27 VSS.n173 VSS.n171 2885.47
R28 VSS.n186 VSS.n171 2885.47
R29 VSS.n159 VSS.n19 2885.47
R30 VSS.n155 VSS.n19 2885.47
R31 VSS.n159 VSS.n18 2885.47
R32 VSS.n155 VSS.n18 2885.47
R33 VSS.n144 VSS.n26 2885.47
R34 VSS.n140 VSS.n26 2885.47
R35 VSS.n144 VSS.n25 2885.47
R36 VSS.n140 VSS.n25 2885.47
R37 VSS.n152 VSS.n22 2885.47
R38 VSS.n148 VSS.n22 2885.47
R39 VSS.n152 VSS.n21 2885.47
R40 VSS.n148 VSS.n21 2885.47
R41 VSS.n137 VSS.n30 2885.47
R42 VSS.n133 VSS.n30 2885.47
R43 VSS.n137 VSS.n29 2885.47
R44 VSS.n133 VSS.n29 2885.47
R45 VSS.n122 VSS.n38 2885.47
R46 VSS.n118 VSS.n38 2885.47
R47 VSS.n122 VSS.n37 2885.47
R48 VSS.n118 VSS.n37 2885.47
R49 VSS.n130 VSS.n33 2885.47
R50 VSS.n126 VSS.n33 2885.47
R51 VSS.n130 VSS.n32 2885.47
R52 VSS.n126 VSS.n32 2885.47
R53 VSS.n115 VSS.n42 2885.47
R54 VSS.n111 VSS.n42 2885.47
R55 VSS.n115 VSS.n41 2885.47
R56 VSS.n111 VSS.n41 2885.47
R57 VSS.n88 VSS.n87 2885.47
R58 VSS.n89 VSS.n88 2885.47
R59 VSS.n87 VSS.n85 2885.47
R60 VSS.n89 VSS.n85 2885.47
R61 VSS.n108 VSS.n45 2885.47
R62 VSS.n104 VSS.n45 2885.47
R63 VSS.n108 VSS.n44 2885.47
R64 VSS.n104 VSS.n44 2885.47
R65 VSS.n72 VSS.n58 2885.47
R66 VSS.n75 VSS.n58 2885.47
R67 VSS.n72 VSS.n57 2885.47
R68 VSS.n75 VSS.n57 2885.47
R69 VSS.n98 VSS.n52 2885.47
R70 VSS.n94 VSS.n52 2885.47
R71 VSS.n98 VSS.n51 2885.47
R72 VSS.n94 VSS.n51 2885.47
R73 VSS.n201 VSS.n7 2846.37
R74 VSS.n99 VSS.n53 2754.63
R75 VSS.n117 VSS.n116 2754.63
R76 VSS.n139 VSS.n138 2754.63
R77 VSS.n164 VSS.n160 2754.63
R78 VSS.n110 VSS.n109 2742.68
R79 VSS.n132 VSS.n131 2742.68
R80 VSS.n154 VSS.n153 2742.68
R81 VSS.n184 VSS.n183 2695.19
R82 VSS.n162 VSS.n17 2595.76
R83 VSS.n165 VSS.n17 2595.76
R84 VSS.n162 VSS.n16 2595.76
R85 VSS.n165 VSS.n16 2595.76
R86 VSS.n178 VSS.n175 1970
R87 VSS.n182 VSS.n175 1970
R88 VSS.n178 VSS.n174 1970
R89 VSS.n182 VSS.n174 1970
R90 VSS.n199 VSS.n6 1970
R91 VSS.n202 VSS.n6 1970
R92 VSS.n199 VSS.n5 1970
R93 VSS.n202 VSS.n5 1970
R94 VSS.t12 VSS.n49 1430.26
R95 VSS.n196 VSS.n12 1078.82
R96 VSS.n163 VSS.n9 1078.82
R97 VSS.n103 VSS.n102 539.409
R98 VSS.n102 VSS.n48 539.409
R99 VSS.n125 VSS.n124 539.409
R100 VSS.n124 VSS.n123 539.409
R101 VSS.n147 VSS.n146 539.409
R102 VSS.n146 VSS.n145 539.409
R103 VSS.n200 VSS.n199 311.115
R104 VSS.n62 VSS.n60 292.5
R105 VSS.t18 VSS.n61 292.5
R106 VSS.n67 VSS.n61 292.5
R107 VSS.t2 VSS.n51 292.5
R108 VSS.n54 VSS.n51 292.5
R109 VSS.t2 VSS.n52 292.5
R110 VSS.n96 VSS.n52 292.5
R111 VSS.t12 VSS.n57 292.5
R112 VSS.n57 VSS.n55 292.5
R113 VSS.t12 VSS.n58 292.5
R114 VSS.n58 VSS.n56 292.5
R115 VSS.n44 VSS.t21 292.5
R116 VSS.n46 VSS.n44 292.5
R117 VSS.n45 VSS.t21 292.5
R118 VSS.n106 VSS.n45 292.5
R119 VSS.t1 VSS.n85 292.5
R120 VSS.n85 VSS.n83 292.5
R121 VSS.n88 VSS.t1 292.5
R122 VSS.n88 VSS.n84 292.5
R123 VSS.n41 VSS.t4 292.5
R124 VSS.n43 VSS.n41 292.5
R125 VSS.n42 VSS.t4 292.5
R126 VSS.n113 VSS.n42 292.5
R127 VSS.n32 VSS.t20 292.5
R128 VSS.n34 VSS.n32 292.5
R129 VSS.n33 VSS.t20 292.5
R130 VSS.n128 VSS.n33 292.5
R131 VSS.n37 VSS.t11 292.5
R132 VSS.n39 VSS.n37 292.5
R133 VSS.n38 VSS.t11 292.5
R134 VSS.n120 VSS.n38 292.5
R135 VSS.n29 VSS.t8 292.5
R136 VSS.n31 VSS.n29 292.5
R137 VSS.n30 VSS.t8 292.5
R138 VSS.n135 VSS.n30 292.5
R139 VSS.n21 VSS.t17 292.5
R140 VSS.n23 VSS.n21 292.5
R141 VSS.n22 VSS.t17 292.5
R142 VSS.n150 VSS.n22 292.5
R143 VSS.n25 VSS.t0 292.5
R144 VSS.n27 VSS.n25 292.5
R145 VSS.n26 VSS.t0 292.5
R146 VSS.n142 VSS.n26 292.5
R147 VSS.n18 VSS.t6 292.5
R148 VSS.n20 VSS.n18 292.5
R149 VSS.n19 VSS.t6 292.5
R150 VSS.n157 VSS.n19 292.5
R151 VSS.t16 VSS.n171 292.5
R152 VSS.n171 VSS.n169 292.5
R153 VSS.n185 VSS.t16 292.5
R154 VSS.n185 VSS.n170 292.5
R155 VSS.t10 VSS.n10 292.5
R156 VSS.n13 VSS.n10 292.5
R157 VSS.t10 VSS.n11 292.5
R158 VSS.n193 VSS.n11 292.5
R159 VSS.t24 VSS.n16 292.5
R160 VSS.n16 VSS.n14 292.5
R161 VSS.t24 VSS.n17 292.5
R162 VSS.n17 VSS.n15 292.5
R163 VSS.t22 VSS.n5 292.5
R164 VSS.n5 VSS.n3 292.5
R165 VSS.t22 VSS.n6 292.5
R166 VSS.n6 VSS.n4 292.5
R167 VSS.n174 VSS.t14 292.5
R168 VSS.n177 VSS.n174 292.5
R169 VSS.n175 VSS.t14 292.5
R170 VSS.n180 VSS.n175 292.5
R171 VSS.n64 VSS.n60 246.404
R172 VSS.n65 VSS.n64 208.341
R173 VSS.n67 VSS.n66 187.482
R174 VSS.n68 VSS.n67 187.482
R175 VSS.n194 VSS.n193 187.482
R176 VSS.n193 VSS.n192 187.482
R177 VSS.n172 VSS.n170 187.482
R178 VSS.n187 VSS.n170 187.482
R179 VSS.n158 VSS.n157 187.482
R180 VSS.n157 VSS.n156 187.482
R181 VSS.n143 VSS.n142 187.482
R182 VSS.n142 VSS.n141 187.482
R183 VSS.n151 VSS.n150 187.482
R184 VSS.n150 VSS.n149 187.482
R185 VSS.n136 VSS.n135 187.482
R186 VSS.n135 VSS.n134 187.482
R187 VSS.n121 VSS.n120 187.482
R188 VSS.n120 VSS.n119 187.482
R189 VSS.n129 VSS.n128 187.482
R190 VSS.n128 VSS.n127 187.482
R191 VSS.n114 VSS.n113 187.482
R192 VSS.n113 VSS.n112 187.482
R193 VSS.n86 VSS.n84 187.482
R194 VSS.n90 VSS.n84 187.482
R195 VSS.n107 VSS.n106 187.482
R196 VSS.n106 VSS.n105 187.482
R197 VSS.n71 VSS.n56 187.482
R198 VSS.n76 VSS.n56 187.482
R199 VSS.n97 VSS.n96 187.482
R200 VSS.n96 VSS.n95 187.482
R201 VSS.n68 VSS.n62 186.353
R202 VSS.n194 VSS.n13 186.353
R203 VSS.n172 VSS.n169 186.353
R204 VSS.n158 VSS.n20 186.353
R205 VSS.n143 VSS.n27 186.353
R206 VSS.n151 VSS.n23 186.353
R207 VSS.n136 VSS.n31 186.353
R208 VSS.n121 VSS.n39 186.353
R209 VSS.n129 VSS.n34 186.353
R210 VSS.n114 VSS.n43 186.353
R211 VSS.n86 VSS.n83 186.353
R212 VSS.n107 VSS.n46 186.353
R213 VSS.n71 VSS.n55 186.353
R214 VSS.n97 VSS.n54 186.353
R215 VSS.t2 VSS.n99 174.192
R216 VSS.t2 VSS.n50 174.192
R217 VSS.t12 VSS.n73 174.192
R218 VSS.n74 VSS.t12 174.192
R219 VSS.n116 VSS.t4 174.192
R220 VSS.n110 VSS.t4 174.192
R221 VSS.n138 VSS.t8 174.192
R222 VSS.n132 VSS.t8 174.192
R223 VSS.n160 VSS.t6 174.192
R224 VSS.n154 VSS.t6 174.192
R225 VSS.n161 VSS.n15 168.66
R226 VSS.n166 VSS.n15 168.66
R227 VSS.n201 VSS.t22 167.559
R228 VSS.t14 VSS.n7 167.559
R229 VSS.n183 VSS.t14 167.559
R230 VSS.n161 VSS.n14 167.53
R231 VSS.t18 VSS.n59 159.861
R232 VSS.n202 VSS.n201 146.25
R233 VSS.n203 VSS.n202 146.25
R234 VSS.n199 VSS.n198 146.25
R235 VSS.n183 VSS.n182 146.25
R236 VSS.n182 VSS.n181 146.25
R237 VSS.n178 VSS.n7 146.25
R238 VSS.n179 VSS.n178 146.25
R239 VSS.n109 VSS.t21 143.964
R240 VSS.n103 VSS.t21 143.964
R241 VSS.t1 VSS.n48 143.964
R242 VSS.t1 VSS.n53 143.964
R243 VSS.n131 VSS.t20 143.964
R244 VSS.n125 VSS.t20 143.964
R245 VSS.n123 VSS.t11 143.964
R246 VSS.n117 VSS.t11 143.964
R247 VSS.n153 VSS.t17 143.964
R248 VSS.n147 VSS.t17 143.964
R249 VSS.n145 VSS.t0 143.964
R250 VSS.n139 VSS.t0 143.964
R251 VSS.t16 VSS.n184 143.964
R252 VSS.t16 VSS.n12 143.964
R253 VSS.t10 VSS.n196 143.964
R254 VSS.t10 VSS.n9 143.964
R255 VSS.t24 VSS.n163 143.964
R256 VSS.n164 VSS.t24 143.964
R257 VSS.n176 VSS.t15 140.359
R258 VSS.t23 VSS.n204 140.359
R259 VSS.n63 VSS.t19 140.225
R260 VSS.t25 VSS.n167 140.135
R261 VSS.n190 VSS.n168 140.03
R262 VSS.n189 VSS.n188 140.03
R263 VSS.t7 VSS.n0 140.03
R264 VSS.n79 VSS.n28 140.03
R265 VSS.n78 VSS.n24 140.03
R266 VSS.t9 VSS.n1 140.03
R267 VSS.n81 VSS.n40 140.03
R268 VSS.n80 VSS.n35 140.03
R269 VSS.t5 VSS.n2 140.03
R270 VSS.n92 VSS.n91 140.03
R271 VSS.n82 VSS.n47 140.03
R272 VSS.t13 VSS.n77 140.03
R273 VSS.n93 VSS.t3 140.03
R274 VSS.n180 VSS.n179 128
R275 VSS.n181 VSS.n180 128
R276 VSS.n198 VSS.n4 128
R277 VSS.n203 VSS.n4 128
R278 VSS.n179 VSS.n177 126.871
R279 VSS.n198 VSS.n3 126.871
R280 VSS.n66 VSS.n63 126.871
R281 VSS.n192 VSS.n190 126.871
R282 VSS.n188 VSS.n187 126.871
R283 VSS.n156 VSS.n0 126.871
R284 VSS.n141 VSS.n28 126.871
R285 VSS.n149 VSS.n24 126.871
R286 VSS.n134 VSS.n1 126.871
R287 VSS.n119 VSS.n40 126.871
R288 VSS.n127 VSS.n35 126.871
R289 VSS.n112 VSS.n2 126.871
R290 VSS.n91 VSS.n90 126.871
R291 VSS.n105 VSS.n47 126.871
R292 VSS.n77 VSS.n76 126.871
R293 VSS.n95 VSS.n93 126.871
R294 VSS.n167 VSS.n166 108.047
R295 VSS.n165 VSS.n164 83.5719
R296 VSS.n166 VSS.n165 83.5719
R297 VSS.n163 VSS.n162 83.5719
R298 VSS.n162 VSS.n161 83.5719
R299 VSS.n66 VSS.n65 73.1255
R300 VSS.n70 VSS.n69 73.1255
R301 VSS.n69 VSS.n68 73.1255
R302 VSS.n94 VSS.n50 73.1255
R303 VSS.n95 VSS.n94 73.1255
R304 VSS.n99 VSS.n98 73.1255
R305 VSS.n98 VSS.n97 73.1255
R306 VSS.n75 VSS.n74 73.1255
R307 VSS.n76 VSS.n75 73.1255
R308 VSS.n73 VSS.n72 73.1255
R309 VSS.n72 VSS.n71 73.1255
R310 VSS.n104 VSS.n103 73.1255
R311 VSS.n105 VSS.n104 73.1255
R312 VSS.n109 VSS.n108 73.1255
R313 VSS.n108 VSS.n107 73.1255
R314 VSS.n89 VSS.n53 73.1255
R315 VSS.n90 VSS.n89 73.1255
R316 VSS.n87 VSS.n48 73.1255
R317 VSS.n87 VSS.n86 73.1255
R318 VSS.n111 VSS.n110 73.1255
R319 VSS.n112 VSS.n111 73.1255
R320 VSS.n116 VSS.n115 73.1255
R321 VSS.n115 VSS.n114 73.1255
R322 VSS.n126 VSS.n125 73.1255
R323 VSS.n127 VSS.n126 73.1255
R324 VSS.n131 VSS.n130 73.1255
R325 VSS.n130 VSS.n129 73.1255
R326 VSS.n118 VSS.n117 73.1255
R327 VSS.n119 VSS.n118 73.1255
R328 VSS.n123 VSS.n122 73.1255
R329 VSS.n122 VSS.n121 73.1255
R330 VSS.n133 VSS.n132 73.1255
R331 VSS.n134 VSS.n133 73.1255
R332 VSS.n138 VSS.n137 73.1255
R333 VSS.n137 VSS.n136 73.1255
R334 VSS.n148 VSS.n147 73.1255
R335 VSS.n149 VSS.n148 73.1255
R336 VSS.n153 VSS.n152 73.1255
R337 VSS.n152 VSS.n151 73.1255
R338 VSS.n140 VSS.n139 73.1255
R339 VSS.n141 VSS.n140 73.1255
R340 VSS.n145 VSS.n144 73.1255
R341 VSS.n144 VSS.n143 73.1255
R342 VSS.n155 VSS.n154 73.1255
R343 VSS.n156 VSS.n155 73.1255
R344 VSS.n160 VSS.n159 73.1255
R345 VSS.n159 VSS.n158 73.1255
R346 VSS.n186 VSS.n12 73.1255
R347 VSS.n187 VSS.n186 73.1255
R348 VSS.n184 VSS.n173 73.1255
R349 VSS.n173 VSS.n172 73.1255
R350 VSS.n191 VSS.n9 73.1255
R351 VSS.n192 VSS.n191 73.1255
R352 VSS.n196 VSS.n195 73.1255
R353 VSS.n195 VSS.n194 73.1255
R354 VSS.n181 VSS.n176 67.3887
R355 VSS.n204 VSS.n203 67.3887
R356 VSS.n63 VSS.n62 50.5605
R357 VSS.n177 VSS.n176 50.5605
R358 VSS.n204 VSS.n3 50.5605
R359 VSS.n167 VSS.n14 50.5605
R360 VSS.n190 VSS.n13 50.5605
R361 VSS.n188 VSS.n169 50.5605
R362 VSS.n0 VSS.n20 50.5605
R363 VSS.n28 VSS.n27 50.5605
R364 VSS.n24 VSS.n23 50.5605
R365 VSS.n1 VSS.n31 50.5605
R366 VSS.n40 VSS.n39 50.5605
R367 VSS.n35 VSS.n34 50.5605
R368 VSS.n2 VSS.n43 50.5605
R369 VSS.n91 VSS.n83 50.5605
R370 VSS.n47 VSS.n46 50.5605
R371 VSS.n77 VSS.n55 50.5605
R372 VSS.n93 VSS.n54 50.5605
R373 VSS.n64 VSS.t18 21.1205
R374 VSS.n70 VSS.n59 14.3327
R375 VSS VSS.t23 2.40298
R376 VSS.n189 VSS.t15 2.3411
R377 VSS.n78 VSS.t7 2.3411
R378 VSS.n80 VSS.t9 2.3411
R379 VSS.n82 VSS.t5 2.3411
R380 VSS.t3 VSS.t13 2.3317
R381 VSS.t3 VSS.n92 2.3317
R382 VSS.t5 VSS.n81 2.3317
R383 VSS.t9 VSS.n79 2.3317
R384 VSS.t25 VSS.t7 2.3317
R385 VSS.t23 VSS.t15 2.3317
R386 VSS.t22 VSS.n200 2.26967
R387 VSS.t13 VSS.t19 2.13743
R388 VSS.n168 VSS.n189 1.1661
R389 VSS.n79 VSS.n78 1.1661
R390 VSS.n81 VSS.n80 1.1661
R391 VSS.n92 VSS.n82 1.1661
R392 VSS.n168 VSS.t25 1.1567
C0 A1B PCLK 0.35206f
C1 net2 net1 5.2266f
C2 DEC0 net3 0.12624f
C3 A0 net3 0.11611f
C4 A1T N1 0.24751f
C5 PCLK DEC1 0.12156f
C6 DEC3 DEC2 5.22874f
C7 N3 DEC2 0.13045f
C8 A1B DEC2 0.12156f
C9 DEC0 PCLK 0.12917f
C10 A0 PCLK 5.22872f
C11 A0B N2 0.2457f
C12 DEC2 DEC1 5.22874f
C13 net2 A1T 0.1227f
C14 A0B A1 5.45963f
C15 DEC3 N3 1.42552f
C16 DEC3 A1B 0.12156f
C17 DEC0 DEC2 0.12668f
C18 A0 DEC2 0.12156f
C19 N3 A1B 0.24554f
C20 A0T N0 0.24789f
C21 net4 N2 0.12287f
C22 A0T VDD 0.79024f
C23 A1 net4 0.11611f
C24 A0T net1 0.1227f
C25 DEC3 DEC1 0.12668f
C26 N3 DEC1 0.12548f
C27 A1B DEC1 0.12156f
C28 A0B N1 0.24582f
C29 DEC3 DEC0 0.12631f
C30 DEC3 A0 0.12156f
C31 net3 N2 0.33586f
C32 DEC0 N3 0.12596f
C33 A0 N3 0.24554f
C34 DEC0 A1B 0.12204f
C35 A1 net3 0.11611f
C36 A0 A1B 0.36629f
C37 net4 N1 0.1227f
C38 DEC0 DEC1 5.22874f
C39 PCLK N2 0.58112f
C40 A0 DEC1 0.12156f
C41 A0T A1T 5.35865f
C42 A1 PCLK 0.12331f
C43 A0B net2 0.11611f
C44 EVAL_GND N0 0.30786f
C45 A0 DEC0 0.12204f
C46 EVAL_GND VDD 0.29678f
C47 N1 net3 0.12287f
C48 EVAL_GND net1 0.58345f
C49 DEC2 N2 1.38505f
C50 net4 net2 0.12454f
C51 A1 DEC2 0.12156f
C52 PCLK N1 0.58112f
C53 net2 net3 5.2266f
C54 DEC3 N2 0.12156f
C55 N3 N2 5.4246f
C56 DEC3 A1 0.12156f
C57 EVAL_GND A1T 0.3081f
C58 A1B N2 0.24582f
C59 A1 N3 0.24554f
C60 A1 A1B 1.24035f
C61 DEC2 N1 0.12156f
C62 A0B A0T 1.2307f
C63 PCLK net2 0.11612f
C64 DEC1 N2 0.13045f
C65 A1 DEC1 0.12156f
C66 DEC0 N2 0.12596f
C67 A0 N2 0.24554f
C68 net4 A0T 0.7395f
C69 DEC3 N1 0.12156f
C70 A1 DEC0 0.12204f
C71 A0 A1 5.22461f
C72 N3 N1 0.24789f
C73 DEC2 net2 0.12548f
C74 A1B N1 0.85261f
C75 A0T net3 0.11676f
C76 N0 VDD 2.13462f
C77 DEC1 N1 1.34457f
C78 N0 net1 0.33586f
C79 VDD net1 0.12253f
C80 DEC3 net2 0.12548f
C81 N3 net2 0.12505f
C82 DEC0 N1 0.13093f
C83 A0B EVAL_GND 3.85222f
C84 A0 N1 0.24554f
C85 A1B net2 1.95039f
C86 PCLK A0T 0.23022f
C87 DEC1 net2 0.12561f
C88 net4 EVAL_GND 5.70321f
C89 N0 A1T 5.35295f
C90 DEC0 net2 0.12611f
C91 A0 net2 0.11611f
C92 DEC2 A0T 0.12156f
C93 VDD A1T 0.78989f
C94 A1T net1 0.12287f
C95 A1 N2 0.24554f
C96 EVAL_GND net3 0.61147f
C97 DEC3 A0T 0.12188f
C98 N3 A0T 0.28897f
C99 EVAL_GND PCLK 0.81349f
C100 A1B A0T 5.35124f
C101 N1 N2 5.41708f
C102 A1 N1 0.24554f
C103 A0T DEC1 0.12184f
C104 EVAL_GND DEC2 0.25981f
C105 DEC0 A0T 0.12204f
C106 A0 A0T 0.23017f
C107 A0B N0 0.24628f
C108 A0B VDD 1.95631f
C109 net2 N2 0.12438f
C110 A0B net1 0.70616f
C111 A1 net2 0.11611f
C112 DEC3 EVAL_GND 0.25954f
C113 net4 N0 0.1227f
C114 EVAL_GND N3 0.30826f
C115 net4 VDD 0.12257f
C116 EVAL_GND A1B 0.29623f
C117 net4 net1 0.12416f
C118 EVAL_GND DEC1 0.26062f
C119 N0 net3 0.1227f
C120 VDD net3 0.12257f
C121 net2 N1 0.34836f
C122 A0B A1T 0.26774f
C123 net3 net1 0.12454f
C124 DEC0 EVAL_GND 5.30799f
C125 A0 EVAL_GND 0.28412f
C126 PCLK N0 0.58128f
C127 PCLK VDD 5.42908f
C128 net4 A1T 2.05105f
C129 A0T N2 0.24585f
C130 PCLK net1 0.11614f
C131 A1 A0T 0.23033f
C132 DEC2 N0 0.12156f
C133 A1T net3 2.05105f
C134 DEC2 VDD 0.81799f
C135 DEC2 net1 0.12548f
C136 A0T N1 0.24692f
C137 PCLK A1T 0.23012f
C138 DEC3 N0 0.12156f
C139 N3 N0 0.24714f
C140 DEC3 VDD 0.81799f
C141 N3 VDD 2.13462f
C142 A1B N0 0.86331f
C143 DEC3 net1 0.12548f
C144 A1B VDD 1.95476f
C145 EVAL_GND N2 0.30805f
C146 N3 net1 5.22944f
C147 A1B net1 1.95105f
C148 A1 EVAL_GND 0.28412f
C149 A0B net4 0.11611f
C150 DEC2 A1T 0.12156f
C151 N0 DEC1 0.12156f
C152 A0T net2 0.74543f
C153 DEC1 VDD 0.81799f
C154 DEC1 net1 0.12548f
C155 DEC0 N0 1.30458f
C156 A0 N0 0.24554f
C157 DEC0 VDD 0.81799f
C158 A0 VDD 1.30178f
C159 A0B net3 0.70616f
C160 DEC0 net1 0.12606f
C161 A0 net1 0.11611f
C162 DEC3 A1T 0.12156f
C163 EVAL_GND N1 0.30805f
C164 N3 A1T 0.88619f
C165 A1B A1T 1.27148f
C166 net4 net3 5.2266f
C167 A0B PCLK 0.35732f
C168 DEC1 A1T 0.12156f
C169 EVAL_GND net2 0.57229f
C170 DEC0 A1T 0.12204f
C171 net4 PCLK 0.11612f
C172 A0 A1T 0.2301f
C173 A0B DEC2 0.12184f
C174 PCLK net3 0.11612f
C175 net4 DEC2 0.12563f
C176 N0 N2 0.24751f
C177 VDD N2 2.13462f
C178 A1 N0 0.26731f
C179 DEC3 A0B 0.12156f
C180 A0B N3 0.2457f
C181 A1 VDD 1.30081f
C182 net1 N2 0.12505f
C183 A0B A1B 5.48408f
C184 A1 net1 0.11611f
C185 DEC2 net3 0.12561f
C186 DEC3 net4 0.12561f
C187 A0B DEC1 0.12156f
C188 net4 N3 0.34836f
C189 net4 A1B 0.11611f
C190 EVAL_GND A0T 4.06378f
C191 N0 N1 5.40993f
C192 A0B DEC0 0.12204f
C193 A0 A0B 1.19949f
C194 PCLK DEC2 0.12156f
C195 VDD N1 2.13462f
C196 DEC3 net3 0.12548f
C197 A1T N2 0.88607f
C198 N1 net1 0.12438f
C199 net4 DEC1 0.12576f
C200 N3 net3 0.12438f
C201 A1 A1T 0.23017f
C202 A1B net3 0.11676f
C203 net4 DEC0 0.12661f
C204 A0 net4 0.11611f
C205 DEC3 PCLK 0.12156f
C206 N0 net2 0.12287f
C207 DEC1 net3 0.12563f
C208 N3 PCLK 0.58097f
C209 VDD net2 0.12257f
C210 DEC3 VSS 31.47772f
C211 DEC2 VSS 18.45455f
C212 DEC1 VSS 18.13375f
C213 DEC0 VSS 21.89995f
C214 VDD VSS 85.21084f
C215 net4 VSS 20.87525f
C216 net3 VSS 19.51783f
C217 net2 VSS 16.2877f
C218 EVAL_GND VSS 36.42005f
C219 net1 VSS 11.96649f
C220 N2 VSS 1.02113f
C221 VSS.t23 VSS 4.01511f
C222 VSS.t15 VSS 4.08453f
C223 VSS.t9 VSS 7.19665f
C224 VSS.t5 VSS 7.35285f
C225 VSS.t19 VSS 8.3732f
.ends row_decoder

* expanding   symbol:  wl_driver.sym # of pins=4
** sym_path: /work/cells/wordline_driver/wl_driver.sym
** sch_path: /work/cells/wordline_driver/wl_driver.sch
.subckt wl_driver VDD WL_IN WL VSS
*.iopin VDD
*.iopin VSS
*.iopin WL_IN
*.iopin WL
XMP1 WL_N WL_IN VDD VDD sky130_fd_pr__pfet_01v8 L=0.15 W=0.42 nf=1 ad='int((nf+1)/2) * W/nf * 0.29' as='int((nf+2)/2) * W/nf * 0.29'
+ pd='2*int((nf+1)/2) * (W/nf + 0.29)' ps='2*int((nf+2)/2) * (W/nf + 0.29)' nrd='0.29 / W' nrs='0.29 / W' sa=0 sb=0 sd=0 mult=1 m=1
XMN1 WL_N WL_IN VSS VSS sky130_fd_pr__nfet_01v8 L=0.15 W=0.42 nf=1 ad='int((nf+1)/2) * W/nf * 0.29' as='int((nf+2)/2) * W/nf * 0.29'
+ pd='2*int((nf+1)/2) * (W/nf + 0.29)' ps='2*int((nf+2)/2) * (W/nf + 0.29)' nrd='0.29 / W' nrs='0.29 / W' sa=0 sb=0 sd=0 mult=1 m=1
XMP2 WL WL_N VDD VDD sky130_fd_pr__pfet_01v8 L=0.15 W=0.84 nf=1 ad='int((nf+1)/2) * W/nf * 0.29' as='int((nf+2)/2) * W/nf * 0.29' pd='2*int((nf+1)/2) * (W/nf + 0.29)'
+ ps='2*int((nf+2)/2) * (W/nf + 0.29)' nrd='0.29 / W' nrs='0.29 / W' sa=0 sb=0 sd=0 mult=1 m=1
XMN2 WL WL_N VSS VSS sky130_fd_pr__nfet_01v8 L=0.15 W=0.84 nf=1 ad='int((nf+1)/2) * W/nf * 0.29' as='int((nf+2)/2) * W/nf * 0.29' pd='2*int((nf+1)/2) * (W/nf + 0.29)'
+ ps='2*int((nf+2)/2) * (W/nf + 0.29)' nrd='0.29 / W' nrs='0.29 / W' sa=0 sb=0 sd=0 mult=1 m=1
.ends

.GLOBAL GND

.lib "/opt/pdks/sky130A/libs.tech/combined/continuous/sky130.lib.spice" ss
.temp -40
.options method=gear minbreak=1e-15 chgtol=1e-18
.save v(dec0) v(dec1) v(dec2) v(dec3) v(net1) v(net2) v(net3) v(net4) v(net5) v(net6) v(net7) v(net8) v(x1.a0b) v(x1.a0t) v(x1.a1b) v(x1.a1t) v(x1.eval_gnd) v(x1.n0) v(x1.n1) v(x1.n2) v(x1.n3) v(x1.net1) v(x1.net2) v(x1.net3) v(x1.net4) v(x1.vss.t0) v(x1.vss.t1) v(x1.vss.t10) v(x1.vss.t11) v(x1.vss.t12) v(x1.vss.t13) v(x1.vss.t14) v(x1.vss.t15) v(x1.vss.t16) v(x1.vss.t17) v(x1.vss.t18) v(x1.vss.t19) v(x1.vss.t2) v(x1.vss.t20) v(x1.vss.t21) v(x1.vss.t22) v(x1.vss.t23) v(x1.vss.t24) v(x1.vss.t25) v(x1.vss.t3) v(x1.vss.t4) v(x1.vss.t5) v(x1.vss.t6) v(x1.vss.t7) v(x1.vss.t8) v(x1.vss.t9) v(x2.wl_n) v(x3.wl_n) v(x4.wl_n) v(x5.wl_n) i(VDD_SRC) i(VPCLK) i(VA0) i(VA1) v(x1.n0) v(x1.n1) v(x1.n2) v(x1.n3)
.tran 5p 3e-08 0 5e-13 uic
.control
set num_threads=1
run
write waveform.raw
quit 0
.endc
.end
