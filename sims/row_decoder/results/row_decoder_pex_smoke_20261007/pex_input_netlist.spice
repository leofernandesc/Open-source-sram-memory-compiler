** sch_path: /work/sims/row_decoder/tb_row_decoder_sizing.sch
**.subckt tb_row_decoder_sizing
x1 net1 net2 net3 net4 DEC0 DEC1 DEC3 DEC2 GND row_decoder
VDD_SRC net1 GND 1.8
VPCLK net2 GND PULSE(0 1.8 10n 50p 50p 10n 20n)
VA0 net3 GND PULSE(0 1.8 22n 50p 50p 20n 40n)
VA1 net4 GND PULSE(0 1.8 42n 50p 50p 40n 80n)
x2 net1 DEC0 net5 GND wl_driver
x3 net1 DEC1 net6 GND wl_driver
x4 net1 DEC3 net8 GND wl_driver
x5 net1 DEC2 net7 GND wl_driver
C_WL0 net5 GND 17.4f m=1
C_WL1 net6 GND 17.4f m=1
C_WL2 net7 GND 17.4f m=1
C_WL3 net8 GND 17.4f m=1
**.ends

* expanding   symbol:  row_decoder.sym # of pins=9
** sym_path: /work/cells/row_decoder/row_decoder.sym
** sch_path: /work/cells/row_decoder/row_decoder.sch
.subckt row_decoder VDD PCLK A0 A1 DEC0 DEC1 DEC3 DEC2 VSS
X0 VSS.t19 N2.t2 DEC2.t1 VSS.t18 sky130_fd_pr__nfet_01v8 ad=0.58 pd=4.58 as=0.58 ps=4.58 w=2 l=0.15
X1 VSS.t2 A1B.t2 A1T.t1 VSS.t1 sky130_fd_pr__nfet_01v8 ad=0.58 pd=4.58 as=0.58 ps=4.58 w=2 l=0.15
X2 VDD.t17 N2.t3 DEC2.t0 VDD.t16 sky130_fd_pr__pfet_01v8 ad=0.58 pd=4.58 as=0.58 ps=4.58 w=2 l=0.15
X3 VSS.t23 A1.t0 A1B.t0 VSS.t22 sky130_fd_pr__nfet_01v8 ad=0.1218 pd=1.42 as=0.1218 ps=1.42 w=0.42 l=0.15
X4 EVAL_GND.t0 A0T.t2 net4.t0 VSS.t5 sky130_fd_pr__nfet_01v8 ad=0.29 pd=2.58 as=0.29 ps=2.58 w=1 l=0.15
X5 VSS.t17 A0B.t2 A0T.t0 VSS.t16 sky130_fd_pr__nfet_01v8 ad=0.58 pd=4.58 as=0.58 ps=4.58 w=2 l=0.15
X6 VDD.t21 N3.t2 DEC3.t0 VDD.t20 sky130_fd_pr__pfet_01v8 ad=0.58 pd=4.58 as=0.58 ps=4.58 w=2 l=0.15
X7 VSS.t8 A0.t0 A0B.t1 VSS.t7 sky130_fd_pr__nfet_01v8 ad=0.1218 pd=1.42 as=0.1218 ps=1.42 w=0.42 l=0.15
X8 net2.t1 A1B.t3 N1.t0 VSS.t0 sky130_fd_pr__nfet_01v8 ad=0.29 pd=2.58 as=0.29 ps=2.58 w=1 l=0.15
X9 net1.t0 A1B.t4 N0.t0 VSS.t3 sky130_fd_pr__nfet_01v8 ad=0.29 pd=2.58 as=0.29 ps=2.58 w=1 l=0.15
X10 EVAL_GND.t4 A0B.t3 net3.t1 VSS.t15 sky130_fd_pr__nfet_01v8 ad=0.29 pd=2.58 as=0.29 ps=2.58 w=1 l=0.15
X11 VDD.t19 A1.t0 A1B.t1 VDD.t18 sky130_fd_pr__pfet_01v8 ad=0.1218 pd=1.42 as=0.1218 ps=1.42 w=0.42 l=0.15
X12 VDD.t9 PCLK.t0 N0.t1 VDD.t8 sky130_fd_pr__pfet_01v8 ad=0.145 pd=1.58 as=0.145 ps=1.58 w=0.5 l=0.15
X13 VDD.t5 PCLK.t1 N1.t1 VDD.t4 sky130_fd_pr__pfet_01v8 ad=0.145 pd=1.58 as=0.145 ps=1.58 w=0.5 l=0.15
X14 VDD.t7 PCLK.t2 N2.t1 VDD.t6 sky130_fd_pr__pfet_01v8 ad=0.145 pd=1.58 as=0.145 ps=1.58 w=0.5 l=0.15
X15 VDD.t1 A1B.t5 A1T.t0 VDD.t0 sky130_fd_pr__pfet_01v8 ad=0.58 pd=4.58 as=0.58 ps=4.58 w=2 l=0.15
X16 VSS.t10 PCLK.t3 EVAL_GND.t2 VSS.t9 sky130_fd_pr__nfet_01v8 ad=0.435 pd=3.58 as=0.435 ps=3.58 w=1.5 l=0.15
X17 VDD.t15 N0.t2 DEC0.t0 VDD.t14 sky130_fd_pr__pfet_01v8 ad=0.58 pd=4.58 as=0.58 ps=4.58 w=2 l=0.15
X18 VDD.t23 N1.t2 DEC1.t0 VDD.t22 sky130_fd_pr__pfet_01v8 ad=0.58 pd=4.58 as=0.58 ps=4.58 w=2 l=0.15
X19 EVAL_GND.t1 A0T.t3 net2.t0 VSS.t6 sky130_fd_pr__nfet_01v8 ad=0.29 pd=2.58 as=0.29 ps=2.58 w=1 l=0.15
X20 VSS.t25 N1.t3 DEC1.t1 VSS.t24 sky130_fd_pr__nfet_01v8 ad=0.58 pd=4.58 as=0.58 ps=4.58 w=2 l=0.15
X21 net4.t1 A1T.t2 N3.t0 VSS.t13 sky130_fd_pr__nfet_01v8 ad=0.29 pd=2.58 as=0.29 ps=2.58 w=1 l=0.15
X22 VDD.t3 A0.t0 A0B.t0 VDD.t2 sky130_fd_pr__pfet_01v8 ad=0.1218 pd=1.42 as=0.1218 ps=1.42 w=0.42 l=0.15
X23 VSS.t21 N3.t3 DEC3.t1 VSS.t20 sky130_fd_pr__nfet_01v8 ad=0.58 pd=4.58 as=0.58 ps=4.58 w=2 l=0.15
X24 EVAL_GND.t3 A0B.t4 net1.t1 VSS.t14 sky130_fd_pr__nfet_01v8 ad=0.29 pd=2.58 as=0.29 ps=2.58 w=1 l=0.15
X25 VDD.t13 PCLK.t4 N3.t1 VDD.t12 sky130_fd_pr__pfet_01v8 ad=0.145 pd=1.58 as=0.145 ps=1.58 w=0.5 l=0.15
X26 VDD.t11 A0B.t5 A0T.t1 VDD.t10 sky130_fd_pr__pfet_01v8 ad=0.58 pd=4.58 as=0.58 ps=4.58 w=2 l=0.15
X27 net3.t0 A1T.t3 N2.t0 VSS.t4 sky130_fd_pr__nfet_01v8 ad=0.29 pd=2.58 as=0.29 ps=2.58 w=1 l=0.15
X28 VSS.t12 N0.t3 DEC0.t1 VSS.t11 sky130_fd_pr__nfet_01v8 ad=0.58 pd=4.58 as=0.58 ps=4.58 w=2 l=0.15
R0 N2.n0 N2.t1 676.362
R1 N2.n2 N2.t2 300.118
R2 N2.n1 N2.t3 299.005
R3 N2.n0 N2.t0 115.802
R4 N2 N2.n2 11.1191
R5 N2.n1 N2.n0 2.6936
R6 N2.n2 N2.n1 1.1661
R7 DEC2.n0 DEC2.t0 143.013
R8 DEC2.n0 DEC2.t1 80.2631
R9 DEC2 DEC2.n0 21.6941
R10 VSS.n212 VSS.t22 1.18669e+06
R11 VSS.n215 VSS.n212 465090
R12 VSS.t11 VSS.n6 66918.2
R13 VSS.n37 VSS.t24 66918.2
R14 VSS.n113 VSS.t18 66918.2
R15 VSS.n158 VSS.n6 44580.5
R16 VSS.n136 VSS.n37 44580.5
R17 VSS.n114 VSS.n113 44580.5
R18 VSS.n113 VSS.n37 3325.61
R19 VSS.n37 VSS.n6 3325.61
R20 VSS.t14 VSS.n6 2974.63
R21 VSS.n77 VSS.n73 2959.06
R22 VSS.n76 VSS.n52 2959.06
R23 VSS.n111 VSS.n55 2913.89
R24 VSS.n212 VSS.t14 2907.42
R25 VSS.n106 VSS.n53 2885.47
R26 VSS.n110 VSS.n53 2885.47
R27 VSS.n106 VSS.n54 2885.47
R28 VSS.n110 VSS.n54 2885.47
R29 VSS.n78 VSS.n60 2885.47
R30 VSS.n75 VSS.n60 2885.47
R31 VSS.n78 VSS.n61 2885.47
R32 VSS.n75 VSS.n61 2885.47
R33 VSS.n123 VSS.n42 2885.47
R34 VSS.n127 VSS.n42 2885.47
R35 VSS.n123 VSS.n43 2885.47
R36 VSS.n127 VSS.n43 2885.47
R37 VSS.n145 VSS.n29 2885.47
R38 VSS.n149 VSS.n29 2885.47
R39 VSS.n145 VSS.n30 2885.47
R40 VSS.n149 VSS.n30 2885.47
R41 VSS.n167 VSS.n17 2885.47
R42 VSS.n171 VSS.n17 2885.47
R43 VSS.n167 VSS.n18 2885.47
R44 VSS.n171 VSS.n18 2885.47
R45 VSS.n72 VSS.n63 2885.47
R46 VSS.n68 VSS.n64 2885.47
R47 VSS.n72 VSS.n64 2885.47
R48 VSS.n62 VSS.n51 2876.78
R49 VSS.n151 VSS.n150 2868.72
R50 VSS.n129 VSS.n128 2868.72
R51 VSS.n166 VSS.n165 2851.87
R52 VSS.n144 VSS.n143 2851.87
R53 VSS.n122 VSS.n121 2851.87
R54 VSS.n216 VSS.n5 2846.37
R55 VSS.n176 VSS.n172 2730.55
R56 VSS.n198 VSS.n197 2711.38
R57 VSS.n177 VSS.n15 2595.76
R58 VSS.n174 VSS.n15 2595.76
R59 VSS.n177 VSS.n16 2595.76
R60 VSS.n174 VSS.n16 2595.76
R61 VSS.n113 VSS.n112 2327.93
R62 VSS.n116 VSS.n46 2306.06
R63 VSS.n120 VSS.n46 2306.06
R64 VSS.n116 VSS.n47 2306.06
R65 VSS.n120 VSS.n47 2306.06
R66 VSS.n99 VSS.n95 2306.06
R67 VSS.n97 VSS.n95 2306.06
R68 VSS.n99 VSS.n98 2306.06
R69 VSS.n98 VSS.n97 2306.06
R70 VSS.n138 VSS.n33 2306.06
R71 VSS.n142 VSS.n33 2306.06
R72 VSS.n138 VSS.n34 2306.06
R73 VSS.n142 VSS.n34 2306.06
R74 VSS.n130 VSS.n38 2306.06
R75 VSS.n134 VSS.n38 2306.06
R76 VSS.n130 VSS.n39 2306.06
R77 VSS.n134 VSS.n39 2306.06
R78 VSS.n160 VSS.n21 2306.06
R79 VSS.n164 VSS.n21 2306.06
R80 VSS.n160 VSS.n22 2306.06
R81 VSS.n164 VSS.n22 2306.06
R82 VSS.n152 VSS.n25 2306.06
R83 VSS.n156 VSS.n25 2306.06
R84 VSS.n152 VSS.n26 2306.06
R85 VSS.n156 VSS.n26 2306.06
R86 VSS.n200 VSS.n185 2306.06
R87 VSS.n187 VSS.n185 2306.06
R88 VSS.n200 VSS.n199 2306.06
R89 VSS.n199 VSS.n187 2306.06
R90 VSS.n206 VSS.n8 2306.06
R91 VSS.n210 VSS.n8 2306.06
R92 VSS.n206 VSS.n9 2306.06
R93 VSS.n210 VSS.n9 2306.06
R94 VSS.n217 VSS.n3 1970
R95 VSS.n214 VSS.n3 1970
R96 VSS.n217 VSS.n4 1970
R97 VSS.n214 VSS.n4 1970
R98 VSS.n196 VSS.n188 1970
R99 VSS.n192 VSS.n188 1970
R100 VSS.n196 VSS.n189 1970
R101 VSS.n192 VSS.n189 1970
R102 VSS.t16 VSS.n51 1430.26
R103 VSS.n112 VSS.t20 1430.26
R104 VSS.n112 VSS.n51 1330.24
R105 VSS.n175 VSS.n7 1113.4
R106 VSS.n211 VSS.n10 1113.4
R107 VSS.n158 VSS.n157 629.028
R108 VSS.n159 VSS.n158 629.028
R109 VSS.n136 VSS.n135 629.028
R110 VSS.n137 VSS.n136 629.028
R111 VSS.n114 VSS.n50 629.028
R112 VSS.n115 VSS.n114 629.028
R113 VSS.n215 VSS.n214 313.661
R114 VSS.n194 VSS.n189 292.5
R115 VSS.n189 VSS.t22 292.5
R116 VSS.n191 VSS.n188 292.5
R117 VSS.n188 VSS.t22 292.5
R118 VSS.n4 VSS.n2 292.5
R119 VSS.t7 VSS.n4 292.5
R120 VSS.n3 VSS.n1 292.5
R121 VSS.t7 VSS.n3 292.5
R122 VSS.n208 VSS.n9 292.5
R123 VSS.t14 VSS.n9 292.5
R124 VSS.n11 VSS.n8 292.5
R125 VSS.t14 VSS.n8 292.5
R126 VSS.n199 VSS.n184 292.5
R127 VSS.n199 VSS.t3 292.5
R128 VSS.n185 VSS.n183 292.5
R129 VSS.t3 VSS.n185 292.5
R130 VSS.n16 VSS.n14 292.5
R131 VSS.t9 VSS.n16 292.5
R132 VSS.n15 VSS.n13 292.5
R133 VSS.t9 VSS.n15 292.5
R134 VSS.n154 VSS.n26 292.5
R135 VSS.n26 VSS.t6 292.5
R136 VSS.n27 VSS.n25 292.5
R137 VSS.n25 VSS.t6 292.5
R138 VSS.n162 VSS.n22 292.5
R139 VSS.n22 VSS.t0 292.5
R140 VSS.n23 VSS.n21 292.5
R141 VSS.n21 VSS.t0 292.5
R142 VSS.n169 VSS.n18 292.5
R143 VSS.n18 VSS.t11 292.5
R144 VSS.n19 VSS.n17 292.5
R145 VSS.n17 VSS.t11 292.5
R146 VSS.n132 VSS.n39 292.5
R147 VSS.n39 VSS.t15 292.5
R148 VSS.n40 VSS.n38 292.5
R149 VSS.n38 VSS.t15 292.5
R150 VSS.n140 VSS.n34 292.5
R151 VSS.n34 VSS.t4 292.5
R152 VSS.n35 VSS.n33 292.5
R153 VSS.n33 VSS.t4 292.5
R154 VSS.n147 VSS.n30 292.5
R155 VSS.n30 VSS.t24 292.5
R156 VSS.n31 VSS.n29 292.5
R157 VSS.n29 VSS.t24 292.5
R158 VSS.n98 VSS.n94 292.5
R159 VSS.n98 VSS.t5 292.5
R160 VSS.n95 VSS.n93 292.5
R161 VSS.t5 VSS.n95 292.5
R162 VSS.n118 VSS.n47 292.5
R163 VSS.n47 VSS.t13 292.5
R164 VSS.n48 VSS.n46 292.5
R165 VSS.n46 VSS.t13 292.5
R166 VSS.n125 VSS.n43 292.5
R167 VSS.n43 VSS.t18 292.5
R168 VSS.n44 VSS.n42 292.5
R169 VSS.n42 VSS.t18 292.5
R170 VSS.n61 VSS.n59 292.5
R171 VSS.t16 VSS.n61 292.5
R172 VSS.n60 VSS.n58 292.5
R173 VSS.t16 VSS.n60 292.5
R174 VSS.n108 VSS.n54 292.5
R175 VSS.t20 VSS.n54 292.5
R176 VSS.n56 VSS.n53 292.5
R177 VSS.t20 VSS.n53 292.5
R178 VSS.n70 VSS.n64 292.5
R179 VSS.t1 VSS.n64 292.5
R180 VSS.n65 VSS.n63 292.5
R181 VSS.n221 VSS.t8 261.584
R182 VSS.n0 VSS.t23 261.584
R183 VSS.n67 VSS.n63 246.404
R184 VSS.n68 VSS.n67 208.341
R185 VSS.n108 VSS.n107 187.482
R186 VSS.n109 VSS.n108 187.482
R187 VSS.n79 VSS.n59 187.482
R188 VSS.n74 VSS.n59 187.482
R189 VSS.n125 VSS.n124 187.482
R190 VSS.n126 VSS.n125 187.482
R191 VSS.n147 VSS.n146 187.482
R192 VSS.n148 VSS.n147 187.482
R193 VSS.n169 VSS.n168 187.482
R194 VSS.n170 VSS.n169 187.482
R195 VSS.n71 VSS.n70 187.482
R196 VSS.n70 VSS.n69 187.482
R197 VSS.n109 VSS.n56 186.353
R198 VSS.n74 VSS.n58 186.353
R199 VSS.n126 VSS.n44 186.353
R200 VSS.n148 VSS.n31 186.353
R201 VSS.n170 VSS.n19 186.353
R202 VSS.n71 VSS.n65 186.353
R203 VSS.n77 VSS.t16 174.192
R204 VSS.t16 VSS.n76 174.192
R205 VSS.t20 VSS.n52 174.192
R206 VSS.t20 VSS.n111 174.192
R207 VSS.n178 VSS.n14 168.66
R208 VSS.n173 VSS.n14 168.66
R209 VSS.n151 VSS.t6 167.882
R210 VSS.n157 VSS.t6 167.882
R211 VSS.n159 VSS.t0 167.882
R212 VSS.n165 VSS.t0 167.882
R213 VSS.n166 VSS.t11 167.882
R214 VSS.n172 VSS.t11 167.882
R215 VSS.n129 VSS.t15 167.882
R216 VSS.n135 VSS.t15 167.882
R217 VSS.n137 VSS.t4 167.882
R218 VSS.n143 VSS.t4 167.882
R219 VSS.n144 VSS.t24 167.882
R220 VSS.n150 VSS.t24 167.882
R221 VSS.t5 VSS.n55 167.882
R222 VSS.t5 VSS.n50 167.882
R223 VSS.n115 VSS.t13 167.882
R224 VSS.n121 VSS.t13 167.882
R225 VSS.n122 VSS.t18 167.882
R226 VSS.n128 VSS.t18 167.882
R227 VSS.n197 VSS.t22 167.559
R228 VSS.t22 VSS.n5 167.559
R229 VSS.n216 VSS.t7 167.559
R230 VSS.n173 VSS.n13 167.53
R231 VSS.t1 VSS.n62 159.861
R232 VSS.n118 VSS.n117 149.835
R233 VSS.n119 VSS.n118 149.835
R234 VSS.n100 VSS.n94 149.835
R235 VSS.n96 VSS.n94 149.835
R236 VSS.n140 VSS.n139 149.835
R237 VSS.n141 VSS.n140 149.835
R238 VSS.n132 VSS.n131 149.835
R239 VSS.n133 VSS.n132 149.835
R240 VSS.n162 VSS.n161 149.835
R241 VSS.n163 VSS.n162 149.835
R242 VSS.n154 VSS.n153 149.835
R243 VSS.n155 VSS.n154 149.835
R244 VSS.n201 VSS.n184 149.835
R245 VSS.n186 VSS.n184 149.835
R246 VSS.n208 VSS.n207 149.835
R247 VSS.n209 VSS.n208 149.835
R248 VSS.n119 VSS.n48 148.707
R249 VSS.n96 VSS.n93 148.707
R250 VSS.n141 VSS.n35 148.707
R251 VSS.n133 VSS.n40 148.707
R252 VSS.n163 VSS.n23 148.707
R253 VSS.n155 VSS.n27 148.707
R254 VSS.n186 VSS.n183 148.707
R255 VSS.n209 VSS.n11 148.707
R256 VSS.n176 VSS.t9 148.579
R257 VSS.t9 VSS.n175 148.579
R258 VSS.t14 VSS.n7 148.579
R259 VSS.t14 VSS.n211 148.579
R260 VSS.t3 VSS.n10 148.579
R261 VSS.t3 VSS.n198 148.579
R262 VSS.n193 VSS.n192 146.25
R263 VSS.n192 VSS.n5 146.25
R264 VSS.n196 VSS.n195 146.25
R265 VSS.n197 VSS.n196 146.25
R266 VSS.n214 VSS.n213 146.25
R267 VSS.n218 VSS.n217 146.25
R268 VSS.n217 VSS.n216 146.25
R269 VSS.n220 VSS.n219 140.359
R270 VSS.n190 VSS.n182 140.359
R271 VSS.n92 VSS.n49 140.239
R272 VSS.n102 VSS.n101 140.239
R273 VSS.n88 VSS.n36 140.239
R274 VSS.n89 VSS.n41 140.239
R275 VSS.n84 VSS.n24 140.239
R276 VSS.n85 VSS.n28 140.239
R277 VSS.n203 VSS.n202 140.239
R278 VSS.n205 VSS.n204 140.239
R279 VSS.n66 VSS.n57 140.225
R280 VSS.n180 VSS.n179 140.135
R281 VSS.n105 VSS.n104 140.03
R282 VSS.n81 VSS.n80 140.03
R283 VSS.n91 VSS.n45 140.03
R284 VSS.n87 VSS.n32 140.03
R285 VSS.n83 VSS.n20 140.03
R286 VSS.n218 VSS.n2 128
R287 VSS.n213 VSS.n2 128
R288 VSS.n195 VSS.n194 128
R289 VSS.n194 VSS.n193 128
R290 VSS.n213 VSS.n1 126.871
R291 VSS.n193 VSS.n191 126.871
R292 VSS.n107 VSS.n105 126.871
R293 VSS.n80 VSS.n79 126.871
R294 VSS.n124 VSS.n45 126.871
R295 VSS.n146 VSS.n32 126.871
R296 VSS.n168 VSS.n20 126.871
R297 VSS.n69 VSS.n66 126.871
R298 VSS.n210 VSS.n209 117.001
R299 VSS.n211 VSS.n210 117.001
R300 VSS.n207 VSS.n206 117.001
R301 VSS.n206 VSS.n7 117.001
R302 VSS.n187 VSS.n186 117.001
R303 VSS.n198 VSS.n187 117.001
R304 VSS.n201 VSS.n200 117.001
R305 VSS.n200 VSS.n10 117.001
R306 VSS.n156 VSS.n155 117.001
R307 VSS.n157 VSS.n156 117.001
R308 VSS.n153 VSS.n152 117.001
R309 VSS.n152 VSS.n151 117.001
R310 VSS.n164 VSS.n163 117.001
R311 VSS.n165 VSS.n164 117.001
R312 VSS.n161 VSS.n160 117.001
R313 VSS.n160 VSS.n159 117.001
R314 VSS.n134 VSS.n133 117.001
R315 VSS.n135 VSS.n134 117.001
R316 VSS.n131 VSS.n130 117.001
R317 VSS.n130 VSS.n129 117.001
R318 VSS.n142 VSS.n141 117.001
R319 VSS.n143 VSS.n142 117.001
R320 VSS.n139 VSS.n138 117.001
R321 VSS.n138 VSS.n137 117.001
R322 VSS.n97 VSS.n96 117.001
R323 VSS.n97 VSS.n50 117.001
R324 VSS.n100 VSS.n99 117.001
R325 VSS.n99 VSS.n55 117.001
R326 VSS.n120 VSS.n119 117.001
R327 VSS.n121 VSS.n120 117.001
R328 VSS.n117 VSS.n116 117.001
R329 VSS.n116 VSS.n115 117.001
R330 VSS.n179 VSS.n178 108.047
R331 VSS.n117 VSS.n49 89.224
R332 VSS.n101 VSS.n100 89.224
R333 VSS.n139 VSS.n36 89.224
R334 VSS.n131 VSS.n41 89.224
R335 VSS.n161 VSS.n24 89.224
R336 VSS.n153 VSS.n28 89.224
R337 VSS.n202 VSS.n201 89.224
R338 VSS.n207 VSS.n205 89.224
R339 VSS.n181 VSS.t10 86.0066
R340 VSS.n174 VSS.n173 83.5719
R341 VSS.n175 VSS.n174 83.5719
R342 VSS.n178 VSS.n177 83.5719
R343 VSS.n177 VSS.n176 83.5719
R344 VSS.n171 VSS.n170 73.1255
R345 VSS.n172 VSS.n171 73.1255
R346 VSS.n168 VSS.n167 73.1255
R347 VSS.n167 VSS.n166 73.1255
R348 VSS.n149 VSS.n148 73.1255
R349 VSS.n150 VSS.n149 73.1255
R350 VSS.n146 VSS.n145 73.1255
R351 VSS.n145 VSS.n144 73.1255
R352 VSS.n127 VSS.n126 73.1255
R353 VSS.n128 VSS.n127 73.1255
R354 VSS.n124 VSS.n123 73.1255
R355 VSS.n123 VSS.n122 73.1255
R356 VSS.n75 VSS.n74 73.1255
R357 VSS.n76 VSS.n75 73.1255
R358 VSS.n79 VSS.n78 73.1255
R359 VSS.n78 VSS.n77 73.1255
R360 VSS.n110 VSS.n109 73.1255
R361 VSS.n111 VSS.n110 73.1255
R362 VSS.n107 VSS.n106 73.1255
R363 VSS.n106 VSS.n52 73.1255
R364 VSS.n72 VSS.n71 73.1255
R365 VSS.n73 VSS.n72 73.1255
R366 VSS.n69 VSS.n68 73.1255
R367 VSS.n219 VSS.n218 67.3887
R368 VSS.n195 VSS.n190 67.3887
R369 VSS.n12 VSS.t12 67.2225
R370 VSS.n86 VSS.t25 67.2225
R371 VSS.n90 VSS.t19 67.2225
R372 VSS.n103 VSS.t21 67.2225
R373 VSS.n82 VSS.t17 67.2225
R374 VSS.n57 VSS.t2 67.2225
R375 VSS.n105 VSS.n56 50.5605
R376 VSS.n80 VSS.n58 50.5605
R377 VSS.n45 VSS.n44 50.5605
R378 VSS.n49 VSS.n48 50.5605
R379 VSS.n101 VSS.n93 50.5605
R380 VSS.n32 VSS.n31 50.5605
R381 VSS.n36 VSS.n35 50.5605
R382 VSS.n41 VSS.n40 50.5605
R383 VSS.n20 VSS.n19 50.5605
R384 VSS.n24 VSS.n23 50.5605
R385 VSS.n28 VSS.n27 50.5605
R386 VSS.n179 VSS.n13 50.5605
R387 VSS.n202 VSS.n183 50.5605
R388 VSS.n205 VSS.n11 50.5605
R389 VSS.n219 VSS.n1 50.5605
R390 VSS.n191 VSS.n190 50.5605
R391 VSS.n66 VSS.n65 50.5605
R392 VSS.n67 VSS.t1 21.1205
R393 VSS.n73 VSS.n62 14.3327
R394 VSS.n92 VSS.n91 2.3411
R395 VSS.n88 VSS.n87 2.3411
R396 VSS.n84 VSS.n83 2.3411
R397 VSS.n203 VSS.n182 2.3411
R398 VSS VSS.n221 2.18913
R399 VSS.n81 VSS.n57 2.13743
R400 VSS.n104 VSS.n82 2.13743
R401 VSS.n103 VSS.n102 2.13743
R402 VSS.n90 VSS.n89 2.13743
R403 VSS.n86 VSS.n85 2.13743
R404 VSS.n180 VSS.n12 2.13743
R405 VSS.n220 VSS.n0 2.13743
R406 VSS.n102 VSS.n92 1.1661
R407 VSS.n89 VSS.n88 1.1661
R408 VSS.n85 VSS.n84 1.1661
R409 VSS.n204 VSS.n203 1.1661
R410 VSS.n204 VSS.n181 0.962433
R411 VSS.n82 VSS.n81 0.194767
R412 VSS.n104 VSS.n103 0.194767
R413 VSS.n91 VSS.n90 0.194767
R414 VSS.n87 VSS.n86 0.194767
R415 VSS.n83 VSS.n12 0.194767
R416 VSS.n181 VSS.n180 0.194767
R417 VSS.n182 VSS.n0 0.194767
R418 VSS.n221 VSS.n220 0.194767
R419 VSS.t7 VSS.n215 0.126282
R420 A1B.n0 A1B.t1 684.125
R421 A1B.n4 A1B.t2 296.993
R422 A1B.n3 A1B.t5 295.88
R423 A1B.n0 A1B.t0 264.709
R424 A1B.n1 A1B.t4 216.764
R425 A1B.n2 A1B.t3 216.764
R426 A1B.n3 A1B.n2 18.7911
R427 A1B.n2 A1B.n1 7.0411
R428 A1B.n1 A1B.n0 2.6936
R429 A1B.n4 A1B.n3 1.1661
R430 A1B A1B.n4 0.544133
R431 A1T.n0 A1T.t3 223.88
R432 A1T.n0 A1T.t2 218.014
R433 A1T.n1 A1T.t0 135.513
R434 A1T.n2 A1T.t1 71.5975
R435 A1T.n1 A1T.n0 6.6886
R436 A1T.n2 A1T.n1 1.1661
R437 A1T A1T.n2 0.896633
R438 VDD.n111 VDD.n110 1789.41
R439 VDD.n108 VDD.n106 1789.41
R440 VDD.n85 VDD.n84 1789.41
R441 VDD.n82 VDD.n80 1789.41
R442 VDD.n59 VDD.n58 1789.41
R443 VDD.n56 VDD.n54 1789.41
R444 VDD.n33 VDD.n32 1789.41
R445 VDD.n30 VDD.n28 1789.41
R446 VDD.n20 VDD.n19 1789.41
R447 VDD.n17 VDD.n15 1789.41
R448 VDD.n8 VDD.n7 1789.41
R449 VDD.n5 VDD.n3 1789.41
R450 VDD.n124 VDD.n123 1260
R451 VDD.n121 VDD.n119 1260
R452 VDD.n98 VDD.n97 1260
R453 VDD.n95 VDD.n93 1260
R454 VDD.n72 VDD.n71 1260
R455 VDD.n69 VDD.n67 1260
R456 VDD.n46 VDD.n45 1260
R457 VDD.n43 VDD.n41 1260
R458 VDD.n150 VDD.n149 1231.76
R459 VDD.n147 VDD.n145 1231.76
R460 VDD.n137 VDD.n136 1231.76
R461 VDD.n134 VDD.n132 1231.76
R462 VDD.n154 VDD.t3 679.21
R463 VDD.n141 VDD.t19 679.21
R464 VDD.n128 VDD.t9 668.322
R465 VDD.n102 VDD.t5 668.322
R466 VDD.n76 VDD.t7 668.322
R467 VDD.n50 VDD.t13 668.322
R468 VDD.n145 VDD.n144 247.977
R469 VDD.n149 VDD.n148 247.977
R470 VDD.n132 VDD.n131 247.977
R471 VDD.n136 VDD.n135 247.977
R472 VDD.n119 VDD.n118 244.263
R473 VDD.n123 VDD.n122 244.263
R474 VDD.n93 VDD.n92 244.263
R475 VDD.n97 VDD.n96 244.263
R476 VDD.n67 VDD.n66 244.263
R477 VDD.n71 VDD.n70 244.263
R478 VDD.n41 VDD.n40 244.263
R479 VDD.n45 VDD.n44 244.263
R480 VDD.n107 VDD.n104 190.871
R481 VDD.n107 VDD.n103 190.871
R482 VDD.n81 VDD.n78 190.871
R483 VDD.n81 VDD.n77 190.871
R484 VDD.n55 VDD.n52 190.871
R485 VDD.n55 VDD.n51 190.871
R486 VDD.n29 VDD.n26 190.871
R487 VDD.n29 VDD.n25 190.871
R488 VDD.n16 VDD.n13 190.871
R489 VDD.n16 VDD.n12 190.871
R490 VDD.n4 VDD.n1 190.871
R491 VDD.n4 VDD.n0 190.871
R492 VDD.n112 VDD.n104 189.742
R493 VDD.n86 VDD.n78 189.742
R494 VDD.n60 VDD.n52 189.742
R495 VDD.n34 VDD.n26 189.742
R496 VDD.n21 VDD.n13 189.742
R497 VDD.n9 VDD.n1 189.742
R498 VDD.n106 VDD.n105 173.642
R499 VDD.n110 VDD.n109 173.642
R500 VDD.n80 VDD.n79 173.642
R501 VDD.n84 VDD.n83 173.642
R502 VDD.n54 VDD.n53 173.642
R503 VDD.n58 VDD.n57 173.642
R504 VDD.n28 VDD.n27 173.642
R505 VDD.n32 VDD.n31 173.642
R506 VDD.n15 VDD.n14 173.642
R507 VDD.n19 VDD.n18 173.642
R508 VDD.n3 VDD.n2 173.642
R509 VDD.n7 VDD.n6 173.642
R510 VDD.n120 VDD.n117 134.4
R511 VDD.n120 VDD.n116 134.4
R512 VDD.n94 VDD.n91 134.4
R513 VDD.n94 VDD.n90 134.4
R514 VDD.n68 VDD.n65 134.4
R515 VDD.n68 VDD.n64 134.4
R516 VDD.n42 VDD.n39 134.4
R517 VDD.n42 VDD.n38 134.4
R518 VDD.n125 VDD.n117 133.272
R519 VDD.n99 VDD.n91 133.272
R520 VDD.n73 VDD.n65 133.272
R521 VDD.n47 VDD.n39 133.272
R522 VDD.n146 VDD.n143 131.388
R523 VDD.n146 VDD.n142 131.388
R524 VDD.n133 VDD.n130 131.388
R525 VDD.n133 VDD.n129 131.388
R526 VDD.n153 VDD.n152 131.382
R527 VDD.n140 VDD.n139 131.382
R528 VDD.n127 VDD.n126 131.367
R529 VDD.n101 VDD.n100 131.367
R530 VDD.n75 VDD.n74 131.367
R531 VDD.n49 VDD.n48 131.367
R532 VDD.n11 VDD.n10 131.248
R533 VDD.n114 VDD.n113 131.054
R534 VDD.n88 VDD.n87 131.054
R535 VDD.n62 VDD.n61 131.054
R536 VDD.n36 VDD.n35 131.054
R537 VDD.n23 VDD.n22 131.054
R538 VDD.n115 VDD.t15 130.513
R539 VDD.n89 VDD.t23 130.513
R540 VDD.n63 VDD.t17 130.513
R541 VDD.n37 VDD.t21 130.513
R542 VDD.n24 VDD.t11 130.513
R543 VDD.n11 VDD.t1 130.513
R544 VDD.n151 VDD.n143 130.26
R545 VDD.n138 VDD.n130 130.26
R546 VDD.n113 VDD.n103 130.26
R547 VDD.n87 VDD.n77 130.26
R548 VDD.n61 VDD.n51 130.26
R549 VDD.n35 VDD.n25 130.26
R550 VDD.n22 VDD.n12 130.26
R551 VDD.n10 VDD.n0 130.26
R552 VDD.n147 VDD.n146 92.5005
R553 VDD.n151 VDD.n150 92.5005
R554 VDD.n134 VDD.n133 92.5005
R555 VDD.n138 VDD.n137 92.5005
R556 VDD.n121 VDD.n120 92.5005
R557 VDD.n125 VDD.n124 92.5005
R558 VDD.n108 VDD.n107 92.5005
R559 VDD.n112 VDD.n111 92.5005
R560 VDD.n95 VDD.n94 92.5005
R561 VDD.n99 VDD.n98 92.5005
R562 VDD.n82 VDD.n81 92.5005
R563 VDD.n86 VDD.n85 92.5005
R564 VDD.n69 VDD.n68 92.5005
R565 VDD.n73 VDD.n72 92.5005
R566 VDD.n56 VDD.n55 92.5005
R567 VDD.n60 VDD.n59 92.5005
R568 VDD.n43 VDD.n42 92.5005
R569 VDD.n47 VDD.n46 92.5005
R570 VDD.n30 VDD.n29 92.5005
R571 VDD.n34 VDD.n33 92.5005
R572 VDD.n17 VDD.n16 92.5005
R573 VDD.n21 VDD.n20 92.5005
R574 VDD.n5 VDD.n4 92.5005
R575 VDD.n9 VDD.n8 92.5005
R576 VDD.n111 VDD.n105 79.4196
R577 VDD.n109 VDD.n108 79.4196
R578 VDD.n85 VDD.n79 79.4196
R579 VDD.n83 VDD.n82 79.4196
R580 VDD.n59 VDD.n53 79.4196
R581 VDD.n57 VDD.n56 79.4196
R582 VDD.n33 VDD.n27 79.4196
R583 VDD.n31 VDD.n30 79.4196
R584 VDD.n20 VDD.n14 79.4196
R585 VDD.n18 VDD.n17 79.4196
R586 VDD.n8 VDD.n2 79.4196
R587 VDD.n6 VDD.n5 79.4196
R588 VDD.n126 VDD.n116 73.7887
R589 VDD.n100 VDD.n90 73.7887
R590 VDD.n74 VDD.n64 73.7887
R591 VDD.n48 VDD.n38 73.7887
R592 VDD.n152 VDD.n142 70.777
R593 VDD.n139 VDD.n129 70.777
R594 VDD.n124 VDD.n118 69.4692
R595 VDD.n122 VDD.n121 69.4692
R596 VDD.n98 VDD.n92 69.4692
R597 VDD.n96 VDD.n95 69.4692
R598 VDD.n72 VDD.n66 69.4692
R599 VDD.n70 VDD.n69 69.4692
R600 VDD.n46 VDD.n40 69.4692
R601 VDD.n44 VDD.n43 69.4692
R602 VDD.n150 VDD.n144 68.7187
R603 VDD.n148 VDD.n147 68.7187
R604 VDD.n137 VDD.n131 68.7187
R605 VDD.n135 VDD.n134 68.7187
R606 VDD.n152 VDD.n151 50.5605
R607 VDD.n139 VDD.n138 50.5605
R608 VDD.n126 VDD.n125 50.5605
R609 VDD.n113 VDD.n112 50.5605
R610 VDD.n100 VDD.n99 50.5605
R611 VDD.n87 VDD.n86 50.5605
R612 VDD.n74 VDD.n73 50.5605
R613 VDD.n61 VDD.n60 50.5605
R614 VDD.n48 VDD.n47 50.5605
R615 VDD.n35 VDD.n34 50.5605
R616 VDD.n22 VDD.n21 50.5605
R617 VDD.n10 VDD.n9 50.5605
R618 VDD.n149 VDD.n143 46.2505
R619 VDD.n145 VDD.n142 46.2505
R620 VDD.n136 VDD.n130 46.2505
R621 VDD.n132 VDD.n129 46.2505
R622 VDD.n123 VDD.n117 46.2505
R623 VDD.n119 VDD.n116 46.2505
R624 VDD.n97 VDD.n91 46.2505
R625 VDD.n93 VDD.n90 46.2505
R626 VDD.n71 VDD.n65 46.2505
R627 VDD.n67 VDD.n64 46.2505
R628 VDD.n45 VDD.n39 46.2505
R629 VDD.n41 VDD.n38 46.2505
R630 VDD.n110 VDD.n104 23.1255
R631 VDD.n106 VDD.n103 23.1255
R632 VDD.n84 VDD.n78 23.1255
R633 VDD.n80 VDD.n77 23.1255
R634 VDD.n58 VDD.n52 23.1255
R635 VDD.n54 VDD.n51 23.1255
R636 VDD.n32 VDD.n26 23.1255
R637 VDD.n28 VDD.n25 23.1255
R638 VDD.n19 VDD.n13 23.1255
R639 VDD.n15 VDD.n12 23.1255
R640 VDD.n7 VDD.n1 23.1255
R641 VDD.n3 VDD.n0 23.1255
R642 VDD.n148 VDD.t2 18.6229
R643 VDD.t2 VDD.n144 18.6229
R644 VDD.n135 VDD.t18 18.6229
R645 VDD.t18 VDD.n131 18.6229
R646 VDD.n122 VDD.t8 17.933
R647 VDD.t8 VDD.n118 17.933
R648 VDD.n96 VDD.t4 17.933
R649 VDD.t4 VDD.n92 17.933
R650 VDD.n70 VDD.t6 17.933
R651 VDD.t6 VDD.n66 17.933
R652 VDD.n44 VDD.t12 17.933
R653 VDD.t12 VDD.n40 17.933
R654 VDD.n109 VDD.t14 8.97701
R655 VDD.t14 VDD.n105 8.97701
R656 VDD.n83 VDD.t22 8.97701
R657 VDD.t22 VDD.n79 8.97701
R658 VDD.n57 VDD.t16 8.97701
R659 VDD.t16 VDD.n53 8.97701
R660 VDD.n31 VDD.t20 8.97701
R661 VDD.t20 VDD.n27 8.97701
R662 VDD.n18 VDD.t10 8.97701
R663 VDD.t10 VDD.n14 8.97701
R664 VDD.n6 VDD.t0 8.97701
R665 VDD.t0 VDD.n2 8.97701
R666 VDD.n127 VDD.n115 4.48743
R667 VDD.n49 VDD.n37 3.31243
R668 VDD.n75 VDD.n63 3.31243
R669 VDD.n101 VDD.n89 3.31243
R670 VDD.n23 VDD.n11 2.13743
R671 VDD.n36 VDD.n24 2.13743
R672 VDD.n62 VDD.n50 2.13743
R673 VDD.n88 VDD.n76 2.13743
R674 VDD.n114 VDD.n102 2.13743
R675 VDD.n140 VDD.n128 2.13743
R676 VDD.n153 VDD.n141 2.13743
R677 VDD VDD.n154 1.01413
R678 VDD.n24 VDD.n23 0.194767
R679 VDD.n37 VDD.n36 0.194767
R680 VDD.n50 VDD.n49 0.194767
R681 VDD.n63 VDD.n62 0.194767
R682 VDD.n76 VDD.n75 0.194767
R683 VDD.n89 VDD.n88 0.194767
R684 VDD.n102 VDD.n101 0.194767
R685 VDD.n115 VDD.n114 0.194767
R686 VDD.n128 VDD.n127 0.194767
R687 VDD.n141 VDD.n140 0.194767
R688 VDD.n154 VDD.n153 0.194767
R689 A1 A1.t0 3.24663
R690 A0T.n0 A0T.t3 229.13
R691 A0T.n0 A0T.t2 217.389
R692 A0T.n1 A0T.t1 134.888
R693 A0T.n2 A0T.t0 70.9725
R694 A0T A0T.n2 3.24663
R695 A0T.n1 A0T.n0 3.1636
R696 A0T.n2 A0T.n1 1.1661
R697 net4.n0 net4.t1 119.624
R698 net4.n0 net4.t0 118.927
R699 net4 net4.n0 7.94663
R700 EVAL_GND.n0 EVAL_GND.t3 120.249
R701 EVAL_GND.n2 EVAL_GND.t4 119.553
R702 EVAL_GND.n1 EVAL_GND.t1 119.553
R703 EVAL_GND.n3 EVAL_GND.t0 119.552
R704 EVAL_GND.n0 EVAL_GND.t2 96.0066
R705 EVAL_GND EVAL_GND.n3 7.47663
R706 EVAL_GND.n1 EVAL_GND.n0 6.3361
R707 EVAL_GND.n2 EVAL_GND.n1 5.8661
R708 EVAL_GND.n3 EVAL_GND.n2 5.8661
R709 A0B.n0 A0B.t0 683.5
R710 A0B.n4 A0B.t2 296.368
R711 A0B.n3 A0B.t5 295.255
R712 A0B.n0 A0B.t1 264.084
R713 A0B.n1 A0B.t4 216.139
R714 A0B.n2 A0B.t3 216.139
R715 A0B.n2 A0B.n1 12.9161
R716 A0B.n3 A0B.n2 9.3911
R717 A0B.n1 A0B.n0 6.2186
R718 A0B A0B.n4 2.89413
R719 A0B.n4 A0B.n3 1.1661
R720 N3.n0 N3.t1 676.987
R721 N3.n2 N3.t3 300.743
R722 N3.n1 N3.t2 299.63
R723 N3.n0 N3.t0 116.427
R724 N3 N3.n2 5.24413
R725 N3.n1 N3.n0 2.6936
R726 N3.n2 N3.n1 1.1661
R727 DEC3.n0 DEC3.t0 143.638
R728 DEC3.n0 DEC3.t1 80.8881
R729 DEC3 DEC3.n0 27.5691
R730 A0 A0.t0 0.896633
R731 N1.n0 N1.t1 675.737
R732 N1.n2 N1.t3 299.493
R733 N1.n1 N1.t2 298.38
R734 N1.n0 N1.t0 115.177
R735 N1 N1.n2 16.9941
R736 N1.n1 N1.n0 2.6936
R737 N1.n2 N1.n1 1.1661
R738 net2.n0 net2.t1 118.374
R739 net2.n0 net2.t0 117.677
R740 net2 net2.n0 19.6966
R741 N0.n0 N0.t1 675.112
R742 N0.n2 N0.t3 298.868
R743 N0.n1 N0.t2 297.755
R744 N0.n0 N0.t0 114.552
R745 N0 N0.n2 22.8691
R746 N0.n1 N0.n0 3.8686
R747 N0.n2 N0.n1 1.1661
R748 net1.n0 net1.t0 117.749
R749 net1.n0 net1.t1 117.053
R750 net1 net1.n0 26.7466
R751 net3.n0 net3.t0 118.999
R752 net3.n0 net3.t1 118.303
R753 net3 net3.n0 13.8216
R754 PCLK.n2 PCLK.t3 254.379
R755 PCLK.n0 PCLK.t4 178.903
R756 PCLK.n3 PCLK.t0 173.036
R757 PCLK.n1 PCLK.t1 173.036
R758 PCLK.n0 PCLK.t2 173.036
R759 PCLK.n1 PCLK.n0 5.8661
R760 PCLK PCLK.n3 5.59663
R761 PCLK.n2 PCLK.n1 3.5161
R762 PCLK.n3 PCLK.n2 3.5161
R763 DEC0.n0 DEC0.t0 141.763
R764 DEC0.n0 DEC0.t1 79.0131
R765 DEC0 DEC0.n0 9.94413
R766 DEC1.n0 DEC1.t0 142.388
R767 DEC1.n0 DEC1.t1 79.6381
R768 DEC1 DEC1.n0 15.8191
C0 net2 net1 10.3263f
C1 A1T A1 0.23017f
C2 net1 DEC3 0.12548f
C3 A0B VDD 2.84333f
C4 A0B PCLK 0.36037f
C5 A1 A0 10.3243f
C6 VDD DEC2 0.98094f
C7 A1B net2 3.62199f
C8 DEC2 PCLK 0.12156f
C9 DEC1 DEC0 10.3284f
C10 A1B DEC3 0.12156f
C11 N0 net4 0.1227f
C12 A1T DEC0 0.12204f
C13 net4 A1 0.11611f
C14 DEC0 A0 0.12204f
C15 A0B DEC1 0.12156f
C16 net2 VDD 0.12248f
C17 VDD DEC3 0.98094f
C18 net2 PCLK 0.11612f
C19 DEC2 DEC1 10.3284f
C20 DEC3 PCLK 0.12156f
C21 A1T A0B 0.3007f
C22 N2 N3 10.5963f
C23 A0B A0 2.00705f
C24 A1T DEC2 0.12156f
C25 net4 DEC0 0.12661f
C26 N3 EVAL_GND 0.30826f
C27 DEC2 A0 0.12156f
C28 net2 DEC1 0.12561f
C29 DEC3 DEC1 0.12668f
C30 N3 net3 0.12438f
C31 A0B net4 0.11611f
C32 net2 A1T 0.1227f
C33 A1T DEC3 0.12156f
C34 net4 DEC2 0.12563f
C35 net2 A0 0.11611f
C36 DEC3 A0 0.12156f
C37 net1 N3 10.3295f
C38 N2 EVAL_GND 0.30805f
C39 A0T N1 0.24692f
C40 A1B N3 0.24554f
C41 net2 net4 0.12454f
C42 net4 DEC3 0.12561f
C43 N2 net3 0.36184f
C44 EVAL_GND net3 0.72495f
C45 N3 VDD 2.74166f
C46 net1 N2 0.12505f
C47 N3 PCLK 0.82582f
C48 A0T N0 0.24789f
C49 net1 EVAL_GND 0.67194f
C50 A1B N2 0.24582f
C51 A0T A1 0.23033f
C52 A1B EVAL_GND 0.29609f
C53 net1 net3 0.12454f
C54 N0 N1 10.5673f
C55 N3 DEC1 0.12548f
C56 N2 VDD 2.74166f
C57 A1B net3 0.11676f
C58 N2 PCLK 0.82597f
C59 N1 A1 0.24554f
C60 VDD EVAL_GND 0.29447f
C61 A1T N3 1.4471f
C62 A0T DEC0 0.12204f
C63 EVAL_GND PCLK 1.28928f
C64 N3 A0 0.24554f
C65 A1B net1 3.62264f
C66 VDD net3 0.12248f
C67 PCLK net3 0.11612f
C68 A0T A0B 2.09478f
C69 N2 DEC1 0.13546f
C70 N1 DEC0 0.13594f
C71 A0T DEC2 0.12156f
C72 N3 net4 0.38684f
C73 EVAL_GND DEC1 0.39388f
C74 net1 VDD 0.12247f
C75 N0 A1 0.28863f
C76 net1 PCLK 0.11612f
C77 A1T N2 1.44698f
C78 A1T EVAL_GND 0.30795f
C79 A1B VDD 2.84199f
C80 N2 A0 0.24554f
C81 A0B N1 0.24582f
C82 DEC1 net3 0.12563f
C83 A1B PCLK 0.35206f
C84 EVAL_GND A0 0.28412f
C85 N1 DEC2 0.12156f
C86 A0T net2 1.28967f
C87 A0T DEC3 0.12179f
C88 N0 DEC0 2.30882f
C89 A1T net3 3.82264f
C90 net1 DEC1 0.12548f
C91 net3 A0 0.11611f
C92 N2 net4 0.12287f
C93 VDD PCLK 8.0444f
C94 net4 EVAL_GND 10.9044f
C95 DEC0 A1 0.12204f
C96 A1T net1 0.12287f
C97 A1B DEC1 0.12156f
C98 net2 N1 0.38684f
C99 N1 DEC3 0.12156f
C100 A0B N0 0.24628f
C101 net1 A0 0.11611f
C102 N0 DEC2 0.12156f
C103 A1B A1T 2.17604f
C104 net4 net3 10.3263f
C105 A0B A1 10.56f
C106 A1B A0 0.3806f
C107 VDD DEC1 0.98094f
C108 DEC1 PCLK 0.12156f
C109 DEC2 A1 0.12156f
C110 net1 net4 0.12416f
C111 A1T VDD 1.09964f
C112 net2 N0 0.12287f
C113 N0 DEC3 0.12156f
C114 A1T PCLK 0.23012f
C115 VDD A0 2.05734f
C116 A1B net4 0.11611f
C117 A0B DEC0 0.12204f
C118 PCLK A0 10.3289f
C119 net2 A1 0.11611f
C120 DEC3 A1 0.12156f
C121 DEC2 DEC0 0.12668f
C122 VDD net4 0.12248f
C123 A1T DEC1 0.12156f
C124 net4 PCLK 0.11612f
C125 A0T N3 0.33185f
C126 DEC1 A0 0.12156f
C127 A0B DEC2 0.12176f
C128 net2 DEC0 0.12611f
C129 DEC3 DEC0 0.12631f
C130 A1T A0 0.2301f
C131 N3 N1 0.24789f
C132 net4 DEC1 0.12576f
C133 net2 A0B 0.11611f
C134 A0B DEC3 0.12156f
C135 net2 DEC2 0.12548f
C136 DEC3 DEC2 10.3284f
C137 A1T net4 3.82264f
C138 A0T N2 0.24585f
C139 A0T EVAL_GND 7.5073f
C140 net4 A0 0.11611f
C141 N3 N0 0.24714f
C142 net2 DEC3 0.12548f
C143 A0T net3 0.11676f
C144 N2 N1 10.5816f
C145 N1 EVAL_GND 0.30805f
C146 N3 A1 0.24554f
C147 A0T net1 0.1227f
C148 N1 net3 0.12287f
C149 A1B A0T 10.4563f
C150 N2 N0 0.24751f
C151 N3 DEC0 0.12596f
C152 net1 N1 0.12438f
C153 N0 EVAL_GND 0.30786f
C154 N2 A1 0.24554f
C155 A0T VDD 1.09958f
C156 A1B N1 1.38018f
C157 EVAL_GND A1 0.28412f
C158 A0T PCLK 0.23022f
C159 N0 net3 0.1227f
C160 A0B N3 0.2457f
C161 N3 DEC2 0.13546f
C162 A1 net3 0.11611f
C163 net1 N0 0.36184f
C164 N1 VDD 2.74166f
C165 N2 DEC0 0.12596f
C166 N1 PCLK 0.82597f
C167 EVAL_GND DEC0 10.4832f
C168 A0T DEC1 0.12176f
C169 A1B N0 1.40089f
C170 net1 A1 0.11611f
C171 net2 N3 0.12505f
C172 N3 DEC3 2.5512f
C173 A0T A1T 10.4734f
C174 A0B N2 0.2457f
C175 DEC0 net3 0.12624f
C176 A1B A1 2.08839f
C177 A0T A0 0.23017f
C178 A0B EVAL_GND 7.09814f
C179 N2 DEC2 2.47025f
C180 N1 DEC1 2.38929f
C181 N0 VDD 2.74166f
C182 EVAL_GND DEC2 0.39307f
C183 N0 PCLK 0.82613f
C184 net1 DEC0 0.12606f
C185 A1T N1 0.24751f
C186 A0B net3 1.21707f
C187 VDD A1 2.05612f
C188 N1 A0 0.24554f
C189 DEC2 net3 0.12561f
C190 PCLK A1 0.12331f
C191 A0T net4 1.28374f
C192 A1B DEC0 0.12204f
C193 net2 N2 0.12438f
C194 N2 DEC3 0.12156f
C195 net1 A0B 1.21707f
C196 net2 EVAL_GND 0.64828f
C197 EVAL_GND DEC3 0.3928f
C198 N0 DEC1 0.12156f
C199 net1 DEC2 0.12548f
C200 A1B A0B 10.5994f
C201 VDD DEC0 0.98094f
C202 N1 net4 0.1227f
C203 net2 net3 10.3263f
C204 A1T N0 10.4533f
C205 DEC3 net3 0.12548f
C206 DEC1 A1 0.12156f
C207 DEC0 PCLK 0.13626f
C208 A1B DEC2 0.12156f
C209 N0 A0 0.24554f
C210 DEC3 VSS 23.05686f
C211 DEC2 VSS 19.30054f
C212 DEC1 VSS 20.47666f
C213 DEC0 VSS 26.15872f
C214 PCLK VSS 23.71248f
C215 A1 VSS 6.33436f
C216 A0 VSS 8.83711f
C217 VDD VSS 54.7062f
C218 net4 VSS 34.3225f
C219 net3 VSS 22.118f
C220 net2 VSS 20.02631f
C221 EVAL_GND VSS 25.16755f
C222 net1 VSS 18.99051f
C223 A1T VSS 13.63208f
C224 A0T VSS 14.1833f
C225 N3 VSS 20.37615f
C226 N2 VSS 21.22487f
C227 N1 VSS 21.48124f
C228 N0 VSS 21.26843f
C229 A1B VSS 18.61161f
C230 A0B VSS 18.77935f
C231 DEC1.t1 VSS 3.31102f
C232 DEC1.t0 VSS 1.30041f
C233 DEC1.n0 VSS 9.22901f
C234 DEC0.t1 VSS 8.01254f
C235 DEC0.t0 VSS 3.23099f
C236 DEC0.n0 VSS -3.02859f
C237 PCLK.t4 VSS 0.10879f
C238 PCLK.t2 VSS 0.15432f
C239 PCLK.n0 VSS 3.23439f
C240 PCLK.t1 VSS 0.15432f
C241 PCLK.n1 VSS 4.03602f
C242 PCLK.t3 VSS 0.24382f
C243 PCLK.n2 VSS 4.91463f
C244 PCLK.t0 VSS 0.15432f
C245 PCLK.n3 VSS 3.97392f
C246 net3.t0 VSS 2.42542f
C247 net3.t1 VSS 2.52198f
C248 net3.n0 VSS 8.5531f
C249 net1.t0 VSS 0.91265f
C250 net1.t1 VSS 0.90594f
C251 net1.n0 VSS 14.3488f
C252 N0.t1 VSS 0.0792f
C253 N0.t0 VSS 0.63355f
C254 N0.n0 VSS 5.34871f
C255 N0.t2 VSS 0.18661f
C256 N0.n1 VSS 4.03483f
C257 N0.t3 VSS 0.30317f
C258 N0.n2 VSS 9.97219f
C259 net2.t1 VSS 1.38352f
C260 net2.t0 VSS 1.40963f
C261 net2.n0 VSS 12.4791f
C262 N1.t1 VSS 0.10184f
C263 N1.t0 VSS 0.87342f
C264 N1.n0 VSS 2.51118f
C265 N1.t2 VSS 0.25766f
C266 N1.n1 VSS 5.12859f
C267 N1.t3 VSS 0.41638f
C268 N1.n2 VSS 11.5181f
C269 A0.t0 VSS 25.4294f
C270 DEC3.t1 VSS 0.93432f
C271 DEC3.t0 VSS 0.3513f
C272 DEC3.n0 VSS 7.59552f
C273 N3.t1 VSS 0.20517f
C274 N3.t0 VSS 1.96268f
C275 N3.n0 VSS -9.29966f
C276 N3.t2 VSS 0.58144f
C277 N3.n1 VSS 11.3227f
C278 N3.t3 VSS 0.92951f
C279 N3.n2 VSS 16.8412f
C280 A0B.t0 VSS 0.06187f
C281 A0B.t1 VSS 0.21488f
C282 A0B.n0 VSS 7.27577f
C283 A0B.t4 VSS 0.30223f
C284 A0B.n1 VSS 7.9321f
C285 A0B.t3 VSS 0.30223f
C286 A0B.n2 VSS 8.66294f
C287 A0B.t5 VSS 0.15341f
C288 A0B.n3 VSS 4.74f
C289 A0B.t2 VSS 0.25427f
C290 A0B.n4 VSS 4.57956f
C291 EVAL_GND.t3 VSS 0.85732f
C292 EVAL_GND.t2 VSS 1.1f
C293 EVAL_GND.n0 VSS 6.81866f
C294 EVAL_GND.t1 VSS 0.85316f
C295 EVAL_GND.n1 VSS 7.53403f
C296 EVAL_GND.t4 VSS 0.85316f
C297 EVAL_GND.n2 VSS 7.41838f
C298 EVAL_GND.t0 VSS 0.85316f
C299 EVAL_GND.n3 VSS 7.81467f
C300 net4.t1 VSS 8.89521f
C301 net4.t0 VSS 9.42877f
C302 net4.n0 VSS -16.2877f
C303 A0T.t3 VSS 0.54349f
C304 A0T.t2 VSS 0.59002f
C305 A0T.n0 VSS 12.0683f
C306 A0T.t1 VSS 0.60722f
C307 A0T.n1 VSS 6.04422f
C308 A0T.t0 VSS 1.75128f
C309 A0T.n2 VSS 7.54529f
C310 A1.t0 VSS 28.4735f
C311 VDD.n0 VSS 0.02983f
C312 VDD.n1 VSS 0.03566f
C313 VDD.t0 VSS 0.32046f
C314 VDD.n3 VSS 0.23484f
C315 VDD.n4 VSS 0.03665f
C316 VDD.n5 VSS 0.03665f
C317 VDD.n7 VSS 0.23484f
C318 VDD.n8 VSS 0.03665f
C319 VDD.n9 VSS 0.02509f
C320 VDD.n10 VSS 0.06446f
C321 VDD.t1 VSS 0.08495f
C322 VDD.n11 VSS 1.01147f
C323 VDD.n12 VSS 0.02983f
C324 VDD.n13 VSS 0.03566f
C325 VDD.t10 VSS 0.32046f
C326 VDD.n15 VSS 0.23484f
C327 VDD.n16 VSS 0.03665f
C328 VDD.n17 VSS 0.03665f
C329 VDD.n19 VSS 0.23484f
C330 VDD.n20 VSS 0.03665f
C331 VDD.n21 VSS 0.02509f
C332 VDD.n22 VSS 0.06407f
C333 VDD.n23 VSS 0.6605f
C334 VDD.t11 VSS 0.08495f
C335 VDD.n24 VSS 0.74616f
C336 VDD.n25 VSS 0.02983f
C337 VDD.n26 VSS 0.03566f
C338 VDD.t20 VSS 0.32046f
C339 VDD.n28 VSS 0.23484f
C340 VDD.n29 VSS 0.03665f
C341 VDD.n30 VSS 0.03665f
C342 VDD.n32 VSS 0.23484f
C343 VDD.n33 VSS 0.03665f
C344 VDD.n34 VSS 0.02509f
C345 VDD.n35 VSS 0.06407f
C346 VDD.n36 VSS 0.6605f
C347 VDD.t21 VSS 0.08495f
C348 VDD.n37 VSS 0.8376f
C349 VDD.n38 VSS 0.01962f
C350 VDD.n39 VSS 0.02561f
C351 VDD.t12 VSS 0.21378f
C352 VDD.n41 VSS 0.14949f
C353 VDD.n42 VSS 0.02598f
C354 VDD.n43 VSS 0.02598f
C355 VDD.n45 VSS 0.14949f
C356 VDD.n46 VSS 0.02598f
C357 VDD.n47 VSS 0.01975f
C358 VDD.n48 VSS 0.06049f
C359 VDD.n49 VSS 0.76863f
C360 VDD.t13 VSS 0.01796f
C361 VDD.n50 VSS 0.72902f
C362 VDD.n51 VSS 0.02983f
C363 VDD.n52 VSS 0.03566f
C364 VDD.t16 VSS 0.32046f
C365 VDD.n54 VSS 0.23484f
C366 VDD.n55 VSS 0.03665f
C367 VDD.n56 VSS 0.03665f
C368 VDD.n58 VSS 0.23484f
C369 VDD.n59 VSS 0.03665f
C370 VDD.n60 VSS 0.02509f
C371 VDD.n61 VSS 0.06407f
C372 VDD.n62 VSS 0.6605f
C373 VDD.t17 VSS 0.08495f
C374 VDD.n63 VSS 0.8376f
C375 VDD.n64 VSS 0.01962f
C376 VDD.n65 VSS 0.02561f
C377 VDD.t6 VSS 0.21378f
C378 VDD.n67 VSS 0.14949f
C379 VDD.n68 VSS 0.02598f
C380 VDD.n69 VSS 0.02598f
C381 VDD.n71 VSS 0.14949f
C382 VDD.n72 VSS 0.02598f
C383 VDD.n73 VSS 0.01975f
C384 VDD.n74 VSS 0.06049f
C385 VDD.n75 VSS 0.76863f
C386 VDD.t7 VSS 0.01796f
C387 VDD.n76 VSS 0.72902f
C388 VDD.n77 VSS 0.02983f
C389 VDD.n78 VSS 0.03566f
C390 VDD.t22 VSS 0.32046f
C391 VDD.n80 VSS 0.23484f
C392 VDD.n81 VSS 0.03665f
C393 VDD.n82 VSS 0.03665f
C394 VDD.n84 VSS 0.23484f
C395 VDD.n85 VSS 0.03665f
C396 VDD.n86 VSS 0.02509f
C397 VDD.n87 VSS 0.06407f
C398 VDD.n88 VSS 0.6605f
C399 VDD.t23 VSS 0.08495f
C400 VDD.n89 VSS 0.8376f
C401 VDD.n90 VSS 0.01962f
C402 VDD.n91 VSS 0.02561f
C403 VDD.t4 VSS 0.21378f
C404 VDD.n93 VSS 0.14949f
C405 VDD.n94 VSS 0.02598f
C406 VDD.n95 VSS 0.02598f
C407 VDD.n97 VSS 0.14949f
C408 VDD.n98 VSS 0.02598f
C409 VDD.n99 VSS 0.01975f
C410 VDD.n100 VSS 0.06049f
C411 VDD.n101 VSS 0.76863f
C412 VDD.t5 VSS 0.01796f
C413 VDD.n102 VSS 0.72902f
C414 VDD.n103 VSS 0.02983f
C415 VDD.n104 VSS 0.03566f
C416 VDD.t14 VSS 0.32046f
C417 VDD.n106 VSS 0.23484f
C418 VDD.n107 VSS 0.03665f
C419 VDD.n108 VSS 0.03665f
C420 VDD.n110 VSS 0.23484f
C421 VDD.n111 VSS 0.03665f
C422 VDD.n112 VSS 0.02509f
C423 VDD.n113 VSS 0.06407f
C424 VDD.n114 VSS 0.6605f
C425 VDD.t15 VSS 0.08495f
C426 VDD.n115 VSS 0.92905f
C427 VDD.n116 VSS 0.01962f
C428 VDD.n117 VSS 0.02561f
C429 VDD.t8 VSS 0.21378f
C430 VDD.n119 VSS 0.14949f
C431 VDD.n120 VSS 0.02598f
C432 VDD.n121 VSS 0.02598f
C433 VDD.n123 VSS 0.14949f
C434 VDD.n124 VSS 0.02598f
C435 VDD.n125 VSS 0.01975f
C436 VDD.n126 VSS 0.06049f
C437 VDD.n127 VSS 0.86007f
C438 VDD.t9 VSS 0.01796f
C439 VDD.n128 VSS 0.72902f
C440 VDD.n129 VSS 0.01908f
C441 VDD.n130 VSS 0.02508f
C442 VDD.t18 VSS 0.2064f
C443 VDD.n132 VSS 0.1458f
C444 VDD.n133 VSS 0.0254f
C445 VDD.n134 VSS 0.0254f
C446 VDD.n136 VSS 0.1458f
C447 VDD.n137 VSS 0.0254f
C448 VDD.n138 VSS 0.01946f
C449 VDD.n139 VSS 0.0603f
C450 VDD.n140 VSS 0.67807f
C451 VDD.t19 VSS 0.0159f
C452 VDD.n141 VSS 0.72659f
C453 VDD.n142 VSS 0.01908f
C454 VDD.n143 VSS 0.02508f
C455 VDD.t2 VSS 0.2064f
C456 VDD.n145 VSS 0.1458f
C457 VDD.n146 VSS 0.0254f
C458 VDD.n147 VSS 0.0254f
C459 VDD.n149 VSS 0.1458f
C460 VDD.n150 VSS 0.0254f
C461 VDD.n151 VSS 0.01946f
C462 VDD.n152 VSS 0.0603f
C463 VDD.n153 VSS 0.67807f
C464 VDD.t3 VSS 0.0159f
C465 VDD.n154 VSS 0.63916f
C466 A1T.t3 VSS 0.5577f
C467 A1T.t2 VSS 0.8009f
C468 A1T.n0 VSS 6.81649f
C469 A1T.t0 VSS 0.82627f
C470 A1T.n1 VSS 10.0488f
C471 A1T.t1 VSS 2.3679f
C472 A1T.n2 VSS 8.7656f
C473 A1B.t1 VSS 0.06591f
C474 A1B.t0 VSS 0.23584f
C475 A1B.n0 VSS 5.87177f
C476 A1B.t4 VSS 0.33013f
C477 A1B.n1 VSS 6.16167f
C478 A1B.t3 VSS 0.33013f
C479 A1B.n2 VSS 10.0589f
C480 A1B.t5 VSS 0.16769f
C481 A1B.n3 VSS 7.36452f
C482 A1B.t2 VSS 0.27662f
C483 A1B.n4 VSS 4.3482f
C484 DEC2.t1 VSS 2.18675f
C485 DEC2.t0 VSS 0.83917f
C486 DEC2.n0 VSS 12.2552f
C487 N2.t1 VSS 0.13583f
C488 N2.t0 VSS 1.23138f
C489 N2.n0 VSS -1.3128f
C490 N2.t3 VSS 0.36396f
C491 N2.n1 VSS 7.16693f
C492 N2.t2 VSS 0.58501f
C493 N2.n2 VSS 13.3056f
.ends row_decoder

* expanding   symbol:  wl_driver.sym # of pins=4
** sym_path: /work/cells/wordline_driver/wl_driver.sym
** sch_path: /work/cells/wordline_driver/wl_driver.sch
.subckt wl_driver VDD WL_IN WL VSS
*.iopin VDD
*.iopin VSS
*.iopin WL_IN
*.iopin WL
XMP1 WL_N WL_IN VDD VDD sky130_fd_pr__pfet_01v8 L=0.15 W=0.42 nf=1 ad='int((nf+1)/2) * W/nf * 0.29' as='int((nf+2)/2) * W/nf * 0.29'
+ pd='2*int((nf+1)/2) * (W/nf + 0.29)' ps='2*int((nf+2)/2) * (W/nf + 0.29)' nrd='0.29 / W' nrs='0.29 / W' sa=0 sb=0 sd=0 mult=1 m=1
XMN1 WL_N WL_IN VSS VSS sky130_fd_pr__nfet_01v8 L=0.15 W=0.42 nf=1 ad='int((nf+1)/2) * W/nf * 0.29' as='int((nf+2)/2) * W/nf * 0.29'
+ pd='2*int((nf+1)/2) * (W/nf + 0.29)' ps='2*int((nf+2)/2) * (W/nf + 0.29)' nrd='0.29 / W' nrs='0.29 / W' sa=0 sb=0 sd=0 mult=1 m=1
XMP2 WL WL_N VDD VDD sky130_fd_pr__pfet_01v8 L=0.15 W=0.84 nf=1 ad='int((nf+1)/2) * W/nf * 0.29' as='int((nf+2)/2) * W/nf * 0.29' pd='2*int((nf+1)/2) * (W/nf + 0.29)'
+ ps='2*int((nf+2)/2) * (W/nf + 0.29)' nrd='0.29 / W' nrs='0.29 / W' sa=0 sb=0 sd=0 mult=1 m=1
XMN2 WL WL_N VSS VSS sky130_fd_pr__nfet_01v8 L=0.15 W=0.84 nf=1 ad='int((nf+1)/2) * W/nf * 0.29' as='int((nf+2)/2) * W/nf * 0.29' pd='2*int((nf+1)/2) * (W/nf + 0.29)'
+ ps='2*int((nf+2)/2) * (W/nf + 0.29)' nrd='0.29 / W' nrs='0.29 / W' sa=0 sb=0 sd=0 mult=1 m=1
.ends

.GLOBAL GND
.end
