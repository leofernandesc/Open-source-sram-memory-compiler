** sch_path: /work/sims/row_decoder/tb_row_decoder_sizing.sch
**.subckt tb_row_decoder_sizing
x1 net1 net2 net3 net4 DEC0 DEC1 DEC3 DEC2 GND row_decoder
VDD_SRC net1 GND 1.62
VPCLK net2 GND PWL(0 0 4.975e-09 0 5.025e-09 1.62 9.975e-09 1.62 1.0025e-08 0 1.9975e-08 0 2.0025e-08 1.62 2.4975e-08 1.62 2.5025e-08 0 3e-08 0)
VA0 net3 GND PWL(0 1.62 1.795e-08 1.62 1.8e-08 0 3e-08 0)
VA1 net4 GND PWL(0 0 1.795e-08 0 1.8e-08 1.62 3e-08 1.62)
x2 net1 DEC0 net5 GND wl_driver
x3 net1 DEC1 net6 GND wl_driver
x4 net1 DEC3 net8 GND wl_driver
x5 net1 DEC2 net7 GND wl_driver
C_WL0 net5 GND 1.74e-14 m=1
C_WL1 net6 GND 1.74e-14 m=1
C_WL2 net7 GND 1.74e-14 m=1
C_WL3 net8 GND 1.74e-14 m=1
**.ends

* expanding   symbol:  row_decoder.sym # of pins=9
** sym_path: /work/cells/row_decoder/row_decoder.sym
** sch_path: /work/cells/row_decoder/row_decoder.sch
.subckt row_decoder VDD PCLK A0 A1 DEC0 DEC1 DEC3 DEC2 VSS
X0 VSS.t11 A1B.t4 A1T.t1 VSS.t10 sky130_fd_pr__nfet_01v8 ad=0.58 pd=4.58 as=0.58 ps=4.58 w=2 l=0.15
X1 VSS.t7 N0.t2 DEC0.t1 VSS.t6 sky130_fd_pr__nfet_01v8 ad=0.58 pd=4.58 as=0.58 ps=4.58 w=2 l=0.15
X2 VDD.t15 A0.t1 A0B.t0 VDD.t14 sky130_fd_pr__pfet_01v8 ad=0.2436 pd=2.26 as=0.2436 ps=2.26 w=0.84 l=0.15
X3 VDD.t21 PCLK.t4 N0.t1 VDD.t20 sky130_fd_pr__pfet_01v8 ad=0.3625 pd=3.08 as=0.3625 ps=3.08 w=1.25 l=0.15
X4 EVAL_GND.t0 A0B.t2 net3.t0 VSS.t0 sky130_fd_pr__nfet_01v8 ad=0.58 pd=4.58 as=0.58 ps=4.58 w=2 l=0.15
X5 VSS.t14 N3.t2 DEC3.t1 VSS.t13 sky130_fd_pr__nfet_01v8 ad=0.58 pd=4.58 as=0.58 ps=4.58 w=2 l=0.15
X6 VDD.t19 PCLK.t3 N1.t1 VDD.t18 sky130_fd_pr__pfet_01v8 ad=0.3625 pd=3.08 as=0.3625 ps=3.08 w=1.25 l=0.15
X7 VDD.t11 A0B.t5 A0T.t1 VDD.t10 sky130_fd_pr__pfet_01v8 ad=0.58 pd=4.58 as=0.58 ps=4.58 w=2 l=0.15
X8 VDD.t23 PCLK.t1 N3.t1 VDD.t22 sky130_fd_pr__pfet_01v8 ad=0.3625 pd=3.08 as=0.3625 ps=3.08 w=1.25 l=0.15
X9 net2.t0 A1B.t2 N1.t0 VSS.t1 sky130_fd_pr__nfet_01v8 ad=0.58 pd=4.58 as=0.58 ps=4.58 w=2 l=0.15
X10 net1.t0 A1B.t3 N0.t0 VSS.t9 sky130_fd_pr__nfet_01v8 ad=0.58 pd=4.58 as=0.58 ps=4.58 w=2 l=0.15
X11 VSS.t3 N2.t2 DEC2.t1 VSS.t2 sky130_fd_pr__nfet_01v8 ad=0.58 pd=4.58 as=0.58 ps=4.58 w=2 l=0.15
X12 VDD.t5 N0.t3 DEC0.t0 VDD.t4 sky130_fd_pr__pfet_01v8 ad=0.87 pd=6.58 as=0.87 ps=6.58 w=3 l=0.15
X13 VDD.t1 N2.t3 DEC2.t0 VDD.t0 sky130_fd_pr__pfet_01v8 ad=0.87 pd=6.58 as=0.87 ps=6.58 w=3 l=0.15
X14 VSS.t21 A1.t0 A1B.t1 VSS.t20 sky130_fd_pr__nfet_01v8 ad=0.2436 pd=2.26 as=0.2436 ps=2.26 w=0.84 l=0.15
X15 VSS.t18 A0B.t4 A0T.t0 VSS.t17 sky130_fd_pr__nfet_01v8 ad=0.58 pd=4.58 as=0.58 ps=4.58 w=2 l=0.15
X16 EVAL_GND.t1 A0T.t3 net2.t1 VSS.t12 sky130_fd_pr__nfet_01v8 ad=0.58 pd=4.58 as=0.58 ps=4.58 w=2 l=0.15
X17 net4.t0 A1T.t2 N3.t0 VSS.t8 sky130_fd_pr__nfet_01v8 ad=0.58 pd=4.58 as=0.58 ps=4.58 w=2 l=0.15
X18 VSS.t25 PCLK.t0 EVAL_GND.t4 VSS.t24 sky130_fd_pr__nfet_01v8 ad=0.435 pd=3.58 as=0.435 ps=3.58 w=1.5 l=0.15
X19 EVAL_GND.t3 A0B.t3 net1.t1 VSS.t19 sky130_fd_pr__nfet_01v8 ad=0.58 pd=4.58 as=0.58 ps=4.58 w=2 l=0.15
X20 VDD.t3 N1.t3 DEC1.t0 VDD.t2 sky130_fd_pr__pfet_01v8 ad=0.87 pd=6.58 as=0.87 ps=6.58 w=3 l=0.15
X21 VDD.t9 N3.t3 DEC3.t0 VDD.t8 sky130_fd_pr__pfet_01v8 ad=0.87 pd=6.58 as=0.87 ps=6.58 w=3 l=0.15
X22 net3.t1 A1T.t3 N2.t0 VSS.t15 sky130_fd_pr__nfet_01v8 ad=0.58 pd=4.58 as=0.58 ps=4.58 w=2 l=0.15
X23 VDD.t13 A1.t1 A1B.t0 VDD.t12 sky130_fd_pr__pfet_01v8 ad=0.2436 pd=2.26 as=0.2436 ps=2.26 w=0.84 l=0.15
X24 VSS.t23 A0.t0 A0B.t1 VSS.t22 sky130_fd_pr__nfet_01v8 ad=0.2436 pd=2.26 as=0.2436 ps=2.26 w=0.84 l=0.15
X25 VSS.t5 N1.t2 DEC1.t1 VSS.t4 sky130_fd_pr__nfet_01v8 ad=0.58 pd=4.58 as=0.58 ps=4.58 w=2 l=0.15
X26 EVAL_GND.t2 A0T.t2 net4.t1 VSS.t16 sky130_fd_pr__nfet_01v8 ad=0.58 pd=4.58 as=0.58 ps=4.58 w=2 l=0.15
X27 VDD.t17 PCLK.t2 N2.t1 VDD.t16 sky130_fd_pr__pfet_01v8 ad=0.3625 pd=3.08 as=0.3625 ps=3.08 w=1.25 l=0.15
X28 VDD.t7 A1B.t5 A1T.t0 VDD.t6 sky130_fd_pr__pfet_01v8 ad=0.58 pd=4.58 as=0.58 ps=4.58 w=2 l=0.15
R0 DEC3.n0 DEC3.t0 95.4423
R1 DEC3.n0 DEC3.t1 58.1912
R2 DEC3 DEC3.n0 21.5962
R3 DEC2.n0 DEC2.t0 95.7757
R4 DEC2.n0 DEC2.t1 57.8579
R5 DEC2 DEC2.n0 17.6012
R6 DEC1.n0 DEC1.t0 96.109
R7 DEC1.n0 DEC1.t1 57.5246
R8 DEC1 DEC1.n0 12.2745
R9 DEC0.n0 DEC0.t0 96.4423
R10 DEC0.n0 DEC0.t1 57.1912
R11 DEC0 DEC0.n0 8.27955
R12 PCLK.n1 PCLK.t0 245.097
R13 PCLK.n0 PCLK.t1 229.445
R14 PCLK.n3 PCLK.t4 225.458
R15 PCLK.n2 PCLK.t3 225.458
R16 PCLK.n0 PCLK.t2 225.458
R17 PCLK PCLK.n3 6.24288
R18 PCLK.n3 PCLK.n2 3.9861
R19 PCLK.n2 PCLK.n1 3.5161
R20 PCLK.n1 PCLK.n0 1.79277
R21 A1.n0 A1.t1 193.358
R22 A1.n0 A1.t0 191.812
R23 A1 A1.n0 3.10955
R24 A0.n0 A0.t1 193.692
R25 A0.n0 A0.t0 191.48
R26 A0 A0.n0 0.446217
R27 VDD.n5 VDD.n3 2142.35
R28 VDD.n8 VDD.n7 2142.35
R29 VDD.n30 VDD.n28 2142.35
R30 VDD.n33 VDD.n32 2142.35
R31 VDD.n56 VDD.n54 2142.35
R32 VDD.n59 VDD.n58 2142.35
R33 VDD.n82 VDD.n80 2142.35
R34 VDD.n85 VDD.n84 2142.35
R35 VDD.n108 VDD.n106 1789.41
R36 VDD.n111 VDD.n110 1789.41
R37 VDD.n134 VDD.n132 1789.41
R38 VDD.n137 VDD.n136 1789.41
R39 VDD.n17 VDD.n15 1524.71
R40 VDD.n20 VDD.n19 1524.71
R41 VDD.n43 VDD.n41 1524.71
R42 VDD.n46 VDD.n45 1524.71
R43 VDD.n69 VDD.n67 1524.71
R44 VDD.n72 VDD.n71 1524.71
R45 VDD.n95 VDD.n93 1524.71
R46 VDD.n98 VDD.n97 1524.71
R47 VDD.n121 VDD.n119 1380
R48 VDD.n124 VDD.n123 1380
R49 VDD.n147 VDD.n145 1380
R50 VDD.n150 VDD.n149 1380
R51 VDD.n128 VDD.t13 341.204
R52 VDD.n154 VDD.t15 341.204
R53 VDD.n24 VDD.t23 230.994
R54 VDD.n50 VDD.t17 230.994
R55 VDD.n76 VDD.t19 230.994
R56 VDD.n102 VDD.t21 230.994
R57 VDD.n4 VDD.n0 228.518
R58 VDD.n4 VDD.n1 228.518
R59 VDD.n29 VDD.n25 228.518
R60 VDD.n29 VDD.n26 228.518
R61 VDD.n55 VDD.n51 228.518
R62 VDD.n55 VDD.n52 228.518
R63 VDD.n81 VDD.n77 228.518
R64 VDD.n81 VDD.n78 228.518
R65 VDD.n9 VDD.n1 227.388
R66 VDD.n34 VDD.n26 227.388
R67 VDD.n60 VDD.n52 227.388
R68 VDD.n86 VDD.n78 227.388
R69 VDD.n123 VDD.n122 223.581
R70 VDD.n119 VDD.n118 223.581
R71 VDD.n149 VDD.n148 223.581
R72 VDD.n145 VDD.n144 223.581
R73 VDD.n19 VDD.n18 203.438
R74 VDD.n15 VDD.n14 203.438
R75 VDD.n45 VDD.n44 203.438
R76 VDD.n41 VDD.n40 203.438
R77 VDD.n71 VDD.n70 203.438
R78 VDD.n67 VDD.n66 203.438
R79 VDD.n97 VDD.n96 203.438
R80 VDD.n93 VDD.n92 203.438
R81 VDD.n107 VDD.n103 190.871
R82 VDD.n107 VDD.n104 190.871
R83 VDD.n133 VDD.n129 190.871
R84 VDD.n133 VDD.n130 190.871
R85 VDD.n112 VDD.n104 189.742
R86 VDD.n138 VDD.n130 189.742
R87 VDD.n110 VDD.n109 173.642
R88 VDD.n106 VDD.n105 173.642
R89 VDD.n136 VDD.n135 173.642
R90 VDD.n132 VDD.n131 173.642
R91 VDD.n10 VDD.n0 167.906
R92 VDD.n35 VDD.n25 167.906
R93 VDD.n61 VDD.n51 167.906
R94 VDD.n87 VDD.n77 167.906
R95 VDD.n16 VDD.n12 162.636
R96 VDD.n16 VDD.n13 162.636
R97 VDD.n42 VDD.n38 162.636
R98 VDD.n42 VDD.n39 162.636
R99 VDD.n68 VDD.n64 162.636
R100 VDD.n68 VDD.n65 162.636
R101 VDD.n94 VDD.n90 162.636
R102 VDD.n94 VDD.n91 162.636
R103 VDD.n21 VDD.n13 161.506
R104 VDD.n47 VDD.n39 161.506
R105 VDD.n73 VDD.n65 161.506
R106 VDD.n99 VDD.n91 161.506
R107 VDD.n120 VDD.n116 147.201
R108 VDD.n120 VDD.n117 147.201
R109 VDD.n146 VDD.n142 147.201
R110 VDD.n146 VDD.n143 147.201
R111 VDD.n125 VDD.n117 146.071
R112 VDD.n151 VDD.n143 146.071
R113 VDD.n7 VDD.n6 144.319
R114 VDD.n3 VDD.n2 144.319
R115 VDD.n32 VDD.n31 144.319
R116 VDD.n28 VDD.n27 144.319
R117 VDD.n58 VDD.n57 144.319
R118 VDD.n54 VDD.n53 144.319
R119 VDD.n84 VDD.n83 144.319
R120 VDD.n80 VDD.n79 144.319
R121 VDD.n113 VDD.n103 130.26
R122 VDD.n139 VDD.n129 130.26
R123 VDD.n11 VDD.n10 126.147
R124 VDD.n36 VDD.n35 125.954
R125 VDD.n62 VDD.n61 125.954
R126 VDD.n88 VDD.n87 125.954
R127 VDD.n114 VDD.n113 125.746
R128 VDD.n140 VDD.n139 125.746
R129 VDD.n23 VDD.n22 125.59
R130 VDD.n49 VDD.n48 125.59
R131 VDD.n75 VDD.n74 125.59
R132 VDD.n101 VDD.n100 125.59
R133 VDD.n127 VDD.n126 125.504
R134 VDD.n153 VDD.n152 125.504
R135 VDD.n115 VDD.t7 123.68
R136 VDD.n141 VDD.t11 123.68
R137 VDD.n22 VDD.n12 102.025
R138 VDD.n48 VDD.n38 102.025
R139 VDD.n74 VDD.n64 102.025
R140 VDD.n100 VDD.n90 102.025
R141 VDD.n11 VDD.t9 93.8443
R142 VDD.n37 VDD.t1 93.8443
R143 VDD.n63 VDD.t3 93.8443
R144 VDD.n89 VDD.t5 93.8443
R145 VDD.n9 VDD.n8 92.5005
R146 VDD.n5 VDD.n4 92.5005
R147 VDD.n21 VDD.n20 92.5005
R148 VDD.n17 VDD.n16 92.5005
R149 VDD.n34 VDD.n33 92.5005
R150 VDD.n30 VDD.n29 92.5005
R151 VDD.n47 VDD.n46 92.5005
R152 VDD.n43 VDD.n42 92.5005
R153 VDD.n60 VDD.n59 92.5005
R154 VDD.n56 VDD.n55 92.5005
R155 VDD.n73 VDD.n72 92.5005
R156 VDD.n69 VDD.n68 92.5005
R157 VDD.n86 VDD.n85 92.5005
R158 VDD.n82 VDD.n81 92.5005
R159 VDD.n99 VDD.n98 92.5005
R160 VDD.n95 VDD.n94 92.5005
R161 VDD.n112 VDD.n111 92.5005
R162 VDD.n108 VDD.n107 92.5005
R163 VDD.n125 VDD.n124 92.5005
R164 VDD.n121 VDD.n120 92.5005
R165 VDD.n138 VDD.n137 92.5005
R166 VDD.n134 VDD.n133 92.5005
R167 VDD.n151 VDD.n150 92.5005
R168 VDD.n147 VDD.n146 92.5005
R169 VDD.n126 VDD.n116 86.5887
R170 VDD.n152 VDD.n142 86.5887
R171 VDD.n6 VDD.n5 82.6992
R172 VDD.n8 VDD.n2 82.6992
R173 VDD.n31 VDD.n30 82.6992
R174 VDD.n33 VDD.n27 82.6992
R175 VDD.n57 VDD.n56 82.6992
R176 VDD.n59 VDD.n53 82.6992
R177 VDD.n83 VDD.n82 82.6992
R178 VDD.n85 VDD.n79 82.6992
R179 VDD.n109 VDD.n108 79.4196
R180 VDD.n111 VDD.n105 79.4196
R181 VDD.n135 VDD.n134 79.4196
R182 VDD.n137 VDD.n131 79.4196
R183 VDD.n18 VDD.n17 75.5742
R184 VDD.n20 VDD.n14 75.5742
R185 VDD.n44 VDD.n43 75.5742
R186 VDD.n46 VDD.n40 75.5742
R187 VDD.n70 VDD.n69 75.5742
R188 VDD.n72 VDD.n66 75.5742
R189 VDD.n96 VDD.n95 75.5742
R190 VDD.n98 VDD.n92 75.5742
R191 VDD.n122 VDD.n121 72.6454
R192 VDD.n124 VDD.n118 72.6454
R193 VDD.n148 VDD.n147 72.6454
R194 VDD.n150 VDD.n144 72.6454
R195 VDD.n10 VDD.n9 50.5605
R196 VDD.n22 VDD.n21 50.5605
R197 VDD.n35 VDD.n34 50.5605
R198 VDD.n48 VDD.n47 50.5605
R199 VDD.n61 VDD.n60 50.5605
R200 VDD.n74 VDD.n73 50.5605
R201 VDD.n87 VDD.n86 50.5605
R202 VDD.n100 VDD.n99 50.5605
R203 VDD.n113 VDD.n112 50.5605
R204 VDD.n126 VDD.n125 50.5605
R205 VDD.n139 VDD.n138 50.5605
R206 VDD.n152 VDD.n151 50.5605
R207 VDD.n119 VDD.n116 37.0005
R208 VDD.n123 VDD.n117 37.0005
R209 VDD.n145 VDD.n142 37.0005
R210 VDD.n149 VDD.n143 37.0005
R211 VDD.n15 VDD.n12 30.8338
R212 VDD.n19 VDD.n13 30.8338
R213 VDD.n41 VDD.n38 30.8338
R214 VDD.n45 VDD.n39 30.8338
R215 VDD.n67 VDD.n64 30.8338
R216 VDD.n71 VDD.n65 30.8338
R217 VDD.n93 VDD.n90 30.8338
R218 VDD.n97 VDD.n91 30.8338
R219 VDD.n106 VDD.n103 23.1255
R220 VDD.n110 VDD.n104 23.1255
R221 VDD.n132 VDD.n129 23.1255
R222 VDD.n136 VDD.n130 23.1255
R223 VDD.n3 VDD.n0 16.8187
R224 VDD.n7 VDD.n1 16.8187
R225 VDD.n28 VDD.n25 16.8187
R226 VDD.n32 VDD.n26 16.8187
R227 VDD.n54 VDD.n51 16.8187
R228 VDD.n58 VDD.n52 16.8187
R229 VDD.n80 VDD.n77 16.8187
R230 VDD.n84 VDD.n78 16.8187
R231 VDD.t12 VDD.n118 14.9873
R232 VDD.n122 VDD.t12 14.9873
R233 VDD.t14 VDD.n144 14.9873
R234 VDD.n148 VDD.t14 14.9873
R235 VDD.t22 VDD.n14 12.343
R236 VDD.n18 VDD.t22 12.343
R237 VDD.t16 VDD.n40 12.343
R238 VDD.n44 VDD.t16 12.343
R239 VDD.t18 VDD.n66 12.343
R240 VDD.n70 VDD.t18 12.343
R241 VDD.t20 VDD.n92 12.343
R242 VDD.n96 VDD.t20 12.343
R243 VDD.t6 VDD.n105 8.97701
R244 VDD.n109 VDD.t6 8.97701
R245 VDD.t10 VDD.n131 8.97701
R246 VDD.n135 VDD.t10 8.97701
R247 VDD.t8 VDD.n2 6.23219
R248 VDD.n6 VDD.t8 6.23219
R249 VDD.t0 VDD.n27 6.23219
R250 VDD.n31 VDD.t0 6.23219
R251 VDD.t2 VDD.n53 6.23219
R252 VDD.n57 VDD.t2 6.23219
R253 VDD.t4 VDD.n79 6.23219
R254 VDD.n83 VDD.t4 6.23219
R255 VDD.n101 VDD.n89 2.45077
R256 VDD.n75 VDD.n63 2.45077
R257 VDD.n62 VDD.n50 2.45077
R258 VDD.n49 VDD.n37 2.45077
R259 VDD.n23 VDD.n11 2.45077
R260 VDD.n153 VDD.n141 1.1191
R261 VDD.n140 VDD.n128 1.1191
R262 VDD.n127 VDD.n115 1.1191
R263 VDD.n114 VDD.n102 1.1191
R264 VDD.n88 VDD.n76 1.1191
R265 VDD.n36 VDD.n24 1.1191
R266 VDD VDD.n154 1.03372
R267 VDD.n154 VDD.n153 0.194767
R268 VDD.n141 VDD.n140 0.194767
R269 VDD.n128 VDD.n127 0.194767
R270 VDD.n115 VDD.n114 0.194767
R271 VDD.n102 VDD.n101 0.194767
R272 VDD.n89 VDD.n88 0.194767
R273 VDD.n76 VDD.n75 0.194767
R274 VDD.n63 VDD.n62 0.194767
R275 VDD.n50 VDD.n49 0.194767
R276 VDD.n37 VDD.n36 0.194767
R277 VDD.n24 VDD.n23 0.194767
R278 VSS.n177 VSS.n5 73059.7
R279 VSS.n206 VSS.n5 47999.8
R280 VSS.t0 VSS.t24 25793.6
R281 VSS.t20 VSS.n5 13006.8
R282 VSS.n98 VSS.n67 2885.47
R283 VSS.n94 VSS.n67 2885.47
R284 VSS.n98 VSS.n66 2885.47
R285 VSS.n175 VSS.n23 2885.47
R286 VSS.n171 VSS.n23 2885.47
R287 VSS.n175 VSS.n22 2885.47
R288 VSS.n171 VSS.n22 2885.47
R289 VSS.n183 VSS.n19 2885.47
R290 VSS.n179 VSS.n19 2885.47
R291 VSS.n183 VSS.n18 2885.47
R292 VSS.n179 VSS.n18 2885.47
R293 VSS.n190 VSS.n15 2885.47
R294 VSS.n186 VSS.n15 2885.47
R295 VSS.n190 VSS.n14 2885.47
R296 VSS.n186 VSS.n14 2885.47
R297 VSS.n204 VSS.n7 2885.47
R298 VSS.n200 VSS.n7 2885.47
R299 VSS.n204 VSS.n6 2885.47
R300 VSS.n200 VSS.n6 2885.47
R301 VSS.n147 VSS.n39 2885.47
R302 VSS.n143 VSS.n39 2885.47
R303 VSS.n147 VSS.n38 2885.47
R304 VSS.n143 VSS.n38 2885.47
R305 VSS.n154 VSS.n35 2885.47
R306 VSS.n150 VSS.n35 2885.47
R307 VSS.n154 VSS.n34 2885.47
R308 VSS.n150 VSS.n34 2885.47
R309 VSS.n161 VSS.n31 2885.47
R310 VSS.n157 VSS.n31 2885.47
R311 VSS.n161 VSS.n30 2885.47
R312 VSS.n157 VSS.n30 2885.47
R313 VSS.n168 VSS.n27 2885.47
R314 VSS.n164 VSS.n27 2885.47
R315 VSS.n168 VSS.n26 2885.47
R316 VSS.n164 VSS.n26 2885.47
R317 VSS.n126 VSS.n51 2885.47
R318 VSS.n122 VSS.n51 2885.47
R319 VSS.n126 VSS.n50 2885.47
R320 VSS.n122 VSS.n50 2885.47
R321 VSS.n133 VSS.n47 2885.47
R322 VSS.n129 VSS.n47 2885.47
R323 VSS.n133 VSS.n46 2885.47
R324 VSS.n129 VSS.n46 2885.47
R325 VSS.n105 VSS.n63 2885.47
R326 VSS.n101 VSS.n63 2885.47
R327 VSS.n105 VSS.n62 2885.47
R328 VSS.n101 VSS.n62 2885.47
R329 VSS.n112 VSS.n59 2885.47
R330 VSS.n108 VSS.n59 2885.47
R331 VSS.n112 VSS.n58 2885.47
R332 VSS.n108 VSS.n58 2885.47
R333 VSS.n119 VSS.n55 2885.47
R334 VSS.n115 VSS.n55 2885.47
R335 VSS.n119 VSS.n54 2885.47
R336 VSS.n115 VSS.n54 2885.47
R337 VSS.n140 VSS.n43 2595.76
R338 VSS.n136 VSS.n43 2595.76
R339 VSS.n140 VSS.n42 2595.76
R340 VSS.n136 VSS.n42 2595.76
R341 VSS.n197 VSS.n11 2213.35
R342 VSS.n193 VSS.n11 2213.35
R343 VSS.n197 VSS.n10 2213.35
R344 VSS.n193 VSS.n10 2213.35
R345 VSS.n211 VSS.n4 2213.35
R346 VSS.n208 VSS.n3 2213.35
R347 VSS.n211 VSS.n3 2213.35
R348 VSS.n114 VSS.n113 1298.15
R349 VSS.n107 VSS.n106 1298.15
R350 VSS.n100 VSS.n99 1298.15
R351 VSS.n163 VSS.n162 1298.15
R352 VSS.n156 VSS.n155 1298.15
R353 VSS.n149 VSS.n148 1298.15
R354 VSS.n170 VSS.n169 1272.09
R355 VSS.n199 VSS.n198 1271.05
R356 VSS.n192 VSS.n191 1271.05
R357 VSS.n185 VSS.n184 1271.05
R358 VSS.n121 VSS.n120 1253.25
R359 VSS.n142 VSS.n141 1253.25
R360 VSS.n135 VSS.n134 1251.46
R361 VSS.n128 VSS.n127 1251.46
R362 VSS.n206 VSS.n205 1237.99
R363 VSS.n178 VSS.n177 635.525
R364 VSS.n177 VSS.n176 635.525
R365 VSS.n68 VSS.n66 292.5
R366 VSS.n67 VSS.t13 292.5
R367 VSS.n96 VSS.n67 292.5
R368 VSS.n54 VSS.t2 292.5
R369 VSS.n56 VSS.n54 292.5
R370 VSS.n55 VSS.t2 292.5
R371 VSS.n117 VSS.n55 292.5
R372 VSS.n58 VSS.t8 292.5
R373 VSS.n60 VSS.n58 292.5
R374 VSS.n59 VSS.t8 292.5
R375 VSS.n110 VSS.n59 292.5
R376 VSS.n62 VSS.t16 292.5
R377 VSS.n64 VSS.n62 292.5
R378 VSS.n63 VSS.t16 292.5
R379 VSS.n103 VSS.n63 292.5
R380 VSS.n46 VSS.t15 292.5
R381 VSS.n48 VSS.n46 292.5
R382 VSS.n47 VSS.t15 292.5
R383 VSS.n131 VSS.n47 292.5
R384 VSS.n42 VSS.t24 292.5
R385 VSS.n44 VSS.n42 292.5
R386 VSS.n43 VSS.t24 292.5
R387 VSS.n138 VSS.n43 292.5
R388 VSS.n50 VSS.t0 292.5
R389 VSS.n52 VSS.n50 292.5
R390 VSS.n51 VSS.t0 292.5
R391 VSS.n124 VSS.n51 292.5
R392 VSS.n26 VSS.t6 292.5
R393 VSS.n28 VSS.n26 292.5
R394 VSS.n27 VSS.t6 292.5
R395 VSS.n166 VSS.n27 292.5
R396 VSS.n30 VSS.t1 292.5
R397 VSS.n32 VSS.n30 292.5
R398 VSS.n31 VSS.t1 292.5
R399 VSS.n159 VSS.n31 292.5
R400 VSS.n34 VSS.t12 292.5
R401 VSS.n36 VSS.n34 292.5
R402 VSS.n35 VSS.t12 292.5
R403 VSS.n152 VSS.n35 292.5
R404 VSS.n38 VSS.t4 292.5
R405 VSS.n40 VSS.n38 292.5
R406 VSS.n39 VSS.t4 292.5
R407 VSS.n145 VSS.n39 292.5
R408 VSS.n6 VSS.t17 292.5
R409 VSS.n8 VSS.n6 292.5
R410 VSS.n7 VSS.t17 292.5
R411 VSS.n202 VSS.n7 292.5
R412 VSS.t22 VSS.n3 292.5
R413 VSS.n3 VSS.n1 292.5
R414 VSS.n4 VSS.n2 292.5
R415 VSS.n14 VSS.t10 292.5
R416 VSS.n16 VSS.n14 292.5
R417 VSS.n15 VSS.t10 292.5
R418 VSS.n188 VSS.n15 292.5
R419 VSS.n10 VSS.t20 292.5
R420 VSS.n12 VSS.n10 292.5
R421 VSS.n11 VSS.t20 292.5
R422 VSS.n195 VSS.n11 292.5
R423 VSS.n18 VSS.t9 292.5
R424 VSS.n20 VSS.n18 292.5
R425 VSS.n19 VSS.t9 292.5
R426 VSS.n181 VSS.n19 292.5
R427 VSS.n22 VSS.t19 292.5
R428 VSS.n24 VSS.n22 292.5
R429 VSS.n23 VSS.t19 292.5
R430 VSS.n173 VSS.n23 292.5
R431 VSS.n93 VSS.n66 248.287
R432 VSS.n209 VSS.n4 233.893
R433 VSS.n209 VSS.n208 209.589
R434 VSS.n94 VSS.n93 187.87
R435 VSS.n96 VSS.n95 187.482
R436 VSS.n97 VSS.n96 187.482
R437 VSS.n174 VSS.n173 187.482
R438 VSS.n173 VSS.n172 187.482
R439 VSS.n182 VSS.n181 187.482
R440 VSS.n181 VSS.n180 187.482
R441 VSS.n189 VSS.n188 187.482
R442 VSS.n188 VSS.n187 187.482
R443 VSS.n203 VSS.n202 187.482
R444 VSS.n202 VSS.n201 187.482
R445 VSS.n146 VSS.n145 187.482
R446 VSS.n145 VSS.n144 187.482
R447 VSS.n153 VSS.n152 187.482
R448 VSS.n152 VSS.n151 187.482
R449 VSS.n160 VSS.n159 187.482
R450 VSS.n159 VSS.n158 187.482
R451 VSS.n167 VSS.n166 187.482
R452 VSS.n166 VSS.n165 187.482
R453 VSS.n125 VSS.n124 187.482
R454 VSS.n124 VSS.n123 187.482
R455 VSS.n132 VSS.n131 187.482
R456 VSS.n131 VSS.n130 187.482
R457 VSS.n104 VSS.n103 187.482
R458 VSS.n103 VSS.n102 187.482
R459 VSS.n111 VSS.n110 187.482
R460 VSS.n110 VSS.n109 187.482
R461 VSS.n118 VSS.n117 187.482
R462 VSS.n117 VSS.n116 187.482
R463 VSS.n97 VSS.n68 186.353
R464 VSS.n174 VSS.n24 186.353
R465 VSS.n182 VSS.n20 186.353
R466 VSS.n189 VSS.n16 186.353
R467 VSS.n203 VSS.n8 186.353
R468 VSS.n146 VSS.n40 186.353
R469 VSS.n153 VSS.n36 186.353
R470 VSS.n160 VSS.n32 186.353
R471 VSS.n167 VSS.n28 186.353
R472 VSS.n125 VSS.n52 186.353
R473 VSS.n132 VSS.n48 186.353
R474 VSS.n104 VSS.n64 186.353
R475 VSS.n111 VSS.n60 186.353
R476 VSS.n118 VSS.n56 186.353
R477 VSS.n139 VSS.n138 168.66
R478 VSS.n138 VSS.n137 168.66
R479 VSS.n139 VSS.n44 167.53
R480 VSS.n120 VSS.t2 148.2
R481 VSS.n114 VSS.t2 148.2
R482 VSS.n113 VSS.t8 148.2
R483 VSS.n107 VSS.t8 148.2
R484 VSS.n106 VSS.t16 148.2
R485 VSS.n100 VSS.t16 148.2
R486 VSS.n99 VSS.t13 148.2
R487 VSS.n169 VSS.t6 148.2
R488 VSS.n163 VSS.t6 148.2
R489 VSS.n162 VSS.t1 148.2
R490 VSS.n156 VSS.t1 148.2
R491 VSS.n155 VSS.t12 148.2
R492 VSS.n149 VSS.t12 148.2
R493 VSS.n148 VSS.t4 148.2
R494 VSS.n142 VSS.t4 148.2
R495 VSS.n210 VSS.t22 145.106
R496 VSS.n205 VSS.t17 145.106
R497 VSS.n199 VSS.t17 145.106
R498 VSS.n198 VSS.t20 145.106
R499 VSS.n192 VSS.t20 145.106
R500 VSS.n191 VSS.t10 145.106
R501 VSS.n185 VSS.t10 145.106
R502 VSS.n184 VSS.t9 145.106
R503 VSS.n178 VSS.t9 145.106
R504 VSS.n176 VSS.t19 145.106
R505 VSS.n170 VSS.t19 145.106
R506 VSS.n196 VSS.n195 143.812
R507 VSS.n195 VSS.n194 143.812
R508 VSS.n207 VSS.n2 143.812
R509 VSS.n212 VSS.n2 143.812
R510 VSS.n141 VSS.t24 142.869
R511 VSS.n135 VSS.t24 142.869
R512 VSS.n134 VSS.t15 142.869
R513 VSS.n128 VSS.t15 142.869
R514 VSS.n127 VSS.t0 142.869
R515 VSS.n121 VSS.t0 142.869
R516 VSS.n196 VSS.n12 142.683
R517 VSS.n207 VSS.n1 142.683
R518 VSS.n72 VSS.t21 129.631
R519 VSS.n0 VSS.t23 129.631
R520 VSS.n95 VSS.n92 126.871
R521 VSS.n172 VSS.n25 126.871
R522 VSS.n180 VSS.n21 126.871
R523 VSS.n187 VSS.n17 126.871
R524 VSS.n201 VSS.n9 126.871
R525 VSS.n144 VSS.n41 126.871
R526 VSS.n151 VSS.n37 126.871
R527 VSS.n158 VSS.n33 126.871
R528 VSS.n165 VSS.n29 126.871
R529 VSS.n123 VSS.n53 126.871
R530 VSS.n130 VSS.n49 126.871
R531 VSS.n102 VSS.n65 126.871
R532 VSS.n109 VSS.n61 126.871
R533 VSS.n116 VSS.n57 126.871
R534 VSS.n71 VSS.n13 124.871
R535 VSS.n214 VSS.n213 124.871
R536 VSS.n83 VSS.n45 124.734
R537 VSS.n92 VSS.n91 124.629
R538 VSS.n76 VSS.n25 124.629
R539 VSS.n75 VSS.n21 124.629
R540 VSS.n73 VSS.n17 124.629
R541 VSS.n69 VSS.n9 124.629
R542 VSS.n81 VSS.n41 124.629
R543 VSS.n80 VSS.n37 124.629
R544 VSS.n79 VSS.n33 124.629
R545 VSS.n77 VSS.n29 124.629
R546 VSS.n86 VSS.n53 124.629
R547 VSS.n85 VSS.n49 124.629
R548 VSS.n90 VSS.n65 124.629
R549 VSS.n89 VSS.n61 124.629
R550 VSS.n87 VSS.n57 124.629
R551 VSS.n211 VSS.n210 117.001
R552 VSS.n212 VSS.n211 117.001
R553 VSS.n208 VSS.n207 117.001
R554 VSS.n193 VSS.n192 117.001
R555 VSS.n194 VSS.n193 117.001
R556 VSS.n198 VSS.n197 117.001
R557 VSS.n197 VSS.n196 117.001
R558 VSS.n137 VSS.n45 108.047
R559 VSS.n136 VSS.n135 83.5719
R560 VSS.n137 VSS.n136 83.5719
R561 VSS.n141 VSS.n140 83.5719
R562 VSS.n140 VSS.n139 83.5719
R563 VSS.n194 VSS.n13 83.2005
R564 VSS.n213 VSS.n212 83.2005
R565 VSS.n95 VSS.n94 73.1255
R566 VSS.n99 VSS.n98 73.1255
R567 VSS.n98 VSS.n97 73.1255
R568 VSS.n115 VSS.n114 73.1255
R569 VSS.n116 VSS.n115 73.1255
R570 VSS.n120 VSS.n119 73.1255
R571 VSS.n119 VSS.n118 73.1255
R572 VSS.n108 VSS.n107 73.1255
R573 VSS.n109 VSS.n108 73.1255
R574 VSS.n113 VSS.n112 73.1255
R575 VSS.n112 VSS.n111 73.1255
R576 VSS.n101 VSS.n100 73.1255
R577 VSS.n102 VSS.n101 73.1255
R578 VSS.n106 VSS.n105 73.1255
R579 VSS.n105 VSS.n104 73.1255
R580 VSS.n129 VSS.n128 73.1255
R581 VSS.n130 VSS.n129 73.1255
R582 VSS.n134 VSS.n133 73.1255
R583 VSS.n133 VSS.n132 73.1255
R584 VSS.n122 VSS.n121 73.1255
R585 VSS.n123 VSS.n122 73.1255
R586 VSS.n127 VSS.n126 73.1255
R587 VSS.n126 VSS.n125 73.1255
R588 VSS.n164 VSS.n163 73.1255
R589 VSS.n165 VSS.n164 73.1255
R590 VSS.n169 VSS.n168 73.1255
R591 VSS.n168 VSS.n167 73.1255
R592 VSS.n157 VSS.n156 73.1255
R593 VSS.n158 VSS.n157 73.1255
R594 VSS.n162 VSS.n161 73.1255
R595 VSS.n161 VSS.n160 73.1255
R596 VSS.n150 VSS.n149 73.1255
R597 VSS.n151 VSS.n150 73.1255
R598 VSS.n155 VSS.n154 73.1255
R599 VSS.n154 VSS.n153 73.1255
R600 VSS.n143 VSS.n142 73.1255
R601 VSS.n144 VSS.n143 73.1255
R602 VSS.n148 VSS.n147 73.1255
R603 VSS.n147 VSS.n146 73.1255
R604 VSS.n200 VSS.n199 73.1255
R605 VSS.n201 VSS.n200 73.1255
R606 VSS.n205 VSS.n204 73.1255
R607 VSS.n204 VSS.n203 73.1255
R608 VSS.n186 VSS.n185 73.1255
R609 VSS.n187 VSS.n186 73.1255
R610 VSS.n191 VSS.n190 73.1255
R611 VSS.n190 VSS.n189 73.1255
R612 VSS.n179 VSS.n178 73.1255
R613 VSS.n180 VSS.n179 73.1255
R614 VSS.n184 VSS.n183 73.1255
R615 VSS.n183 VSS.n182 73.1255
R616 VSS.n171 VSS.n170 73.1255
R617 VSS.n172 VSS.n171 73.1255
R618 VSS.n176 VSS.n175 73.1255
R619 VSS.n175 VSS.n174 73.1255
R620 VSS.n84 VSS.t25 71.9336
R621 VSS.n91 VSS.t14 53.2577
R622 VSS.n88 VSS.t3 53.1496
R623 VSS.n82 VSS.t5 53.1496
R624 VSS.n78 VSS.t7 53.1496
R625 VSS.n74 VSS.t11 53.1496
R626 VSS.n70 VSS.t18 53.1496
R627 VSS.n92 VSS.n68 50.5605
R628 VSS.n25 VSS.n24 50.5605
R629 VSS.n21 VSS.n20 50.5605
R630 VSS.n13 VSS.n12 50.5605
R631 VSS.n17 VSS.n16 50.5605
R632 VSS.n213 VSS.n1 50.5605
R633 VSS.n9 VSS.n8 50.5605
R634 VSS.n41 VSS.n40 50.5605
R635 VSS.n37 VSS.n36 50.5605
R636 VSS.n33 VSS.n32 50.5605
R637 VSS.n29 VSS.n28 50.5605
R638 VSS.n53 VSS.n52 50.5605
R639 VSS.n45 VSS.n44 50.5605
R640 VSS.n49 VSS.n48 50.5605
R641 VSS.n65 VSS.n64 50.5605
R642 VSS.n61 VSS.n60 50.5605
R643 VSS.n57 VSS.n56 50.5605
R644 VSS.n210 VSS.n206 33.0625
R645 VSS.t22 VSS.n209 27.6986
R646 VSS.n93 VSS.t13 19.0453
R647 VSS VSS.n214 1.34705
R648 VSS.n76 VSS.n75 1.32277
R649 VSS.n77 VSS.n76 1.32277
R650 VSS.n80 VSS.n79 1.32277
R651 VSS.n81 VSS.n80 1.32277
R652 VSS.n86 VSS.n85 1.32277
R653 VSS.n87 VSS.n86 1.32277
R654 VSS.n90 VSS.n89 1.32277
R655 VSS.n91 VSS.n90 1.32277
R656 VSS.n69 VSS.n0 1.20527
R657 VSS.n71 VSS.n70 1.20527
R658 VSS.n73 VSS.n72 1.20527
R659 VSS.n75 VSS.n74 1.20527
R660 VSS.n79 VSS.n78 1.20527
R661 VSS.n83 VSS.n82 1.20527
R662 VSS.n85 VSS.n84 1.20527
R663 VSS.n89 VSS.n88 1.20527
R664 VSS.n214 VSS.n0 0.1086
R665 VSS.n70 VSS.n69 0.1086
R666 VSS.n72 VSS.n71 0.1086
R667 VSS.n74 VSS.n73 0.1086
R668 VSS.n78 VSS.n77 0.1086
R669 VSS.n82 VSS.n81 0.1086
R670 VSS.n84 VSS.n83 0.1086
R671 VSS.n88 VSS.n87 0.1086
R672 net4 net4.t0 54.9635
R673 net4 net4.t1 54.1912
R674 net3 net3.t1 54.6302
R675 net3 net3.t0 53.8579
R676 net2 net2.t0 54.2968
R677 net2 net2.t1 53.5246
R678 EVAL_GND.n1 EVAL_GND.t4 71.642
R679 EVAL_GND.n0 EVAL_GND.t3 57.4685
R680 EVAL_GND.n0 EVAL_GND.t1 53.4829
R681 EVAL_GND EVAL_GND.t2 53.4829
R682 EVAL_GND.n2 EVAL_GND.t0 53.4829
R683 EVAL_GND EVAL_GND.n2 3.9861
R684 EVAL_GND.n2 EVAL_GND.n1 3.82943
R685 EVAL_GND.n1 EVAL_GND.n0 1.47943
R686 net1 net1.t0 53.9635
R687 net1 net1.t1 53.1912
R688 N3 N3.t3 368.192
R689 N3.n1 N3.t2 282.878
R690 N3.n0 N3.t1 233.661
R691 N3.n0 N3.t0 57.1227
R692 N3.n1 N3.n0 2.53693
R693 N3 N3.n1 0.4611
R694 N2 N2.t3 368.526
R695 N2.n1 N2.t2 282.546
R696 N2.n0 N2.t1 233.994
R697 N2.n0 N2.t0 56.7893
R698 N2.n1 N2.n0 2.53693
R699 N2 N2.n1 0.4611
R700 N1 N1.t3 368.86
R701 N1.n1 N1.t2 282.212
R702 N1.n0 N1.t1 234.327
R703 N1.n0 N1.t0 56.456
R704 N1.n1 N1.n0 2.53693
R705 N1 N1.n1 0.4611
R706 N0 N0.t3 369.192
R707 N0.n1 N0.t2 281.878
R708 N0.n0 N0.t1 234.661
R709 N0.n0 N0.t0 56.1227
R710 N0.n1 N0.n0 2.53693
R711 N0 N0.n1 0.4611
R712 A1T.n1 A1T.t3 280.878
R713 A1T A1T.t2 280.878
R714 A1T.n0 A1T.t0 128.346
R715 A1T.n0 A1T.t1 55.1227
R716 A1T.n1 A1T.n0 10.5269
R717 A1T A1T.n1 3.9861
R718 A1B.n0 A1B.t0 345.204
R719 A1B.n2 A1B.t5 289.298
R720 A1B A1B.t2 281.546
R721 A1B.n3 A1B.t3 281.546
R722 A1B.n1 A1B.t4 281.546
R723 A1B.n0 A1B.t1 132.27
R724 A1B A1B.n3 3.9861
R725 A1B.n1 A1B.n0 1.20527
R726 A1B.n3 A1B.n2 0.852767
R727 A1B.n2 A1B.n1 0.4611
R728 A0T.n1 A0T.t3 280.546
R729 A0T A0T.t2 280.546
R730 A0T.n0 A0T.t1 128.679
R731 A0T.n0 A0T.t0 54.7893
R732 A0T A0T.n1 9.31277
R733 A0T.n1 A0T.n0 9.19527
R734 A0B.n0 A0B.t0 345.536
R735 A0B.n2 A0B.t5 289.63
R736 A0B A0B.t2 281.212
R737 A0B.n3 A0B.t3 281.212
R738 A0B.n1 A0B.t4 281.212
R739 A0B.n0 A0B.t1 131.936
R740 A0B A0B.n3 9.31277
R741 A0B.n3 A0B.n2 4.84777
R742 A0B.n1 A0B.n0 1.20527
R743 A0B.n2 A0B.n1 0.4611
C0 N3 VDD 1.2629f
C1 A0B A1 0.1958f
C2 A0 DEC1 0.04478f
C3 A0 DEC3 0.32732f
C4 A1 DEC0 0.05429f
C5 A1 PCLK 1.0325f
C6 N2 VDD 1.21142f
C7 VDD DEC1 0.59688f
C8 VDD DEC3 0.77946f
C9 EVAL_GND DEC2 0.1885f
C10 N0 VDD 1.2397f
C11 A1T DEC2 0.10702f
C12 N1 DEC2 0.13243f
C13 A0T DEC2 0.10685f
C14 A0B DEC0 0.30924f
C15 net1 EVAL_GND 0.17346f
C16 DEC1 A1 0.04517f
C17 DEC3 A1 0.42245f
C18 VDD A1B 1.11281f
C19 A0B PCLK 0.16327f
C20 net4 N3 0.17369f
C21 net1 A1T 0
C22 PCLK DEC0 0.05898f
C23 EVAL_GND net2 0.31901f
C24 net1 A0T 0.02306f
C25 net2 A1T 0
C26 N1 net2 0.17369f
C27 net2 A0T 0.39434f
C28 EVAL_GND A1T 0.11611f
C29 N1 EVAL_GND 0.11826f
C30 net4 DEC3 0
C31 EVAL_GND A0T 0.89022f
C32 A1B A1 0.9844f
C33 N3 PCLK 0.15354f
C34 N2 A0B 0.18185f
C35 A0 DEC2 0.04548f
C36 N1 A1T 0.09462f
C37 A0B DEC1 0.15033f
C38 A1T A0T 4.11088f
C39 DEC3 A0B 0.10157f
C40 N1 A0T 0.11588f
C41 DEC1 DEC0 2.33749f
C42 N2 PCLK 0.24494f
C43 DEC3 DEC0 0.05894f
C44 net3 A0B 0.38406f
C45 VDD DEC2 0.59997f
C46 DEC1 PCLK 0.05975f
C47 DEC3 PCLK 1.57277f
C48 N0 A0B 0.09936f
C49 N3 N2 0.06211f
C50 N0 DEC0 1.03626f
C51 N3 DEC3 1.08818f
C52 N0 PCLK 0.21246f
C53 A0B A1B 2.06714f
C54 A1B DEC0 0.31536f
C55 A1 DEC2 0.04544f
C56 N2 DEC3 0.14861f
C57 A1B PCLK 0.10934f
C58 A0 A0T 0.02845f
C59 DEC3 DEC1 0.0596f
C60 net3 N2 0.17369f
C61 VDD A1T 0.47174f
C62 N1 VDD 1.23958f
C63 VDD A0T 0.47174f
C64 N0 DEC1 0.13235f
C65 N0 DEC3 0.11851f
C66 DEC1 A1B 0.1222f
C67 A0B DEC2 0.18283f
C68 DEC3 A1B 0.10961f
C69 DEC0 DEC2 0.05169f
C70 A1T A1 0.02791f
C71 A0T A1 0.11927f
C72 PCLK DEC2 0.12245f
C73 N0 A1B 1.54925f
C74 net1 A0B 0.34381f
C75 net1 DEC0 0
C76 A0 VDD 0.7249f
C77 net4 EVAL_GND 0.3033f
C78 N3 DEC2 0
C79 A0B net2 0
C80 net4 A1T 0.06772f
C81 EVAL_GND A0B 0.16853f
C82 net4 A0T 0.49435f
C83 N2 DEC2 1.06826f
C84 EVAL_GND DEC0 0.1885f
C85 DEC1 DEC2 3.38598f
C86 A0B A1T 3.39143f
C87 N1 A0B 0.39899f
C88 DEC3 DEC2 4.79167f
C89 EVAL_GND PCLK 0.38039f
C90 A0 A1 0.33346f
C91 A0B A0T 1.31609f
C92 A1T DEC0 0.10674f
C93 N1 DEC0 0
C94 A0T DEC0 0.11645f
C95 net3 DEC2 0
C96 A1T PCLK 0.11163f
C97 N1 PCLK 0.2481f
C98 A0T PCLK 0.11246f
C99 N3 EVAL_GND 0.05836f
C100 N0 DEC2 0.10272f
C101 VDD A1 0.73532f
C102 N3 A1T 0.50782f
C103 DEC1 net2 0
C104 EVAL_GND N2 0.11535f
C105 N3 A0T 0.11411f
C106 A1B DEC2 0.09585f
C107 net1 N0 0.17369f
C108 EVAL_GND DEC1 0.1885f
C109 EVAL_GND DEC3 0.14403f
C110 N2 A1T 0.64602f
C111 N2 A0T 0.11308f
C112 A0 A0B 0.9779f
C113 DEC1 A1T 0.09739f
C114 N1 DEC1 1.05527f
C115 DEC3 A1T 0.07451f
C116 net3 EVAL_GND 0.3087f
C117 A0 DEC0 0.05413f
C118 N1 DEC3 0.11846f
C119 net1 A1B 0.05863f
C120 DEC1 A0T 0.12018f
C121 DEC3 A0T 0.06994f
C122 N0 EVAL_GND 0.05894f
C123 A0 PCLK 0.05182f
C124 net3 A1T 0.06545f
C125 VDD A0B 1.08512f
C126 net3 A0T 0.04606f
C127 net2 A1B 0.06157f
C128 N0 A1T 0.10095f
C129 N1 N0 0.06317f
C130 VDD DEC0 0.5955f
C131 N0 A0T 0.11377f
C132 EVAL_GND A1B 0.05785f
C133 VDD PCLK 8.30541f
C134 A1T A1B 0.90394f
C135 N1 A1B 0.5738f
C136 A1B A0T 0.24267f
C137 DEC3 VSS 8.64854f
C138 DEC2 VSS 7.56665f
C139 DEC1 VSS 5.78101f
C140 DEC0 VSS 4.78794f
C141 PCLK VSS 6.92834f
C142 A1 VSS 2.8838f
C143 A0 VSS 2.18731f
C144 VDD VSS 31.95217f
C145 net4 VSS 2.36295f
C146 net3 VSS 2.27191f
C147 net2 VSS 2.20369f
C148 EVAL_GND VSS 10.44276f
C149 net1 VSS 2.08279f
C150 N3 VSS 5.93635f
C151 N2 VSS 5.71513f
C152 N1 VSS 5.57048f
C153 N0 VSS 5.49617f
C154 A1T VSS 7.54476f
C155 A1B VSS 8.79335f
C156 A0T VSS 10.14581f
C157 A0B VSS 11.39098f
C158 A0B.t1 VSS 0.13891f
C159 A0B.t0 VSS 0.09369f
C160 A0B.n0 VSS 1.97164f
C161 A0B.n1 VSS 1.21307f
C162 A0B.n2 VSS 1.95058f
C163 A0B.n3 VSS 3.37027f
C164 A0T.t0 VSS 0.219f
C165 A0T.t1 VSS 0.18558f
C166 A0T.n0 VSS 2.97869f
C167 A0T.n1 VSS 3.5258f
C168 A1B.t1 VSS 0.14954f
C169 A1B.t0 VSS 0.09484f
C170 A1B.n0 VSS 1.96497f
C171 A1B.n1 VSS 1.25162f
C172 A1B.n2 VSS 1.21614f
C173 A1B.n3 VSS 1.79801f
C174 A1T.t1 VSS 0.2962f
C175 A1T.t0 VSS 0.23499f
C176 A1T.n0 VSS 4.3741f
C177 A1T.n1 VSS 4.07558f
C178 N0.t0 VSS 0.2598f
C179 N0.t1 VSS 0.11803f
C180 N0.n0 VSS 2.07927f
C181 N0.n1 VSS 1.43094f
C182 N1.t0 VSS 0.23639f
C183 N1.t1 VSS 0.10556f
C184 N1.n0 VSS 1.79647f
C185 N1.n1 VSS 1.27334f
C186 N2.t0 VSS 0.23144f
C187 N2.t1 VSS 0.09836f
C188 N2.n0 VSS 1.63982f
C189 N2.n1 VSS 1.19635f
C190 N3.t0 VSS 0.21086f
C191 N3.t1 VSS 0.10162f
C192 N3.n0 VSS 1.41061f
C193 N3.n1 VSS 1.05865f
C194 net1.t0 VSS 0.13335f
C195 net1.t1 VSS 0.12735f
C196 EVAL_GND.t3 VSS 0.16371f
C197 EVAL_GND.t1 VSS 0.11743f
C198 EVAL_GND.n0 VSS 1.22543f
C199 EVAL_GND.t4 VSS 0.11913f
C200 EVAL_GND.n1 VSS 0.65556f
C201 EVAL_GND.t0 VSS 0.12358f
C202 EVAL_GND.n2 VSS 0.87804f
C203 EVAL_GND.t2 VSS 0.11743f
C204 net2.t0 VSS 0.15237f
C205 net2.t1 VSS 0.13923f
C206 net3.t1 VSS 0.15956f
C207 net3.t0 VSS 0.14657f
C208 net4.t0 VSS 0.16464f
C209 net4.t1 VSS 0.14532f
C210 VSS.t23 VSS 0.05481f
C211 VSS.t14 VSS 0.0271f
C212 VSS.t18 VSS 0.038f
C213 VSS.t21 VSS 0.06263f
C214 VSS.t11 VSS 0.03871f
C215 VSS.t7 VSS 0.03716f
C216 VSS.t5 VSS 0.03288f
C217 VSS.t25 VSS 0.06122f
C218 VSS.t3 VSS 0.03075f
C219 VDD.n0 VSS 0.03607f
C220 VDD.n1 VSS 0.04174f
C221 VDD.t8 VSS 0.38472f
C222 VDD.n3 VSS 0.28707f
C223 VDD.n4 VSS 0.04294f
C224 VDD.n5 VSS 0.04294f
C225 VDD.n7 VSS 0.28707f
C226 VDD.n8 VSS 0.04294f
C227 VDD.n9 VSS 0.02812f
C228 VDD.n10 VSS 0.04621f
C229 VDD.t9 VSS 0.10859f
C230 VDD.n11 VSS 0.64447f
C231 VDD.n12 VSS 0.0243f
C232 VDD.n13 VSS 0.03009f
C233 VDD.t22 VSS 0.26213f
C234 VDD.n15 VSS 0.18917f
C235 VDD.n16 VSS 0.03081f
C236 VDD.n17 VSS 0.03081f
C237 VDD.n19 VSS 0.18917f
C238 VDD.n20 VSS 0.03081f
C239 VDD.n21 VSS 0.02206f
C240 VDD.n22 VSS 0.03885f
C241 VDD.n23 VSS 0.38054f
C242 VDD.t23 VSS 0.08027f
C243 VDD.n24 VSS 0.27284f
C244 VDD.n25 VSS 0.03607f
C245 VDD.n26 VSS 0.04174f
C246 VDD.t0 VSS 0.38472f
C247 VDD.n28 VSS 0.28707f
C248 VDD.n29 VSS 0.04294f
C249 VDD.n30 VSS 0.04294f
C250 VDD.n32 VSS 0.28707f
C251 VDD.n33 VSS 0.04294f
C252 VDD.n34 VSS 0.02812f
C253 VDD.n35 VSS 0.04587f
C254 VDD.n36 VSS 0.29855f
C255 VDD.t1 VSS 0.11318f
C256 VDD.n37 VSS 0.42059f
C257 VDD.n38 VSS 0.0243f
C258 VDD.n39 VSS 0.03009f
C259 VDD.t16 VSS 0.26213f
C260 VDD.n41 VSS 0.18917f
C261 VDD.n42 VSS 0.03081f
C262 VDD.n43 VSS 0.03081f
C263 VDD.n45 VSS 0.18917f
C264 VDD.n46 VSS 0.03081f
C265 VDD.n47 VSS 0.02206f
C266 VDD.n48 VSS 0.03885f
C267 VDD.n49 VSS 0.38054f
C268 VDD.t17 VSS 0.06731f
C269 VDD.n50 VSS 0.37474f
C270 VDD.n51 VSS 0.03607f
C271 VDD.n52 VSS 0.04174f
C272 VDD.t2 VSS 0.38472f
C273 VDD.n54 VSS 0.28707f
C274 VDD.n55 VSS 0.04294f
C275 VDD.n56 VSS 0.04294f
C276 VDD.n58 VSS 0.28707f
C277 VDD.n59 VSS 0.04294f
C278 VDD.n60 VSS 0.02812f
C279 VDD.n61 VSS 0.04587f
C280 VDD.n62 VSS 0.40045f
C281 VDD.t3 VSS 0.11652f
C282 VDD.n63 VSS 0.42059f
C283 VDD.n64 VSS 0.0243f
C284 VDD.n65 VSS 0.03009f
C285 VDD.t18 VSS 0.26213f
C286 VDD.n67 VSS 0.18917f
C287 VDD.n68 VSS 0.03081f
C288 VDD.n69 VSS 0.03081f
C289 VDD.n71 VSS 0.18917f
C290 VDD.n72 VSS 0.03081f
C291 VDD.n73 VSS 0.02206f
C292 VDD.n74 VSS 0.03885f
C293 VDD.n75 VSS 0.38054f
C294 VDD.t19 VSS 0.06731f
C295 VDD.n76 VSS 0.27284f
C296 VDD.n77 VSS 0.03607f
C297 VDD.n78 VSS 0.04174f
C298 VDD.t4 VSS 0.38472f
C299 VDD.n80 VSS 0.28707f
C300 VDD.n81 VSS 0.04294f
C301 VDD.n82 VSS 0.04294f
C302 VDD.n84 VSS 0.28707f
C303 VDD.n85 VSS 0.04294f
C304 VDD.n86 VSS 0.02812f
C305 VDD.n87 VSS 0.04587f
C306 VDD.n88 VSS 0.29855f
C307 VDD.t5 VSS 0.12236f
C308 VDD.n89 VSS 0.42059f
C309 VDD.n90 VSS 0.0243f
C310 VDD.n91 VSS 0.03009f
C311 VDD.t20 VSS 0.26213f
C312 VDD.n93 VSS 0.18917f
C313 VDD.n94 VSS 0.03081f
C314 VDD.n95 VSS 0.03081f
C315 VDD.n97 VSS 0.18917f
C316 VDD.n98 VSS 0.03081f
C317 VDD.n99 VSS 0.02206f
C318 VDD.n100 VSS 0.03885f
C319 VDD.n101 VSS 0.38054f
C320 VDD.t21 VSS 0.06731f
C321 VDD.n102 VSS 0.27284f
C322 VDD.n103 VSS 0.02933f
C323 VDD.n104 VSS 0.03506f
C324 VDD.t6 VSS 0.31508f
C325 VDD.n106 VSS 0.2309f
C326 VDD.n107 VSS 0.03603f
C327 VDD.n108 VSS 0.03603f
C328 VDD.n110 VSS 0.2309f
C329 VDD.n111 VSS 0.03603f
C330 VDD.n112 VSS 0.02467f
C331 VDD.n113 VSS 0.04185f
C332 VDD.n114 VSS 0.28718f
C333 VDD.t7 VSS 0.09294f
C334 VDD.n115 VSS 0.29241f
C335 VDD.n116 VSS 0.02156f
C336 VDD.n117 VSS 0.0274f
C337 VDD.t12 VSS 0.23285f
C338 VDD.n119 VSS 0.16655f
C339 VDD.n120 VSS 0.02794f
C340 VDD.n121 VSS 0.02794f
C341 VDD.n123 VSS 0.16655f
C342 VDD.n124 VSS 0.02794f
C343 VDD.n125 VSS 0.02062f
C344 VDD.n126 VSS 0.03721f
C345 VDD.n127 VSS 0.27397f
C346 VDD.t13 VSS 0.05659f
C347 VDD.n128 VSS 0.26104f
C348 VDD.n129 VSS 0.02933f
C349 VDD.n130 VSS 0.03506f
C350 VDD.t10 VSS 0.31508f
C351 VDD.n132 VSS 0.2309f
C352 VDD.n133 VSS 0.03603f
C353 VDD.n134 VSS 0.03603f
C354 VDD.n136 VSS 0.2309f
C355 VDD.n137 VSS 0.03603f
C356 VDD.n138 VSS 0.02467f
C357 VDD.n139 VSS 0.04185f
C358 VDD.n140 VSS 0.28718f
C359 VDD.t11 VSS 0.09386f
C360 VDD.n141 VSS 0.29241f
C361 VDD.n142 VSS 0.02156f
C362 VDD.n143 VSS 0.0274f
C363 VDD.t14 VSS 0.23285f
C364 VDD.n145 VSS 0.16655f
C365 VDD.n146 VSS 0.02794f
C366 VDD.n147 VSS 0.02794f
C367 VDD.n149 VSS 0.16655f
C368 VDD.n150 VSS 0.02794f
C369 VDD.n151 VSS 0.02062f
C370 VDD.n152 VSS 0.03721f
C371 VDD.n153 VSS 0.27397f
C372 VDD.t15 VSS 0.05404f
C373 VDD.n154 VSS 0.25449f
C374 A0.n0 VSS 2.30535f
C375 A1.n0 VSS 3.11863f
C376 PCLK.n0 VSS 3.30832f
C377 PCLK.n1 VSS 2.8481f
C378 PCLK.n2 VSS 2.20885f
C379 PCLK.n3 VSS 2.78908f
C380 DEC0.t0 VSS 0.25734f
C381 DEC0.t1 VSS 0.30367f
C382 DEC0.n0 VSS 3.32679f
C383 DEC1.t0 VSS 0.30187f
C384 DEC1.t1 VSS 0.37791f
C385 DEC1.n0 VSS 5.05319f
C386 DEC2.t0 VSS 0.30037f
C387 DEC2.t1 VSS 0.39569f
C388 DEC2.n0 VSS 6.38595f
C389 DEC3.t0 VSS 0.23196f
C390 DEC3.t1 VSS 0.3196f
C391 DEC3.n0 VSS 5.66699f
.ends row_decoder

* expanding   symbol:  wl_driver.sym # of pins=4
** sym_path: /work/cells/wordline_driver/wl_driver.sym
** sch_path: /work/cells/wordline_driver/wl_driver.sch
.subckt wl_driver VDD WL_IN WL VSS
*.iopin VDD
*.iopin VSS
*.iopin WL_IN
*.iopin WL
XMP1 WL_N WL_IN VDD VDD sky130_fd_pr__pfet_01v8 L=0.15 W=0.42 nf=1 ad='int((nf+1)/2) * W/nf * 0.29' as='int((nf+2)/2) * W/nf * 0.29'
+ pd='2*int((nf+1)/2) * (W/nf + 0.29)' ps='2*int((nf+2)/2) * (W/nf + 0.29)' nrd='0.29 / W' nrs='0.29 / W' sa=0 sb=0 sd=0 mult=1 m=1
XMN1 WL_N WL_IN VSS VSS sky130_fd_pr__nfet_01v8 L=0.15 W=0.42 nf=1 ad='int((nf+1)/2) * W/nf * 0.29' as='int((nf+2)/2) * W/nf * 0.29'
+ pd='2*int((nf+1)/2) * (W/nf + 0.29)' ps='2*int((nf+2)/2) * (W/nf + 0.29)' nrd='0.29 / W' nrs='0.29 / W' sa=0 sb=0 sd=0 mult=1 m=1
XMP2 WL WL_N VDD VDD sky130_fd_pr__pfet_01v8 L=0.15 W=0.84 nf=1 ad='int((nf+1)/2) * W/nf * 0.29' as='int((nf+2)/2) * W/nf * 0.29' pd='2*int((nf+1)/2) * (W/nf + 0.29)'
+ ps='2*int((nf+2)/2) * (W/nf + 0.29)' nrd='0.29 / W' nrs='0.29 / W' sa=0 sb=0 sd=0 mult=1 m=1
XMN2 WL WL_N VSS VSS sky130_fd_pr__nfet_01v8 L=0.15 W=0.84 nf=1 ad='int((nf+1)/2) * W/nf * 0.29' as='int((nf+2)/2) * W/nf * 0.29' pd='2*int((nf+1)/2) * (W/nf + 0.29)'
+ ps='2*int((nf+2)/2) * (W/nf + 0.29)' nrd='0.29 / W' nrs='0.29 / W' sa=0 sb=0 sd=0 mult=1 m=1
.ends

.GLOBAL GND

.lib "/opt/pdks/sky130A/libs.tech/combined/continuous/sky130.lib.spice" ss
.temp -40
.options method=gear
.save v(dec0) v(dec1) v(dec2) v(dec3) v(net1) v(net2) v(net5) v(net6) v(net7) v(net8) v(x1.a0.t0) v(x1.a0.t1) v(x1.a0b.t0) v(x1.a0b.t1) v(x1.a0b.t2) v(x1.a0b.t3) v(x1.a0b.t4) v(x1.a0b.t5) v(x1.a0t.t0) v(x1.a0t.t1) v(x1.a0t.t2) v(x1.a0t.t3) v(x1.a1.t0) v(x1.a1.t1) v(x1.a1b.t0) v(x1.a1b.t1) v(x1.a1b.t2) v(x1.a1b.t3) v(x1.a1b.t4) v(x1.a1b.t5) v(x1.a1t.t0) v(x1.a1t.t1) v(x1.a1t.t2) v(x1.a1t.t3) v(x1.dec0.t0) v(x1.dec0.t1) v(x1.dec1.t0) v(x1.dec1.t1) v(x1.dec2.t0) v(x1.dec2.t1) v(x1.dec3.t0) v(x1.dec3.t1) v(x1.eval_gnd.t0) v(x1.eval_gnd.t1) v(x1.eval_gnd.t2) v(x1.eval_gnd.t3) v(x1.eval_gnd.t4) v(x1.n0.t0) v(x1.n0.t1) v(x1.n0.t2) v(x1.n0.t3) v(x1.n1.t0) v(x1.n1.t1) v(x1.n1.t2) v(x1.n1.t3) v(x1.n2.t0) v(x1.n2.t1) v(x1.n2.t2) v(x1.n2.t3) v(x1.n3.t0) v(x1.n3.t1) v(x1.n3.t2) v(x1.n3.t3) v(x1.net1.t0) v(x1.net1.t1) v(x1.net2.t0) v(x1.net2.t1) v(x1.net3.t0) v(x1.net3.t1) v(x1.net4.t0) v(x1.net4.t1) v(x1.pclk.t0) v(x1.pclk.t1) v(x1.pclk.t2) v(x1.pclk.t3) v(x1.pclk.t4) v(x1.vdd.t0) v(x1.vdd.t1) v(x1.vdd.t10) v(x1.vdd.t11) v(x1.vdd.t12) v(x1.vdd.t13) v(x1.vdd.t14) v(x1.vdd.t15) v(x1.vdd.t16) v(x1.vdd.t17) v(x1.vdd.t18) v(x1.vdd.t19) v(x1.vdd.t2) v(x1.vdd.t20) v(x1.vdd.t21) v(x1.vdd.t22) v(x1.vdd.t23) v(x1.vdd.t3) v(x1.vdd.t4) v(x1.vdd.t5) v(x1.vdd.t6) v(x1.vdd.t7) v(x1.vdd.t8) v(x1.vdd.t9) v(x1.vss.t0) v(x1.vss.t1) v(x1.vss.t10) v(x1.vss.t11) v(x1.vss.t12) v(x1.vss.t13) v(x1.vss.t14) v(x1.vss.t15) v(x1.vss.t16) v(x1.vss.t17) v(x1.vss.t18) v(x1.vss.t19) v(x1.vss.t2) v(x1.vss.t20) v(x1.vss.t21) v(x1.vss.t22) v(x1.vss.t23) v(x1.vss.t24) v(x1.vss.t25) v(x1.vss.t3) v(x1.vss.t4) v(x1.vss.t5) v(x1.vss.t6) v(x1.vss.t7) v(x1.vss.t8) v(x1.vss.t9) v(x2.wl_n) v(x3.wl_n) v(x4.wl_n) v(x5.wl_n) i(VDD_SRC) i(VPCLK) i(VA0) i(VA1) v(dec0) v(dec1) v(dec2) v(dec3) v(net1) v(net2) v(net3) v(net4) v(x1.n0) v(x1.n0.n0) v(x1.n0.n1) v(x1.n0.t0) v(x1.n0.t1) v(x1.n0.t2) v(x1.n0.t3) v(x1.n1) v(x1.n1.n0) v(x1.n1.n1) v(x1.n1.t0) v(x1.n1.t1) v(x1.n1.t2) v(x1.n1.t3) v(x1.n2) v(x1.n2.n0) v(x1.n2.n1) v(x1.n2.t0) v(x1.n2.t1) v(x1.n2.t2) v(x1.n2.t3) v(x1.n3) v(x1.n3.n0) v(x1.n3.n1) v(x1.n3.t0) v(x1.n3.t1) v(x1.n3.t2) v(x1.n3.t3)
.tran 5p 3e-08 0 5e-12 uic
.control
set num_threads=1
run
write waveform.raw
quit 0
.endc
.end
