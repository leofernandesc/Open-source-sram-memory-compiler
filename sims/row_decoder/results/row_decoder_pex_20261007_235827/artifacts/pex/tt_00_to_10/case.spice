** sch_path: /work/sims/row_decoder/tb_row_decoder_sizing.sch
**.subckt tb_row_decoder_sizing
x1 net1 net2 net3 net4 DEC0 DEC1 DEC3 DEC2 GND row_decoder
VDD_SRC net1 GND 1.8
VPCLK net2 GND PWL(0 0 4.975e-09 0 5.025e-09 1.8 9.975e-09 1.8 1.0025e-08 0 1.9975e-08 0 2.0025e-08 1.8 2.4975e-08 1.8 2.5025e-08 0 3e-08 0)
VA0 net3 GND PWL(0 0 3e-08 0)
VA1 net4 GND PWL(0 0 1.795e-08 0 1.8e-08 1.8 3e-08 1.8)
x2 net1 DEC0 net5 GND wl_driver
x3 net1 DEC1 net6 GND wl_driver
x4 net1 DEC3 net8 GND wl_driver
x5 net1 DEC2 net7 GND wl_driver
C_WL0 net5 GND 1.74e-14 m=1
C_WL1 net6 GND 1.74e-14 m=1
C_WL2 net7 GND 1.74e-14 m=1
C_WL3 net8 GND 1.74e-14 m=1
**.ends

* expanding   symbol:  row_decoder.sym # of pins=9
** sym_path: /work/cells/row_decoder/row_decoder.sym
** sch_path: /work/cells/row_decoder/row_decoder.sch
.subckt row_decoder VDD PCLK A0 A1 DEC0 DEC1 DEC3 DEC2 VSS
X0 VDD PCLK N2 VDD sky130_fd_pr__pfet_01v8 ad=0.29 pd=2.58 as=0.29 ps=2.58 w=1 l=0.15
X1 VSS.t5 N2 DEC2 VSS.t4 sky130_fd_pr__nfet_01v8 ad=0.58 pd=4.58 as=0.58 ps=4.58 w=2 l=0.15
X2 VSS.t19 A1B A1T VSS.t18 sky130_fd_pr__nfet_01v8 ad=0.58 pd=4.58 as=0.58 ps=4.58 w=2 l=0.15
X3 VDD N2 DEC2 VDD sky130_fd_pr__pfet_01v8 ad=0.58 pd=4.58 as=0.58 ps=4.58 w=2 l=0.15
X4 VSS.t15 A1 A1B VSS.t14 sky130_fd_pr__nfet_01v8 ad=0.1218 pd=1.42 as=0.1218 ps=1.42 w=0.42 l=0.15
X5 EVAL_GND A0T net4 VSS.t1 sky130_fd_pr__nfet_01v8 ad=0.29 pd=2.58 as=0.29 ps=2.58 w=1 l=0.15
X6 VSS.t13 A0B A0T VSS.t12 sky130_fd_pr__nfet_01v8 ad=0.58 pd=4.58 as=0.58 ps=4.58 w=2 l=0.15
X7 VDD N3 DEC3 VDD sky130_fd_pr__pfet_01v8 ad=0.58 pd=4.58 as=0.58 ps=4.58 w=2 l=0.15
X8 VSS.t23 A0 A0B VSS.t22 sky130_fd_pr__nfet_01v8 ad=0.1218 pd=1.42 as=0.1218 ps=1.42 w=0.42 l=0.15
X9 net2 A1B N1 VSS.t17 sky130_fd_pr__nfet_01v8 ad=0.29 pd=2.58 as=0.29 ps=2.58 w=1 l=0.15
X10 net1 A1B N0 VSS.t16 sky130_fd_pr__nfet_01v8 ad=0.29 pd=2.58 as=0.29 ps=2.58 w=1 l=0.15
X11 VDD PCLK N3 VDD sky130_fd_pr__pfet_01v8 ad=0.29 pd=2.58 as=0.29 ps=2.58 w=1 l=0.15
X12 EVAL_GND A0B net3 VSS.t11 sky130_fd_pr__nfet_01v8 ad=0.29 pd=2.58 as=0.29 ps=2.58 w=1 l=0.15
X13 VDD A1 A1B VDD sky130_fd_pr__pfet_01v8 ad=0.1218 pd=1.42 as=0.1218 ps=1.42 w=0.42 l=0.15
X14 VDD A1B A1T VDD sky130_fd_pr__pfet_01v8 ad=0.58 pd=4.58 as=0.58 ps=4.58 w=2 l=0.15
X15 VSS.t25 PCLK EVAL_GND VSS.t24 sky130_fd_pr__nfet_01v8 ad=0.435 pd=3.58 as=0.435 ps=3.58 w=1.5 l=0.15
X16 VDD N0 DEC0 VDD sky130_fd_pr__pfet_01v8 ad=0.58 pd=4.58 as=0.58 ps=4.58 w=2 l=0.15
X17 VDD N1 DEC1 VDD sky130_fd_pr__pfet_01v8 ad=0.58 pd=4.58 as=0.58 ps=4.58 w=2 l=0.15
X18 EVAL_GND A0T net2 VSS.t0 sky130_fd_pr__nfet_01v8 ad=0.29 pd=2.58 as=0.29 ps=2.58 w=1 l=0.15
X19 VSS.t9 N1 DEC1 VSS.t8 sky130_fd_pr__nfet_01v8 ad=0.58 pd=4.58 as=0.58 ps=4.58 w=2 l=0.15
X20 net4 A1T N3 VSS.t21 sky130_fd_pr__nfet_01v8 ad=0.29 pd=2.58 as=0.29 ps=2.58 w=1 l=0.15
X21 VDD A0 A0B VDD sky130_fd_pr__pfet_01v8 ad=0.1218 pd=1.42 as=0.1218 ps=1.42 w=0.42 l=0.15
X22 VSS.t3 N3 DEC3 VSS.t2 sky130_fd_pr__nfet_01v8 ad=0.58 pd=4.58 as=0.58 ps=4.58 w=2 l=0.15
X23 EVAL_GND A0B net1 VSS.t10 sky130_fd_pr__nfet_01v8 ad=0.29 pd=2.58 as=0.29 ps=2.58 w=1 l=0.15
X24 VDD A0B A0T VDD sky130_fd_pr__pfet_01v8 ad=0.58 pd=4.58 as=0.58 ps=4.58 w=2 l=0.15
X25 net3 A1T N2 VSS.t20 sky130_fd_pr__nfet_01v8 ad=0.29 pd=2.58 as=0.29 ps=2.58 w=1 l=0.15
X26 VSS.t7 N0 DEC0 VSS.t6 sky130_fd_pr__nfet_01v8 ad=0.58 pd=4.58 as=0.58 ps=4.58 w=2 l=0.15
X27 VDD PCLK N0 VDD sky130_fd_pr__pfet_01v8 ad=0.29 pd=2.58 as=0.29 ps=2.58 w=1 l=0.15
X28 VDD PCLK N1 VDD sky130_fd_pr__pfet_01v8 ad=0.29 pd=2.58 as=0.29 ps=2.58 w=1 l=0.15
R0 VSS.n198 VSS.t14 164450
R1 VSS.n102 VSS.t4 100089
R2 VSS.n37 VSS.t8 100089
R3 VSS.t6 VSS.n9 100089
R4 VSS.n103 VSS.n102 66688.4
R5 VSS.n125 VSS.n37 66688.4
R6 VSS.n147 VSS.n9 66688.4
R7 VSS.t22 VSS.n198 64912.9
R8 VSS.n37 VSS.n9 3325.61
R9 VSS.n102 VSS.n37 3325.61
R10 VSS.t10 VSS.n9 2980.71
R11 VSS.n74 VSS.n51 2959.06
R12 VSS.n75 VSS.n71 2959.06
R13 VSS.n100 VSS.n54 2928.58
R14 VSS.n198 VSS.t10 2921.92
R15 VSS.n118 VSS.n117 2898.1
R16 VSS.n140 VSS.n139 2898.1
R17 VSS.n111 VSS.n110 2886.73
R18 VSS.n133 VSS.n132 2886.73
R19 VSS.n155 VSS.n154 2886.73
R20 VSS.n70 VSS.n62 2885.47
R21 VSS.n66 VSS.n62 2885.47
R22 VSS.n70 VSS.n61 2885.47
R23 VSS.n160 VSS.n20 2885.47
R24 VSS.n156 VSS.n20 2885.47
R25 VSS.n160 VSS.n19 2885.47
R26 VSS.n156 VSS.n19 2885.47
R27 VSS.n138 VSS.n31 2885.47
R28 VSS.n134 VSS.n31 2885.47
R29 VSS.n138 VSS.n30 2885.47
R30 VSS.n134 VSS.n30 2885.47
R31 VSS.n116 VSS.n43 2885.47
R32 VSS.n112 VSS.n43 2885.47
R33 VSS.n116 VSS.n42 2885.47
R34 VSS.n112 VSS.n42 2885.47
R35 VSS.n73 VSS.n59 2885.47
R36 VSS.n76 VSS.n59 2885.47
R37 VSS.n73 VSS.n58 2885.47
R38 VSS.n76 VSS.n58 2885.47
R39 VSS.n99 VSS.n53 2885.47
R40 VSS.n95 VSS.n53 2885.47
R41 VSS.n99 VSS.n52 2885.47
R42 VSS.n95 VSS.n52 2885.47
R43 VSS.n60 VSS.n50 2876.78
R44 VSS.n201 VSS.n8 2846.37
R45 VSS.n165 VSS.n161 2733.99
R46 VSS.n185 VSS.n184 2705.61
R47 VSS.n163 VSS.n18 2595.76
R48 VSS.n166 VSS.n18 2595.76
R49 VSS.n163 VSS.n17 2595.76
R50 VSS.n166 VSS.n17 2595.76
R51 VSS.n102 VSS.n101 2327.93
R52 VSS.n196 VSS.n12 2306.06
R53 VSS.n192 VSS.n12 2306.06
R54 VSS.n196 VSS.n11 2306.06
R55 VSS.n192 VSS.n11 2306.06
R56 VSS.n186 VSS.n174 2306.06
R57 VSS.n187 VSS.n186 2306.06
R58 VSS.n174 VSS.n172 2306.06
R59 VSS.n187 VSS.n172 2306.06
R60 VSS.n145 VSS.n27 2306.06
R61 VSS.n141 VSS.n27 2306.06
R62 VSS.n145 VSS.n26 2306.06
R63 VSS.n141 VSS.n26 2306.06
R64 VSS.n153 VSS.n23 2306.06
R65 VSS.n149 VSS.n23 2306.06
R66 VSS.n153 VSS.n22 2306.06
R67 VSS.n149 VSS.n22 2306.06
R68 VSS.n123 VSS.n39 2306.06
R69 VSS.n119 VSS.n39 2306.06
R70 VSS.n123 VSS.n38 2306.06
R71 VSS.n119 VSS.n38 2306.06
R72 VSS.n131 VSS.n34 2306.06
R73 VSS.n127 VSS.n34 2306.06
R74 VSS.n131 VSS.n33 2306.06
R75 VSS.n127 VSS.n33 2306.06
R76 VSS.n89 VSS.n88 2306.06
R77 VSS.n90 VSS.n89 2306.06
R78 VSS.n88 VSS.n86 2306.06
R79 VSS.n90 VSS.n86 2306.06
R80 VSS.n109 VSS.n46 2306.06
R81 VSS.n105 VSS.n46 2306.06
R82 VSS.n109 VSS.n45 2306.06
R83 VSS.n105 VSS.n45 2306.06
R84 VSS.n179 VSS.n176 1970
R85 VSS.n183 VSS.n176 1970
R86 VSS.n179 VSS.n175 1970
R87 VSS.n183 VSS.n175 1970
R88 VSS.n200 VSS.n0 1970
R89 VSS.n202 VSS.n0 1970
R90 VSS.n200 VSS.n1 239.255
R91 VSS.n202 VSS.n7 1970
R92 VSS.n101 VSS.t2 1430.26
R93 VSS.t12 VSS.n50 1430.26
R94 VSS.n101 VSS.n50 1330.24
R95 VSS.n197 VSS.n13 1101.63
R96 VSS.n164 VSS.n10 1101.63
R97 VSS.n104 VSS.n103 636.716
R98 VSS.n103 VSS.n49 636.716
R99 VSS.n126 VSS.n125 636.716
R100 VSS.n125 VSS.n124 636.716
R101 VSS.n148 VSS.n147 636.716
R102 VSS.n147 VSS.n146 636.716
R103 VSS.t22 VSS.n1 35.5247
R104 VSS.n63 VSS.n61 292.5
R105 VSS.t18 VSS.n62 292.5
R106 VSS.n68 VSS.n62 292.5
R107 VSS.t2 VSS.n52 292.5
R108 VSS.n55 VSS.n52 292.5
R109 VSS.t2 VSS.n53 292.5
R110 VSS.n97 VSS.n53 292.5
R111 VSS.t12 VSS.n58 292.5
R112 VSS.n58 VSS.n56 292.5
R113 VSS.t12 VSS.n59 292.5
R114 VSS.n59 VSS.n57 292.5
R115 VSS.n42 VSS.t4 292.5
R116 VSS.n44 VSS.n42 292.5
R117 VSS.n43 VSS.t4 292.5
R118 VSS.n114 VSS.n43 292.5
R119 VSS.n45 VSS.t21 292.5
R120 VSS.n47 VSS.n45 292.5
R121 VSS.n46 VSS.t21 292.5
R122 VSS.n107 VSS.n46 292.5
R123 VSS.t1 VSS.n86 292.5
R124 VSS.n86 VSS.n84 292.5
R125 VSS.n89 VSS.t1 292.5
R126 VSS.n89 VSS.n85 292.5
R127 VSS.n30 VSS.t8 292.5
R128 VSS.n32 VSS.n30 292.5
R129 VSS.n31 VSS.t8 292.5
R130 VSS.n136 VSS.n31 292.5
R131 VSS.n33 VSS.t20 292.5
R132 VSS.n35 VSS.n33 292.5
R133 VSS.n34 VSS.t20 292.5
R134 VSS.n129 VSS.n34 292.5
R135 VSS.n38 VSS.t11 292.5
R136 VSS.n40 VSS.n38 292.5
R137 VSS.n39 VSS.t11 292.5
R138 VSS.n121 VSS.n39 292.5
R139 VSS.n19 VSS.t6 292.5
R140 VSS.n21 VSS.n19 292.5
R141 VSS.n20 VSS.t6 292.5
R142 VSS.n158 VSS.n20 292.5
R143 VSS.n22 VSS.t17 292.5
R144 VSS.n24 VSS.n22 292.5
R145 VSS.n23 VSS.t17 292.5
R146 VSS.n151 VSS.n23 292.5
R147 VSS.n26 VSS.t0 292.5
R148 VSS.n28 VSS.n26 292.5
R149 VSS.n27 VSS.t0 292.5
R150 VSS.n143 VSS.n27 292.5
R151 VSS.t24 VSS.n17 292.5
R152 VSS.n17 VSS.n15 292.5
R153 VSS.t24 VSS.n18 292.5
R154 VSS.n18 VSS.n16 292.5
R155 VSS.t16 VSS.n172 292.5
R156 VSS.n172 VSS.n170 292.5
R157 VSS.n186 VSS.t16 292.5
R158 VSS.n186 VSS.n171 292.5
R159 VSS.t10 VSS.n11 292.5
R160 VSS.n14 VSS.n11 292.5
R161 VSS.t10 VSS.n12 292.5
R162 VSS.n194 VSS.n12 292.5
R163 VSS.n1 VSS.n7 223.755
R164 VSS.n7 VSS.n5 292.5
R165 VSS.t22 VSS.n0 292.5
R166 VSS.n0 VSS.n6 292.5
R167 VSS.n175 VSS.t14 292.5
R168 VSS.n178 VSS.n175 292.5
R169 VSS.n176 VSS.t14 292.5
R170 VSS.n181 VSS.n176 292.5
R171 VSS.n65 VSS.n61 246.404
R172 VSS.n66 VSS.n65 208.341
R173 VSS.n68 VSS.n67 187.482
R174 VSS.n69 VSS.n68 187.482
R175 VSS.n159 VSS.n158 187.482
R176 VSS.n158 VSS.n157 187.482
R177 VSS.n137 VSS.n136 187.482
R178 VSS.n136 VSS.n135 187.482
R179 VSS.n115 VSS.n114 187.482
R180 VSS.n114 VSS.n113 187.482
R181 VSS.n72 VSS.n57 187.482
R182 VSS.n77 VSS.n57 187.482
R183 VSS.n98 VSS.n97 187.482
R184 VSS.n97 VSS.n96 187.482
R185 VSS.n69 VSS.n63 186.353
R186 VSS.n159 VSS.n21 186.353
R187 VSS.n137 VSS.n32 186.353
R188 VSS.n115 VSS.n44 186.353
R189 VSS.n72 VSS.n56 186.353
R190 VSS.n98 VSS.n55 186.353
R191 VSS.t2 VSS.n100 174.192
R192 VSS.t2 VSS.n51 174.192
R193 VSS.t12 VSS.n74 174.192
R194 VSS.n75 VSS.t12 174.192
R195 VSS.n117 VSS.t4 169.935
R196 VSS.n111 VSS.t4 169.935
R197 VSS.n110 VSS.t21 169.935
R198 VSS.n104 VSS.t21 169.935
R199 VSS.t1 VSS.n49 169.935
R200 VSS.t1 VSS.n54 169.935
R201 VSS.n139 VSS.t8 169.935
R202 VSS.n133 VSS.t8 169.935
R203 VSS.n132 VSS.t20 169.935
R204 VSS.n126 VSS.t20 169.935
R205 VSS.n124 VSS.t11 169.935
R206 VSS.n118 VSS.t11 169.935
R207 VSS.n161 VSS.t6 169.935
R208 VSS.n155 VSS.t6 169.935
R209 VSS.n154 VSS.t17 169.935
R210 VSS.n148 VSS.t17 169.935
R211 VSS.n146 VSS.t0 169.935
R212 VSS.n140 VSS.t0 169.935
R213 VSS.n162 VSS.n16 168.66
R214 VSS.n167 VSS.n16 168.66
R215 VSS.n201 VSS.t22 168.441
R216 VSS.t14 VSS.n8 167.559
R217 VSS.n184 VSS.t14 167.559
R218 VSS.n162 VSS.n15 167.53
R219 VSS.t18 VSS.n60 159.861
R220 VSS.n195 VSS.n194 149.835
R221 VSS.n194 VSS.n193 149.835
R222 VSS.n173 VSS.n171 149.835
R223 VSS.n188 VSS.n171 149.835
R224 VSS.n144 VSS.n143 149.835
R225 VSS.n143 VSS.n142 149.835
R226 VSS.n152 VSS.n151 149.835
R227 VSS.n151 VSS.n150 149.835
R228 VSS.n122 VSS.n121 149.835
R229 VSS.n121 VSS.n120 149.835
R230 VSS.n130 VSS.n129 149.835
R231 VSS.n129 VSS.n128 149.835
R232 VSS.n87 VSS.n85 149.835
R233 VSS.n91 VSS.n85 149.835
R234 VSS.n108 VSS.n107 149.835
R235 VSS.n107 VSS.n106 149.835
R236 VSS.n195 VSS.n14 148.707
R237 VSS.n173 VSS.n170 148.707
R238 VSS.n144 VSS.n28 148.707
R239 VSS.n152 VSS.n24 148.707
R240 VSS.n122 VSS.n40 148.707
R241 VSS.n130 VSS.n35 148.707
R242 VSS.n87 VSS.n84 148.707
R243 VSS.n108 VSS.n47 148.707
R244 VSS.t16 VSS.n185 147.008
R245 VSS.t16 VSS.n13 147.008
R246 VSS.t10 VSS.n197 147.008
R247 VSS.t10 VSS.n10 147.008
R248 VSS.t24 VSS.n164 147.008
R249 VSS.n165 VSS.t24 147.008
R250 VSS.n202 VSS.n201 146.25
R251 VSS.n203 VSS.n202 146.25
R252 VSS.n200 VSS.n199 146.25
R253 VSS.n184 VSS.n183 146.25
R254 VSS.n183 VSS.n182 146.25
R255 VSS.n179 VSS.n8 146.25
R256 VSS.n180 VSS.n179 146.25
R257 VSS.n177 VSS.t15 140.359
R258 VSS.t23 VSS.n204 140.359
R259 VSS.n191 VSS.n169 140.239
R260 VSS.n190 VSS.n189 140.239
R261 VSS.n80 VSS.n29 140.239
R262 VSS.n79 VSS.n25 140.239
R263 VSS.n82 VSS.n41 140.239
R264 VSS.n81 VSS.n36 140.239
R265 VSS.n93 VSS.n92 140.239
R266 VSS.n83 VSS.n48 140.239
R267 VSS.n64 VSS.t19 140.225
R268 VSS.t25 VSS.n168 140.135
R269 VSS.t7 VSS.n2 140.03
R270 VSS.t9 VSS.n3 140.03
R271 VSS.t5 VSS.n4 140.03
R272 VSS.t13 VSS.n78 140.03
R273 VSS.n94 VSS.t3 140.03
R274 VSS.n181 VSS.n180 128
R275 VSS.n182 VSS.n181 128
R276 VSS.n199 VSS.n6 128
R277 VSS.n203 VSS.n6 128
R278 VSS.n180 VSS.n178 126.871
R279 VSS.n199 VSS.n5 126.871
R280 VSS.n67 VSS.n64 126.871
R281 VSS.n157 VSS.n2 126.871
R282 VSS.n135 VSS.n3 126.871
R283 VSS.n113 VSS.n4 126.871
R284 VSS.n78 VSS.n77 126.871
R285 VSS.n96 VSS.n94 126.871
R286 VSS.n105 VSS.n104 117.001
R287 VSS.n106 VSS.n105 117.001
R288 VSS.n110 VSS.n109 117.001
R289 VSS.n109 VSS.n108 117.001
R290 VSS.n90 VSS.n54 117.001
R291 VSS.n91 VSS.n90 117.001
R292 VSS.n88 VSS.n49 117.001
R293 VSS.n88 VSS.n87 117.001
R294 VSS.n127 VSS.n126 117.001
R295 VSS.n128 VSS.n127 117.001
R296 VSS.n132 VSS.n131 117.001
R297 VSS.n131 VSS.n130 117.001
R298 VSS.n119 VSS.n118 117.001
R299 VSS.n120 VSS.n119 117.001
R300 VSS.n124 VSS.n123 117.001
R301 VSS.n123 VSS.n122 117.001
R302 VSS.n149 VSS.n148 117.001
R303 VSS.n150 VSS.n149 117.001
R304 VSS.n154 VSS.n153 117.001
R305 VSS.n153 VSS.n152 117.001
R306 VSS.n141 VSS.n140 117.001
R307 VSS.n142 VSS.n141 117.001
R308 VSS.n146 VSS.n145 117.001
R309 VSS.n145 VSS.n144 117.001
R310 VSS.n187 VSS.n13 117.001
R311 VSS.n188 VSS.n187 117.001
R312 VSS.n185 VSS.n174 117.001
R313 VSS.n174 VSS.n173 117.001
R314 VSS.n192 VSS.n10 117.001
R315 VSS.n193 VSS.n192 117.001
R316 VSS.n197 VSS.n196 117.001
R317 VSS.n196 VSS.n195 117.001
R318 VSS.n168 VSS.n167 108.047
R319 VSS.n193 VSS.n191 89.224
R320 VSS.n189 VSS.n188 89.224
R321 VSS.n142 VSS.n29 89.224
R322 VSS.n150 VSS.n25 89.224
R323 VSS.n120 VSS.n41 89.224
R324 VSS.n128 VSS.n36 89.224
R325 VSS.n92 VSS.n91 89.224
R326 VSS.n106 VSS.n48 89.224
R327 VSS.n166 VSS.n165 83.5719
R328 VSS.n167 VSS.n166 83.5719
R329 VSS.n164 VSS.n163 83.5719
R330 VSS.n163 VSS.n162 83.5719
R331 VSS.n67 VSS.n66 73.1255
R332 VSS.n71 VSS.n70 73.1255
R333 VSS.n70 VSS.n69 73.1255
R334 VSS.n95 VSS.n51 73.1255
R335 VSS.n96 VSS.n95 73.1255
R336 VSS.n100 VSS.n99 73.1255
R337 VSS.n99 VSS.n98 73.1255
R338 VSS.n76 VSS.n75 73.1255
R339 VSS.n77 VSS.n76 73.1255
R340 VSS.n74 VSS.n73 73.1255
R341 VSS.n73 VSS.n72 73.1255
R342 VSS.n112 VSS.n111 73.1255
R343 VSS.n113 VSS.n112 73.1255
R344 VSS.n117 VSS.n116 73.1255
R345 VSS.n116 VSS.n115 73.1255
R346 VSS.n134 VSS.n133 73.1255
R347 VSS.n135 VSS.n134 73.1255
R348 VSS.n139 VSS.n138 73.1255
R349 VSS.n138 VSS.n137 73.1255
R350 VSS.n156 VSS.n155 73.1255
R351 VSS.n157 VSS.n156 73.1255
R352 VSS.n161 VSS.n160 73.1255
R353 VSS.n160 VSS.n159 73.1255
R354 VSS.n182 VSS.n177 67.3887
R355 VSS.n204 VSS.n203 67.3887
R356 VSS.n64 VSS.n63 50.5605
R357 VSS.n178 VSS.n177 50.5605
R358 VSS.n204 VSS.n5 50.5605
R359 VSS.n191 VSS.n14 50.5605
R360 VSS.n189 VSS.n170 50.5605
R361 VSS.n168 VSS.n15 50.5605
R362 VSS.n29 VSS.n28 50.5605
R363 VSS.n25 VSS.n24 50.5605
R364 VSS.n2 VSS.n21 50.5605
R365 VSS.n41 VSS.n40 50.5605
R366 VSS.n36 VSS.n35 50.5605
R367 VSS.n3 VSS.n32 50.5605
R368 VSS.n92 VSS.n84 50.5605
R369 VSS.n48 VSS.n47 50.5605
R370 VSS.n4 VSS.n44 50.5605
R371 VSS.n78 VSS.n56 50.5605
R372 VSS.n94 VSS.n55 50.5605
R373 VSS.n65 VSS.t18 21.1205
R374 VSS.n71 VSS.n60 14.3327
R375 VSS VSS.t23 2.40298
R376 VSS.n190 VSS.t15 2.3411
R377 VSS.n79 VSS.t7 2.3411
R378 VSS.n81 VSS.t9 2.3411
R379 VSS.n83 VSS.t5 2.3411
R380 VSS.t3 VSS.t13 2.3317
R381 VSS.t3 VSS.n93 2.3317
R382 VSS.t5 VSS.n82 2.3317
R383 VSS.t9 VSS.n80 2.3317
R384 VSS.t25 VSS.t7 2.3317
R385 VSS.t23 VSS.t15 2.3317
R386 VSS.t13 VSS.t19 2.13743
R387 VSS.n169 VSS.n190 1.1661
R388 VSS.n80 VSS.n79 1.1661
R389 VSS.n82 VSS.n81 1.1661
R390 VSS.n93 VSS.n83 1.1661
R391 VSS.n169 VSS.t25 1.1567
C0 DEC2 N3 0.13045f
C1 VDD net3 0.12255f
C2 PCLK DEC2 0.12156f
C3 DEC1 N3 0.12548f
C4 A1 N3 0.24554f
C5 PCLK DEC1 0.12156f
C6 A1 PCLK 0.12331f
C7 A0T N2 0.24585f
C8 DEC3 net3 0.12548f
C9 A0T A0B 1.2307f
C10 N0 N2 0.24751f
C11 N0 A0B 0.24628f
C12 A1T net4 2.01932f
C13 N1 A0 0.24554f
C14 DEC2 N2 1.36331f
C15 N1 EVAL_GND 0.30805f
C16 DEC2 A0B 0.12176f
C17 A0 EVAL_GND 0.28412f
C18 DEC1 N2 0.13045f
C19 A0T net3 0.11676f
C20 A1B net2 1.91866f
C21 A1 N2 0.24554f
C22 N0 net3 0.1227f
C23 DEC1 A0B 0.12156f
C24 A1 A0B 5.45963f
C25 DEC0 A1T 0.12204f
C26 VDD A1T 0.78961f
C27 DEC2 net3 0.12561f
C28 DEC1 net3 0.12563f
C29 N1 net1 0.12438f
C30 A1 net3 0.11611f
C31 DEC3 A1T 0.12156f
C32 A0 net1 0.11611f
C33 net1 EVAL_GND 0.49676f
C34 PCLK N3 0.55822f
C35 net2 net4 0.12454f
C36 A0T A1T 5.3569f
C37 net2 DEC0 0.12611f
C38 N0 A1T 5.35295f
C39 VDD net2 0.12255f
C40 N2 N3 5.42451f
C41 A0B N3 0.2457f
C42 PCLK N2 0.55838f
C43 A1T DEC2 0.12156f
C44 PCLK A0B 0.35641f
C45 net2 DEC3 0.12548f
C46 DEC1 A1T 0.12156f
C47 A1 A1T 0.23017f
C48 A1B N1 0.83216f
C49 A1B A0 0.36629f
C50 net3 N3 0.12438f
C51 A1B EVAL_GND 0.29609f
C52 PCLK net3 0.11612f
C53 N2 A0B 0.2457f
C54 net2 A0T 0.72499f
C55 net2 N0 0.12287f
C56 net2 DEC2 0.12548f
C57 N1 net4 0.1227f
C58 A0 net4 0.11611f
C59 net3 N2 0.24917f
C60 A1B net1 1.91932f
C61 net4 EVAL_GND 5.61652f
C62 net3 A0B 0.68572f
C63 DEC1 net2 0.12561f
C64 A1 net2 0.11611f
C65 DEC0 N1 0.13093f
C66 DEC0 A0 0.12204f
C67 VDD N1 1.92256f
C68 A1T N3 0.86575f
C69 DEC0 EVAL_GND 5.30799f
C70 VDD A0 1.30178f
C71 PCLK A1T 0.23012f
C72 VDD EVAL_GND 0.29619f
C73 DEC3 N1 0.12156f
C74 net1 net4 0.12416f
C75 DEC3 A0 0.12156f
C76 DEC3 EVAL_GND 0.25943f
C77 A1T N2 0.86563f
C78 DEC0 net1 0.12606f
C79 A1T A0B 0.26599f
C80 VDD net1 0.12252f
C81 A0T N1 0.24692f
C82 A0T A0 0.23017f
C83 N0 N1 5.40985f
C84 N0 A0 0.24554f
C85 A0T EVAL_GND 4.00065f
C86 net2 N3 0.12505f
C87 N0 EVAL_GND 0.30786f
C88 PCLK net2 0.11612f
C89 DEC3 net1 0.12548f
C90 N1 DEC2 0.12156f
C91 A1T net3 2.01932f
C92 DEC2 A0 0.12156f
C93 DEC2 EVAL_GND 0.25971f
C94 DEC1 N1 1.32283f
C95 A1 N1 0.24554f
C96 DEC1 A0 0.12156f
C97 A1 A0 5.22461f
C98 A1B net4 0.11611f
C99 DEC1 EVAL_GND 0.26051f
C100 A1 EVAL_GND 0.28412f
C101 net2 N2 0.12438f
C102 A0T net1 0.1227f
C103 net2 A0B 0.11611f
C104 N0 net1 0.24917f
C105 A1B DEC0 0.12204f
C106 A1B VDD 1.95447f
C107 DEC2 net1 0.12548f
C108 DEC1 net1 0.12548f
C109 net2 net3 5.2266f
C110 A1 net1 0.11611f
C111 A1B DEC3 0.12156f
C112 DEC0 net4 0.12661f
C113 N1 N3 0.24789f
C114 VDD net4 0.12255f
C115 A0 N3 0.24554f
C116 PCLK N1 0.55838f
C117 A1B A0T 5.34949f
C118 PCLK A0 5.22872f
C119 EVAL_GND N3 0.30826f
C120 A1B N0 0.84286f
C121 PCLK EVAL_GND 0.81238f
C122 DEC3 net4 0.12561f
C123 VDD DEC0 0.67042f
C124 A1B DEC2 0.12156f
C125 net2 A1T 0.1227f
C126 N1 N2 5.41699f
C127 A1B DEC1 0.12156f
C128 A1 A1B 1.24035f
C129 DEC0 DEC3 0.12631f
C130 A0 N2 0.24554f
C131 N1 A0B 0.24582f
C132 A0 A0B 1.19949f
C133 N2 EVAL_GND 0.30805f
C134 net1 N3 5.22944f
C135 VDD DEC3 0.67042f
C136 A0T net4 0.71906f
C137 A0B EVAL_GND 3.7903f
C138 PCLK net1 0.11612f
C139 N0 net4 0.1227f
C140 DEC2 net4 0.12563f
C141 N1 net3 0.12287f
C142 A0T DEC0 0.12204f
C143 A0 net3 0.11611f
C144 N0 DEC0 1.28284f
C145 VDD A0T 0.78993f
C146 net3 EVAL_GND 0.52478f
C147 DEC1 net4 0.12576f
C148 A1 net4 0.11611f
C149 VDD N0 1.92256f
C150 net1 N2 0.12505f
C151 net1 A0B 0.68572f
C152 DEC0 DEC2 0.12668f
C153 A0T DEC3 0.12179f
C154 VDD DEC2 0.67042f
C155 N0 DEC3 0.12156f
C156 DEC1 DEC0 5.22874f
C157 A1 DEC0 0.12204f
C158 VDD DEC1 0.67042f
C159 A1 VDD 1.30066f
C160 A1B N3 0.24554f
C161 net3 net1 0.12454f
C162 DEC3 DEC2 5.22874f
C163 A1B PCLK 0.35206f
C164 DEC1 DEC3 0.12668f
C165 A1 DEC3 0.12156f
C166 A0T N0 0.24789f
C167 A1T N1 0.24751f
C168 A1T A0 0.2301f
C169 A1T EVAL_GND 0.30795f
C170 A0T DEC2 0.12156f
C171 N0 DEC2 0.12156f
C172 A1B N2 0.24582f
C173 net4 N3 0.26167f
C174 A1B A0B 5.48233f
C175 DEC1 A0T 0.12176f
C176 A1 A0T 0.23033f
C177 DEC1 N0 0.12156f
C178 PCLK net4 0.11612f
C179 A1 N0 0.26722f
C180 DEC1 DEC2 5.22874f
C181 DEC0 N3 0.12596f
C182 A1 DEC2 0.12156f
C183 A1T net1 0.12287f
C184 PCLK DEC0 0.12909f
C185 A1B net3 0.11676f
C186 VDD N3 1.92271f
C187 net2 N1 0.26167f
C188 A1 DEC1 0.12156f
C189 PCLK VDD 5.16939f
C190 net2 A0 0.11611f
C191 N2 net4 0.12287f
C192 net2 EVAL_GND 0.4856f
C193 A0B net4 0.11611f
C194 DEC3 N3 1.40379f
C195 PCLK DEC3 0.12156f
C196 DEC0 N2 0.12596f
C197 DEC0 A0B 0.12204f
C198 VDD N2 1.92256f
C199 net3 net4 5.2266f
C200 VDD A0B 1.95615f
C201 A0T N3 0.28897f
C202 net2 net1 5.2266f
C203 N0 N3 0.24714f
C204 PCLK A0T 0.23022f
C205 PCLK N0 0.55853f
C206 DEC3 N2 0.12156f
C207 DEC3 A0B 0.12156f
C208 DEC0 net3 0.12624f
C209 A1B A1T 1.27148f
C210 DEC3 VSS 31.38521f
C211 DEC2 VSS 22.32732f
C212 DEC1 VSS 19.09798f
C213 DEC0 VSS 17.9026f
C214 VDD VSS 79.41354f
C215 net4 VSS 26.80693f
C216 net3 VSS 12.08955f
C217 net2 VSS 16.11905f
C218 EVAL_GND VSS 31.86838f
C219 net1 VSS 9.82146f
C220 VSS.t23 VSS 4.01511f
C221 VSS.t15 VSS 4.08453f
C222 VSS.t5 VSS 11.23612f
C223 VSS.t3 VSS 5.22221f
C224 VSS.t13 VSS 8.22925f
C225 VSS.t19 VSS 8.32585f
.ends row_decoder

* expanding   symbol:  wl_driver.sym # of pins=4
** sym_path: /work/cells/wordline_driver/wl_driver.sym
** sch_path: /work/cells/wordline_driver/wl_driver.sch
.subckt wl_driver VDD WL_IN WL VSS
*.iopin VDD
*.iopin VSS
*.iopin WL_IN
*.iopin WL
XMP1 WL_N WL_IN VDD VDD sky130_fd_pr__pfet_01v8 L=0.15 W=0.42 nf=1 ad='int((nf+1)/2) * W/nf * 0.29' as='int((nf+2)/2) * W/nf * 0.29'
+ pd='2*int((nf+1)/2) * (W/nf + 0.29)' ps='2*int((nf+2)/2) * (W/nf + 0.29)' nrd='0.29 / W' nrs='0.29 / W' sa=0 sb=0 sd=0 mult=1 m=1
XMN1 WL_N WL_IN VSS VSS sky130_fd_pr__nfet_01v8 L=0.15 W=0.42 nf=1 ad='int((nf+1)/2) * W/nf * 0.29' as='int((nf+2)/2) * W/nf * 0.29'
+ pd='2*int((nf+1)/2) * (W/nf + 0.29)' ps='2*int((nf+2)/2) * (W/nf + 0.29)' nrd='0.29 / W' nrs='0.29 / W' sa=0 sb=0 sd=0 mult=1 m=1
XMP2 WL WL_N VDD VDD sky130_fd_pr__pfet_01v8 L=0.15 W=0.84 nf=1 ad='int((nf+1)/2) * W/nf * 0.29' as='int((nf+2)/2) * W/nf * 0.29' pd='2*int((nf+1)/2) * (W/nf + 0.29)'
+ ps='2*int((nf+2)/2) * (W/nf + 0.29)' nrd='0.29 / W' nrs='0.29 / W' sa=0 sb=0 sd=0 mult=1 m=1
XMN2 WL WL_N VSS VSS sky130_fd_pr__nfet_01v8 L=0.15 W=0.84 nf=1 ad='int((nf+1)/2) * W/nf * 0.29' as='int((nf+2)/2) * W/nf * 0.29' pd='2*int((nf+1)/2) * (W/nf + 0.29)'
+ ps='2*int((nf+2)/2) * (W/nf + 0.29)' nrd='0.29 / W' nrs='0.29 / W' sa=0 sb=0 sd=0 mult=1 m=1
.ends

.GLOBAL GND

.lib "/opt/pdks/sky130A/libs.tech/combined/continuous/sky130.lib.spice" tt
.temp 27
.options method=gear
.save v(dec0) v(dec1) v(dec2) v(dec3) v(net1) v(net2) v(net3) v(net4) v(net5) v(net6) v(net7) v(net8) v(x1.a0b) v(x1.a0t) v(x1.a1b) v(x1.a1t) v(x1.eval_gnd) v(x1.n0) v(x1.n1) v(x1.n2) v(x1.n3) v(x1.net1) v(x1.net2) v(x1.net3) v(x1.net4) v(x1.vss.t0) v(x1.vss.t1) v(x1.vss.t10) v(x1.vss.t11) v(x1.vss.t12) v(x1.vss.t13) v(x1.vss.t14) v(x1.vss.t15) v(x1.vss.t16) v(x1.vss.t17) v(x1.vss.t18) v(x1.vss.t19) v(x1.vss.t2) v(x1.vss.t20) v(x1.vss.t21) v(x1.vss.t22) v(x1.vss.t23) v(x1.vss.t24) v(x1.vss.t25) v(x1.vss.t3) v(x1.vss.t4) v(x1.vss.t5) v(x1.vss.t6) v(x1.vss.t7) v(x1.vss.t8) v(x1.vss.t9) v(x2.wl_n) v(x3.wl_n) v(x4.wl_n) v(x5.wl_n) i(VDD_SRC) i(VPCLK) i(VA0) i(VA1) v(x1.n0) v(x1.n1) v(x1.n2) v(x1.n3)
.tran 5p 3e-08 0 5e-12 uic
.control
set num_threads=1
run
write waveform.raw
quit 0
.endc
.end
