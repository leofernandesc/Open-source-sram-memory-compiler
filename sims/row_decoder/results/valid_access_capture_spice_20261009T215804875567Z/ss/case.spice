* valid_access_capture transistor-level check: ss
.lib "/opt/pdks/sky130A/libs.tech/ngspice/sky130.lib.spice" ss
.include "/opt/pdks/sky130A/libs.ref/sky130_fd_sc_hd/spice/sky130_fd_sc_hd.spice"
.include "/work/sims/row_decoder/results/valid_access_capture_spice_20261009T215804875567Z/valid_access_capture_cell.spice"
.temp -40
.options method=gear reltol=1e-4 vabstol=1e-9 iabstol=1e-12
VSS_SRC VSS 0 0
VDD_SRC VDD VSS 1.62
VCLK CLK VSS PULSE(0 1.62 1n 50p 50p 1n 2n)
VCSB CSb VSS PWL(0 1.62 4.5e-10 1.62 5e-10 0 1.8e-09 0 1.85e-09 1.62 2.45e-09 1.62 2.5e-09 0 3.8e-09 0 3.85e-09 1.62 4.45e-09 1.62 4.5e-09 0 5.8e-09 0 5.85e-09 1.62 6.45e-09 1.62 6.5e-09 0 7.8e-09 0 7.85e-09 1.62 8.45e-09 1.62 8.5e-09 1.62 9.8e-09 1.62 9.85e-09 0 1.045e-08 0 1.05e-08 1.62 1.18e-08 1.62 1.185e-08 0 1.245e-08 0 1.25e-08 1.62 1.38e-08 1.62 1.385e-08 0 1.445e-08 0 1.45e-08 1.62 1.58e-08 1.62 1.585e-08 0)
VOEB OEb VSS PWL(0 1.62 4.5e-10 1.62 5e-10 0 1.8e-09 0 1.85e-09 1.62 2.45e-09 1.62 2.5e-09 0 3.8e-09 0 3.85e-09 1.62 4.45e-09 1.62 4.5e-09 1.62 5.8e-09 1.62 5.85e-09 0 6.45e-09 0 6.5e-09 1.62 7.8e-09 1.62 7.85e-09 0 8.45e-09 0 8.5e-09 0 9.8e-09 0 9.85e-09 1.62 1.045e-08 1.62 1.05e-08 0 1.18e-08 0 1.185e-08 1.62 1.245e-08 1.62 1.25e-08 1.62 1.38e-08 1.62 1.385e-08 0 1.445e-08 0 1.45e-08 1.62 1.58e-08 1.62 1.585e-08 0)
VWEB WEb VSS PWL(0 1.62 4.5e-10 1.62 5e-10 0 1.8e-09 0 1.85e-09 1.62 2.45e-09 1.62 2.5e-09 1.62 3.8e-09 1.62 3.85e-09 0 4.45e-09 0 4.5e-09 0 5.8e-09 0 5.85e-09 1.62 6.45e-09 1.62 6.5e-09 1.62 7.8e-09 1.62 7.85e-09 0 8.45e-09 0 8.5e-09 0 9.8e-09 0 9.85e-09 1.62 1.045e-08 1.62 1.05e-08 1.62 1.18e-08 1.62 1.185e-08 0 1.245e-08 0 1.25e-08 0 1.38e-08 0 1.385e-08 1.62 1.445e-08 1.62 1.45e-08 1.62 1.58e-08 1.62 1.585e-08 0)
XACCESS CLK CSb OEb WEb VDD VSS VALID_ACCESS_Q valid_access_capture
CLOAD VALID_ACCESS_Q VSS 3.434554f
.control
set ngbehavior=hsa
set ng_nomodcheck
set noaskquit
tran 5p 17n 0 5p
wrdata /work/sims/row_decoder/results/valid_access_capture_spice_20261009T215804875567Z/ss/valid_access_q.dat v(VALID_ACCESS_Q)
.endc
.end
