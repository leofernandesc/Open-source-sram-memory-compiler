* NGSPICE file created from bitcell_6t_flat.ext - technology: sky130A

.subckt bitcell_6t_flat VDD BL BLB VSS WL
X0 a_167_n2114.t0 a_215_n2026.t4 VDD.t1 VDD.t0 sky130_fd_pr__pfet_01v8 ad=0.1218 pd=1.42 as=0.1218 ps=1.42 w=0.42 l=0.15
X1 a_215_n2026.t2 WL.t1 BL.t0 VSS.t4 sky130_fd_pr__nfet_01v8 ad=0.174 pd=1.78 as=0.174 ps=1.78 w=0.6 l=0.15
X2 a_167_n2114.t1 a_215_n2026.t3 VSS.t1 VSS.t0 sky130_fd_pr__nfet_01v8 ad=0.3654 pd=3.1 as=0.3654 ps=3.1 w=1.26 l=0.15
X3 a_215_n2026.t0 a_167_n2114.t4 VDD.t3 VDD.t2 sky130_fd_pr__pfet_01v8 ad=0.1218 pd=1.42 as=0.1218 ps=1.42 w=0.42 l=0.15
X4 a_167_n2114.t2 WL.t0 BLB.t0 VSS.t5 sky130_fd_pr__nfet_01v8 ad=0.174 pd=1.78 as=0.174 ps=1.78 w=0.6 l=0.15
X5 a_215_n2026.t1 a_167_n2114.t3 VSS.t3 VSS.t2 sky130_fd_pr__nfet_01v8 ad=0.3654 pd=3.1 as=0.3654 ps=3.1 w=1.26 l=0.15
C0 BL VDD 0
C1 VDD WL 0
C2 BL BLB 1.84472f
C3 WL BLB 0.18443f
C4 VDD BLB 0
C5 BL WL 1.87992f
R0 BLB BLB.t0 233.916
R1 BL BL.t0 233.596
R2 WL.n0 WL.t1 319.156
R3 WL.n0 WL.t0 317.147
R4 WL WL.n0 13.5102
R5 VDD.n0 VDD.t1 671.755
R6 VDD.n2 VDD.t3 671.547
R7 VDD.n0 VDD.t0 186.004
R8 VDD.n1 VDD.t2 185.75
R9 VDD.n1 VDD.n0 0.269071
R10 VDD VDD.n2 0.143179
R11 VDD.n2 VDD.n1 0.0900238
R12 VSS.n22 VSS.n21 14329.5
R13 VSS.n21 VSS.n4 8261.87
R14 VSS.n21 VSS.n20 6478.74
R15 VSS.n24 VSS.n1 2456.71
R16 VSS.n24 VSS.n2 2456.71
R17 VSS.n23 VSS.n1 2456.71
R18 VSS.n23 VSS.n2 2456.71
R19 VSS.n11 VSS.n7 2456.71
R20 VSS.n11 VSS.n8 2456.71
R21 VSS.n10 VSS.n7 2456.71
R22 VSS.n10 VSS.n8 2456.71
R23 VSS.n16 VSS.n6 2074.29
R24 VSS.n18 VSS.n6 2074.29
R25 VSS.n17 VSS.n16 2074.29
R26 VSS.n18 VSS.n17 2074.29
R27 VSS.n15 VSS.n14 684.424
R28 VSS.n14 VSS.n13 518.711
R29 VSS.n4 VSS.n3 502.558
R30 VSS.t0 VSS.n5 413.563
R31 VSS.t0 VSS.n9 413.563
R32 VSS.t2 VSS.n3 413.563
R33 VSS.t2 VSS.n22 413.563
R34 VSS.n20 VSS.n5 400.476
R35 VSS.n13 VSS.n6 304.949
R36 VSS.n25 VSS.n24 304.048
R37 VSS.n12 VSS.n11 303.976
R38 VSS.t0 VSS.n10 292.5
R39 VSS.n11 VSS.t0 292.5
R40 VSS.t2 VSS.n23 292.5
R41 VSS.n24 VSS.t2 292.5
R42 VSS.n17 VSS.t4 292.5
R43 VSS.n6 VSS.t4 292.5
R44 VSS.n15 VSS.t4 269.041
R45 VSS.n19 VSS.t4 269.041
R46 VSS.n9 VSS.n4 240.81
R47 VSS.n20 VSS.n19 223.065
R48 VSS.n19 VSS.n18 146.25
R49 VSS.n16 VSS.n15 146.25
R50 VSS.n9 VSS.n8 97.5005
R51 VSS.n7 VSS.n5 97.5005
R52 VSS.n22 VSS.n2 97.5005
R53 VSS.n3 VSS.n1 97.5005
R54 VSS.n26 VSS.t3 87.7129
R55 VSS.n0 VSS.t1 87.574
R56 VSS.n14 VSS.t5 22.5505
R57 VSS.n13 VSS.n12 0.537643
R58 VSS.n25 VSS.n0 0.269071
R59 VSS VSS.n26 0.143179
R60 VSS.n12 VSS.n0 0.0900238
R61 VSS.n26 VSS.n25 0.0900238
R62 a_215_n2026.t0 a_215_n2026.n2 667.521
R63 a_215_n2026.n2 a_215_n2026.n0 4.34871
R64 a_215_n2026.n0 a_215_n2026.n1 0.179548
R65 a_215_n2026.n1 a_215_n2026.t2 233.82
R66 a_215_n2026.n1 a_215_n2026.t4 312.329
R67 a_215_n2026.n0 a_215_n2026.t3 433.293
R68 a_215_n2026.n2 a_215_n2026.t1 85.1015
R69 a_167_n2114.t0 a_167_n2114.n2 667.313
R70 a_167_n2114.n2 a_167_n2114.n1 3.85693
R71 a_167_n2114.n1 a_167_n2114.t2 234.183
R72 a_167_n2114.n1 a_167_n2114.n0 4.41538
R73 a_167_n2114.n0 a_167_n2114.t3 430.065
R74 a_167_n2114.n0 a_167_n2114.t4 308.337
R75 a_167_n2114.n2 a_167_n2114.t1 85.2404
C6 BLB VSS 3.69851f
C7 BL VSS 4.62073f
C8 WL VSS 5.66171f
C9 VDD VSS 3.43195f
C10 a_167_n2114.t0 VSS 0.02953f $ **FLOATING
C11 a_167_n2114.t1 VSS 0.10375f $ **FLOATING
C12 a_167_n2114.t4 VSS 0.05599f $ **FLOATING
C13 a_167_n2114.n0 VSS 0.97304f $ **FLOATING
C14 a_167_n2114.t3 VSS 0.07537f $ **FLOATING
C15 a_167_n2114.t2 VSS 0.06319f $ **FLOATING
C16 a_167_n2114.n1 VSS 2.56459f $ **FLOATING
C17 a_167_n2114.n2 VSS 0.9811f $ **FLOATING
C18 a_215_n2026.t0 VSS 0.03792f $ **FLOATING
C19 a_215_n2026.t1 VSS 0.13152f $ **FLOATING
C20 a_215_n2026.t3 VSS 0.10426f $ **FLOATING
C21 a_215_n2026.n0 VSS 2.0383f $ **FLOATING
C22 a_215_n2026.t4 VSS 0.07763f $ **FLOATING
C23 a_215_n2026.n1 VSS 2.86834f $ **FLOATING
C24 a_215_n2026.t2 VSS 0.07927f $ **FLOATING
C25 a_215_n2026.n2 VSS 1.39991f $ **FLOATING
C26 VDD.t0 VSS 0.94709f $ **FLOATING
C27 VDD.t1 VSS 0.02103f $ **FLOATING
C28 VDD.n0 VSS 1.52311f $ **FLOATING
C29 VDD.t2 VSS 0.94541f $ **FLOATING
C30 VDD.n1 VSS 0.40673f $ **FLOATING
C31 VDD.t3 VSS 0.0209f $ **FLOATING
C32 VDD.n2 VSS 0.37159f $ **FLOATING
C33 WL.t1 VSS 0.04805f $ **FLOATING
C34 WL.t0 VSS 0.04743f $ **FLOATING
C35 WL.n0 VSS 0.61729f $ **FLOATING
C36 BL.t0 VSS 0.09658f $ **FLOATING
C37 BLB.t0 VSS 0.05439f $ **FLOATING
.ends
