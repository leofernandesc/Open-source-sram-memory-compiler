* NGSPICE file created from write_driver_w5p04_flat.ext - technology: sky130A

.subckt write_driver_w5p04_flat DATA DATA_B WE BL BLB VDD VSS
X0 VSS.t3 WE.t1 a_1415_n5504.t1 VSS.t2 sky130_fd_pr__nfet_01v8 ad=1.4616 pd=10.66 as=1.4616 ps=10.66 w=5.04 l=0.15
X1 VDD.t7 WE.t3 a_227_n1084.t0 VDD.t6 sky130_fd_pr__pfet_01v8 ad=0.2436 pd=2.26 as=0.2436 ps=2.26 w=0.84 l=0.15
X2 VDD.t1 a_227_n1084.t3 a_1027_n1504.t0 VDD.t0 sky130_fd_pr__pfet_01v8 ad=1.4616 pd=10.66 as=1.4616 ps=10.66 w=5.04 l=0.15
X3 a_3015_n5504.t0 DATA.t0 BLB.t0 VSS.t0 sky130_fd_pr__nfet_01v8 ad=1.4616 pd=10.66 as=1.4616 ps=10.66 w=5.04 l=0.15
X4 a_1027_n1504.t1 DATA_B.t1 BL.t0 VDD.t5 sky130_fd_pr__pfet_01v8 ad=1.4616 pd=10.66 as=1.4616 ps=10.66 w=5.04 l=0.15
X5 VSS.t7 WE.t0 a_3015_n5504.t1 VSS.t6 sky130_fd_pr__nfet_01v8 ad=1.4616 pd=10.66 as=1.4616 ps=10.66 w=5.04 l=0.15
X6 VDD.t3 a_227_n1084.t2 a_2627_n1504.t0 VDD.t2 sky130_fd_pr__pfet_01v8 ad=1.4616 pd=10.66 as=1.4616 ps=10.66 w=5.04 l=0.15
X7 a_2627_n1504.t1 DATA.t1 BLB.t1 VDD.t4 sky130_fd_pr__pfet_01v8 ad=1.4616 pd=10.66 as=1.4616 ps=10.66 w=5.04 l=0.15
X8 VSS.t5 WE.t2 a_227_n1084.t1 VSS.t4 sky130_fd_pr__nfet_01v8 ad=0.2436 pd=2.26 as=0.2436 ps=2.26 w=0.84 l=0.15
X9 a_1415_n5504.t0 DATA_B.t0 BL.t1 VSS.t1 sky130_fd_pr__nfet_01v8 ad=1.4616 pd=10.66 as=1.4616 ps=10.66 w=5.04 l=0.15
C0 DATA_B DATA 2.61788f
C1 DATA_B VDD 0.45492f
C2 DATA BL 2.62653f
C3 DATA_B WE 0.62157f
C4 VDD BL 0.55121f
C5 DATA_B BLB 0.10435f
C6 BL WE 0.70062f
C7 BLB BL 2.63785f
C8 VDD DATA 0.44343f
C9 DATA WE 0.28723f
C10 VDD WE 0.97779f
C11 BLB DATA 1.27977f
C12 VDD BLB 0.55092f
C13 BLB WE 0.26348f
C14 DATA_B BL 1.81912f
R0 BLB.n0 BLB.t1 58.6317
R1 BLB.n0 BLB.t0 29.2021
R2 BLB BLB.n0 1.74789
R3 DATA.n0 DATA.t1 1056.08
R4 DATA.n0 DATA.t0 1043.98
R5 DATA DATA.n0 1.45806
R6 BL.n0 BL.t0 58.4085
R7 BL.n0 BL.t1 29.4254
R8 BL BL.n0 0.852655
R9 DATA_B.n0 DATA_B.t1 1055.66
R10 DATA_B.n0 DATA_B.t0 1042.99
R11 DATA_B DATA_B.n0 0.758655
R12 WE.n0 WE.t0 1044.61
R13 WE.n0 WE.t1 1044.31
R14 WE.n2 WE.t3 379.339
R15 WE.n1 WE.t2 368.916
R16 WE.n1 WE.n0 0.476095
R17 WE WE.n2 0.311036
R18 WE.n2 WE.n1 0.280262
R19 VDD.n6 VDD.t7 340.288
R20 VDD.n0 VDD.t4 191.141
R21 VDD.n3 VDD.t0 190.694
R22 VDD.n2 VDD.t5 190.694
R23 VDD.n0 VDD.t2 190.694
R24 VDD.n5 VDD.t6 187.156
R25 VDD.n4 VDD.t1 57.2359
R26 VDD.n1 VDD.t3 57.2359
R27 VDD.n3 VDD.n2 0.448119
R28 VDD VDD.n6 0.384893
R29 VDD.n5 VDD.n4 0.3765
R30 VDD.n2 VDD.n1 0.320548
R31 VDD.n1 VDD.n0 0.128071
R32 VDD.n4 VDD.n3 0.128071
R33 VDD.n6 VDD.n5 0.072119
R34 VSS.n38 VSS.n37 106940
R35 VSS.n17 VSS.n16 106001
R36 VSS.n17 VSS.n4 97726.3
R37 VSS.n37 VSS.n4 97726.3
R38 VSS.n18 VSS.n17 16936.5
R39 VSS.n24 VSS.n4 16936.5
R40 VSS.n37 VSS.n36 16936.5
R41 VSS.n35 VSS.n33 4646.88
R42 VSS.n35 VSS.n34 4646.88
R43 VSS.n33 VSS.n32 4646.88
R44 VSS.n34 VSS.n32 4646.88
R45 VSS.n26 VSS.n5 4646.88
R46 VSS.n28 VSS.n5 4646.88
R47 VSS.n27 VSS.n26 4646.88
R48 VSS.n28 VSS.n27 4646.88
R49 VSS.n20 VSS.n6 4646.88
R50 VSS.n22 VSS.n6 4646.88
R51 VSS.n21 VSS.n20 4646.88
R52 VSS.n22 VSS.n21 4646.88
R53 VSS.n13 VSS.n12 4646.88
R54 VSS.n14 VSS.n13 4646.88
R55 VSS.n15 VSS.n14 4646.88
R56 VSS.n15 VSS.n12 4646.88
R57 VSS.n40 VSS.n1 2213.35
R58 VSS.n40 VSS.n2 2213.35
R59 VSS.n39 VSS.n1 2213.35
R60 VSS.n39 VSS.n2 2213.35
R61 VSS.n19 VSS.n7 529.884
R62 VSS.n25 VSS.n23 529.884
R63 VSS.n30 VSS.n29 529.884
R64 VSS.n31 VSS.n3 529.884
R65 VSS.n12 VSS.n11 306.122
R66 VSS.n35 VSS.n0 305.971
R67 VSS.n9 VSS.n5 305.625
R68 VSS.n41 VSS.n40 305.521
R69 VSS.n10 VSS.n6 305.486
R70 VSS.n21 VSS.t0 292.5
R71 VSS.n6 VSS.t0 292.5
R72 VSS.n27 VSS.t2 292.5
R73 VSS.n5 VSS.t2 292.5
R74 VSS.t4 VSS.n39 292.5
R75 VSS.n40 VSS.t4 292.5
R76 VSS.t1 VSS.n32 292.5
R77 VSS.t1 VSS.n35 292.5
R78 VSS.n14 VSS.t6 292.5
R79 VSS.n12 VSS.t6 292.5
R80 VSS.n16 VSS.t6 172.978
R81 VSS.t6 VSS.n7 172.978
R82 VSS.n23 VSS.t0 172.978
R83 VSS.n29 VSS.t2 172.978
R84 VSS.t1 VSS.n31 172.978
R85 VSS.t4 VSS.n3 172.978
R86 VSS.t4 VSS.n38 172.978
R87 VSS.n42 VSS.t5 126.996
R88 VSS.n38 VSS.n2 117.001
R89 VSS.n3 VSS.n1 117.001
R90 VSS.n18 VSS.t0 109.481
R91 VSS.n24 VSS.t2 109.481
R92 VSS.n36 VSS.t1 109.481
R93 VSS.n19 VSS.n18 63.4989
R94 VSS.n25 VSS.n24 63.4989
R95 VSS.n36 VSS.n30 63.4989
R96 VSS.n23 VSS.n22 34.4123
R97 VSS.n20 VSS.n19 34.4123
R98 VSS.n29 VSS.n28 34.4123
R99 VSS.n26 VSS.n25 34.4123
R100 VSS.n34 VSS.n31 34.4123
R101 VSS.n33 VSS.n30 34.4123
R102 VSS.n13 VSS.n7 34.4123
R103 VSS.n16 VSS.n15 34.4123
R104 VSS.n8 VSS.t3 26.4492
R105 VSS.n11 VSS.t7 26.4492
R106 VSS VSS.n42 0.55275
R107 VSS.n10 VSS.n9 0.425738
R108 VSS.n41 VSS.n0 0.420143
R109 VSS.n11 VSS.n10 0.3765
R110 VSS.n8 VSS.n0 0.298167
R111 VSS.n42 VSS.n41 0.178429
R112 VSS.n9 VSS.n8 0.0945
R113 a_3015_n5504.t0 a_3015_n5504.t1 56.918
R114 a_1415_n5504.t0 a_1415_n5504.t1 57.8108
R115 a_2627_n1504.t0 a_2627_n1504.t1 118.638
R116 a_1027_n1504.t0 a_1027_n1504.t1 117.746
R117 a_227_n1084.t0 a_227_n1084.n1 340.68
R118 a_227_n1084.n1 a_227_n1084.n0 0.354119
R119 a_227_n1084.n0 a_227_n1084.t2 1055.88
R120 a_227_n1084.n1 a_227_n1084.t1 130.643
R121 a_227_n1084.n0 a_227_n1084.t3 1054.99
C15 BLB VSS 3.14307f
C16 DATA VSS 3.12774f
C17 BL VSS 2.31625f
C18 DATA_B VSS 2.05827f
C19 WE VSS 5.08768f
C20 VDD VSS 13.68683f
C21 a_227_n1084.t0 VSS 0.10493f $ **FLOATING
C22 a_227_n1084.t3 VSS 0.28474f $ **FLOATING
C23 a_227_n1084.n0 VSS 5.86652f $ **FLOATING
C24 a_227_n1084.t1 VSS 0.22366f $ **FLOATING
C25 a_227_n1084.n1 VSS 4.72607f $ **FLOATING
C26 a_227_n1084.t2 VSS 0.28775f $ **FLOATING
C27 a_1027_n1504.t0 VSS 5.75744f $ **FLOATING
C28 a_1027_n1504.t1 VSS 5.76263f $ **FLOATING
C29 a_2627_n1504.t0 VSS 5.76725f $ **FLOATING
C30 a_2627_n1504.t1 VSS 5.75721f $ **FLOATING
C31 a_1415_n5504.t0 VSS 4.48974f $ **FLOATING
C32 a_1415_n5504.t1 VSS 4.49135f $ **FLOATING
C33 a_3015_n5504.t0 VSS 2.48733f $ **FLOATING
C34 a_3015_n5504.t1 VSS 2.48156f $ **FLOATING
C35 VDD.t4 VSS 1.36f $ **FLOATING
C36 VDD.t2 VSS 1.35923f $ **FLOATING
C37 VDD.n0 VSS 0.55556f $ **FLOATING
C38 VDD.t3 VSS 0.16059f $ **FLOATING
C39 VDD.n1 VSS 0.37916f $ **FLOATING
C40 VDD.t5 VSS 1.35923f $ **FLOATING
C41 VDD.n2 VSS 0.26133f $ **FLOATING
C42 VDD.t0 VSS 1.35923f $ **FLOATING
C43 VDD.n3 VSS 0.22951f $ **FLOATING
C44 VDD.t1 VSS 0.16059f $ **FLOATING
C45 VDD.n4 VSS 0.38841f $ **FLOATING
C46 VDD.t6 VSS 0.58652f $ **FLOATING
C47 VDD.n5 VSS 0.27068f $ **FLOATING
C48 VDD.t7 VSS 0.02288f $ **FLOATING
C49 VDD.n6 VSS 0.26294f $ **FLOATING
C50 WE.t0 VSS 0.2137f $ **FLOATING
C51 WE.t1 VSS 0.21108f $ **FLOATING
C52 WE.n0 VSS 5.80669f $ **FLOATING
C53 WE.t2 VSS 0.10457f $ **FLOATING
C54 WE.n1 VSS 2.4541f $ **FLOATING
C55 WE.t3 VSS 0.07948f $ **FLOATING
C56 WE.n2 VSS 0.93501f $ **FLOATING
C57 DATA_B.t1 VSS 0.3356f $ **FLOATING
C58 DATA_B.t0 VSS 0.33651f $ **FLOATING
C59 DATA_B.n0 VSS 8.488f $ **FLOATING
C60 BL.t0 VSS 0.84883f $ **FLOATING
C61 BL.t1 VSS 1.4035f $ **FLOATING
C62 BL.n0 VSS 8.05891f $ **FLOATING
C63 DATA.t1 VSS 0.31398f $ **FLOATING
C64 DATA.t0 VSS 0.3148f $ **FLOATING
C65 DATA.n0 VSS 7.48805f $ **FLOATING
C66 BLB.t1 VSS 0.79464f $ **FLOATING
C67 BLB.t0 VSS 1.26803f $ **FLOATING
C68 BLB.n0 VSS 6.83184f $ **FLOATING
.ends
