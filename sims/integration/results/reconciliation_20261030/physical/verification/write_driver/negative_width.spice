.model sky130_fd_pr__nfet_01v8 nmos
.model sky130_fd_pr__pfet_01v8 pmos
.subckt write_driver DATA DATA_B WE BL BLB VDD VSS
MMPWEB WE_B WE VDD VDD sky130_fd_pr__pfet_01v8 w=1.008u l=0.15u
MMNWEB WE_B WE VSS VSS sky130_fd_pr__nfet_01v8 w=0.84u l=0.15u
MMPENBL net1 WE_B VDD VDD sky130_fd_pr__pfet_01v8 w=5.04u l=0.15u
MMPDBL BL DATA_B net1 VDD sky130_fd_pr__pfet_01v8 w=5.04u l=0.15u
MMNDBL BL DATA_B net2 VSS sky130_fd_pr__nfet_01v8 w=5.04u l=0.15u
MMNENBL net2 WE VSS VSS sky130_fd_pr__nfet_01v8 w=5.04u l=0.15u
MMPENBLB net3 WE_B VDD VDD sky130_fd_pr__pfet_01v8 w=5.04u l=0.15u
MMPDBLB BLB DATA net3 VDD sky130_fd_pr__pfet_01v8 w=5.04u l=0.15u
MMNDBLB BLB DATA net4 VSS sky130_fd_pr__nfet_01v8 w=5.04u l=0.15u
MMNENBLB net4 WE VSS VSS sky130_fd_pr__nfet_01v8 w=5.04u l=0.15u
.ends write_driver
