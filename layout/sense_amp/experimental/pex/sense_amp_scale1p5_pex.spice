* NGSPICE file created from sense_amp_scale1p5_flat.ext - technology: sky130A

.subckt sense_amp_scale1p5_flat VDD VSS BL BLB SCLK SA_OUT SA_OUTB
X0 a_615_n3098.t0 SA_OUT.t3 SA_OUTB.t1 VSS.t0 sky130_fd_pr__nfet_01v8 ad=0.2842 pd=2.54 as=0.2842 ps=2.54 w=0.98 l=0.15
X1 a_615_n3098.t2 SA_OUTB.t3 SA_OUT.t1 VSS.t3 sky130_fd_pr__nfet_01v8 ad=0.2842 pd=2.54 as=0.2842 ps=2.54 w=0.98 l=0.15
X2 BLB.t0 SCLK.t1 SA_OUTB.t2 VDD.t3 sky130_fd_pr__pfet_01v8 ad=0.58 pd=4.58 as=0.58 ps=4.58 w=2 l=0.15
X3 VSS.t2 SCLK.t0 a_615_n3098.t1 VSS.t1 sky130_fd_pr__nfet_01v8 ad=0.2842 pd=2.54 as=0.2842 ps=2.54 w=0.98 l=0.15
X4 VDD.t5 SA_OUTB.t4 SA_OUT.t0 VDD.t4 sky130_fd_pr__pfet_01v8 ad=0.5481 pd=4.36 as=0.5481 ps=4.36 w=1.89 l=0.15
X5 VDD.t1 SA_OUT.t4 SA_OUTB.t0 VDD.t0 sky130_fd_pr__pfet_01v8 ad=0.5481 pd=4.36 as=0.5481 ps=4.36 w=1.89 l=0.15
X6 SA_OUT.t2 SCLK.t2 BL.t0 VDD.t2 sky130_fd_pr__pfet_01v8 ad=0.58 pd=4.58 as=0.58 ps=4.58 w=2 l=0.15
C0 BLB SA_OUT 0.13779f
C1 SA_OUTB SA_OUT 1.9559f
C2 BL BLB 1.56483f
C3 BL SA_OUTB 0.00107f
C4 VDD BLB 0.5704f
C5 VDD SA_OUTB 1.22664f
C6 SCLK SA_OUT 1.26504f
C7 SA_OUTB BLB 0.35628f
C8 SCLK BL 0.25004f
C9 BL SA_OUT 0.32408f
C10 SCLK VDD 0.56947f
C11 VDD SA_OUT 1.24368f
C12 SCLK BLB 0.28508f
C13 VDD BL 1.75917f
C14 SCLK SA_OUTB 1.3794f
R0 BLB BLB.t0 124.849
R1 BL BL.t0 124.34
R2 SCLK.n0 SCLK.t1 568.048
R3 SCLK.n1 SCLK.t2 567.812
R4 SCLK.n0 SCLK.t0 387.146
R5 SCLK SCLK.n1 1.68858
R6 SCLK.n1 SCLK.n0 0.392167
R7 SA_OUT.n1 SA_OUT.t4 549.399
R8 SA_OUT.n0 SA_OUT.t3 387.865
R9 SA_OUT.n3 SA_OUT.t0 144.132
R10 SA_OUT.n0 SA_OUT.t2 124.212
R11 SA_OUT.n2 SA_OUT.t1 94.2167
R12 SA_OUT.n2 SA_OUT.n1 0.4893
R13 SA_OUT.n1 SA_OUT.n0 0.313833
R14 SA_OUT.n3 SA_OUT.n2 0.2355
R15 SA_OUT SA_OUT.n3 0.0247833
R16 SA_OUTB.n3 SA_OUTB.t4 551.263
R17 SA_OUTB.n2 SA_OUTB.t3 386.229
R18 SA_OUTB.n1 SA_OUTB.t0 145.998
R19 SA_OUTB.n0 SA_OUTB.t2 126.606
R20 SA_OUTB.n0 SA_OUTB.t1 92.3521
R21 SA_OUTB.n1 SA_OUTB.n0 0.313833
R22 SA_OUTB.n2 SA_OUTB.n1 0.295033
R23 SA_OUTB.n3 SA_OUTB.n2 0.2355
R24 SA_OUTB SA_OUTB.n3 0.024
R25 VDD.n19 VDD.n18 1789.41
R26 VDD.n16 VDD.n14 1789.41
R27 VDD.n8 VDD.n7 1789.41
R28 VDD.n5 VDD.n3 1789.41
R29 VDD.n44 VDD.n43 1750.59
R30 VDD.n41 VDD.n39 1750.59
R31 VDD.n31 VDD.n30 1750.59
R32 VDD.n28 VDD.n26 1750.59
R33 VDD.n15 VDD.n12 190.871
R34 VDD.n15 VDD.n11 190.871
R35 VDD.n4 VDD.n1 190.871
R36 VDD.n4 VDD.n0 190.871
R37 VDD.n20 VDD.n12 189.742
R38 VDD.n9 VDD.n1 189.742
R39 VDD.n40 VDD.n37 186.73
R40 VDD.n40 VDD.n36 186.73
R41 VDD.n27 VDD.n24 186.73
R42 VDD.n27 VDD.n23 186.73
R43 VDD.n45 VDD.n37 185.601
R44 VDD.n32 VDD.n24 185.601
R45 VDD.n39 VDD.n38 176.815
R46 VDD.n43 VDD.n42 176.815
R47 VDD.n26 VDD.n25 176.815
R48 VDD.n30 VDD.n29 176.815
R49 VDD.n14 VDD.n13 173.642
R50 VDD.n18 VDD.n17 173.642
R51 VDD.n3 VDD.n2 173.642
R52 VDD.n7 VDD.n6 173.642
R53 VDD.n48 VDD.t5 143.498
R54 VDD.n35 VDD.t1 143.498
R55 VDD.n21 VDD.n11 130.26
R56 VDD.n10 VDD.n0 130.26
R57 VDD.n46 VDD.n36 126.118
R58 VDD.n33 VDD.n23 126.118
R59 VDD.n41 VDD.n40 92.5005
R60 VDD.n45 VDD.n44 92.5005
R61 VDD.n28 VDD.n27 92.5005
R62 VDD.n32 VDD.n31 92.5005
R63 VDD.n16 VDD.n15 92.5005
R64 VDD.n20 VDD.n19 92.5005
R65 VDD.n5 VDD.n4 92.5005
R66 VDD.n9 VDD.n8 92.5005
R67 VDD.n19 VDD.n13 79.4196
R68 VDD.n17 VDD.n16 79.4196
R69 VDD.n8 VDD.n2 79.4196
R70 VDD.n6 VDD.n5 79.4196
R71 VDD.n44 VDD.n38 78.9848
R72 VDD.n42 VDD.n41 78.9848
R73 VDD.n31 VDD.n25 78.9848
R74 VDD.n29 VDD.n28 78.9848
R75 VDD.n46 VDD.n45 50.5605
R76 VDD.n33 VDD.n32 50.5605
R77 VDD.n21 VDD.n20 50.5605
R78 VDD.n10 VDD.n9 50.5605
R79 VDD.n47 VDD.n46 47.4734
R80 VDD.n34 VDD.n33 47.4734
R81 VDD.n22 VDD.n21 47.4505
R82 VDD.n22 VDD.n10 32.038
R83 VDD.n43 VDD.n37 23.1255
R84 VDD.n39 VDD.n36 23.1255
R85 VDD.n30 VDD.n24 23.1255
R86 VDD.n26 VDD.n23 23.1255
R87 VDD.n18 VDD.n12 23.1255
R88 VDD.n14 VDD.n11 23.1255
R89 VDD.n7 VDD.n1 23.1255
R90 VDD.n3 VDD.n0 23.1255
R91 VDD.n42 VDD.t4 9.34373
R92 VDD.t4 VDD.n38 9.34373
R93 VDD.n29 VDD.t0 9.34373
R94 VDD.t0 VDD.n25 9.34373
R95 VDD.n17 VDD.t2 8.97701
R96 VDD.t2 VDD.n13 8.97701
R97 VDD.n6 VDD.t3 8.97701
R98 VDD.t3 VDD.n2 8.97701
R99 VDD.n34 VDD.n22 0.627167
R100 VDD VDD.n48 0.532383
R101 VDD.n47 VDD.n35 0.4893
R102 VDD.n35 VDD.n34 0.138367
R103 VDD.n48 VDD.n47 0.138367
R104 VSS.n33 VSS.n29 49773.3
R105 VSS.n29 VSS.n6 48812.2
R106 VSS.n29 VSS.n28 11558.7
R107 VSS.n35 VSS.n3 2294.47
R108 VSS.n31 VSS.n3 2294.47
R109 VSS.n35 VSS.n4 2294.47
R110 VSS.n15 VSS.n7 2294.47
R111 VSS.n11 VSS.n7 2294.47
R112 VSS.n15 VSS.n8 2294.47
R113 VSS.n11 VSS.n8 2294.47
R114 VSS.n22 VSS.n17 2294.47
R115 VSS.n26 VSS.n17 2294.47
R116 VSS.n22 VSS.n18 2294.47
R117 VSS.n26 VSS.n18 2294.47
R118 VSS.n27 VSS.n16 1162.19
R119 VSS.n34 VSS.n5 1162.19
R120 VSS.n32 VSS.n31 327.955
R121 VSS.t1 VSS.n6 314.428
R122 VSS.n16 VSS.t0 314.428
R123 VSS.t0 VSS.n5 314.428
R124 VSS.n13 VSS.n8 292.5
R125 VSS.n8 VSS.t0 292.5
R126 VSS.n10 VSS.n7 292.5
R127 VSS.n7 VSS.t0 292.5
R128 VSS.n4 VSS.n2 292.5
R129 VSS.n3 VSS.n1 292.5
R130 VSS.t3 VSS.n3 292.5
R131 VSS.n24 VSS.n18 292.5
R132 VSS.n18 VSS.t1 292.5
R133 VSS.n19 VSS.n17 292.5
R134 VSS.n17 VSS.t1 292.5
R135 VSS.n34 VSS.n33 276.618
R136 VSS.n32 VSS.n4 222.349
R137 VSS.n28 VSS.t1 199.006
R138 VSS.n36 VSS.n2 149.083
R139 VSS.n30 VSS.n2 149.083
R140 VSS.n14 VSS.n13 149.083
R141 VSS.n13 VSS.n12 149.083
R142 VSS.n25 VSS.n24 149.083
R143 VSS.n24 VSS.n23 149.083
R144 VSS.n30 VSS.n1 147.953
R145 VSS.n12 VSS.n10 147.953
R146 VSS.n25 VSS.n19 147.953
R147 VSS.n12 VSS.n11 117.001
R148 VSS.n11 VSS.n5 117.001
R149 VSS.n15 VSS.n14 117.001
R150 VSS.n16 VSS.n15 117.001
R151 VSS.n31 VSS.n30 117.001
R152 VSS.n36 VSS.n35 117.001
R153 VSS.n35 VSS.n34 117.001
R154 VSS.n26 VSS.n25 117.001
R155 VSS.n27 VSS.n26 117.001
R156 VSS.n23 VSS.n22 117.001
R157 VSS.n22 VSS.n6 117.001
R158 VSS.n28 VSS.n27 115.424
R159 VSS.n20 VSS.t2 93.3938
R160 VSS.n37 VSS.n36 88.4711
R161 VSS.n14 VSS.n9 88.4711
R162 VSS.n23 VSS.n21 88.4711
R163 VSS.n37 VSS.n1 50.5605
R164 VSS.n10 VSS.n9 50.5605
R165 VSS.n21 VSS.n19 50.5605
R166 VSS.t3 VSS.n32 41.8088
R167 VSS.n21 VSS.n20 39.0503
R168 VSS.n33 VSS.t3 37.8114
R169 VSS.n38 VSS.n37 32.5359
R170 VSS.n9 VSS.n0 32.5359
R171 VSS VSS.n38 0.866083
R172 VSS.n38 VSS.n0 0.7055
R173 VSS.n20 VSS.n0 0.6068
R174 a_615_n3098.t0 a_615_n3098.n0 92.9771
R175 a_615_n3098.n0 a_615_n3098.t1 93.4879
R176 a_615_n3098.n0 a_615_n3098.t2 93.6821
C15 BLB VSS 3.331f
C16 BL VSS 3.88111f
C17 SCLK VSS 2.51585f
C18 SA_OUT VSS 2.04799f
C19 SA_OUTB VSS 2.51906f
C20 VDD VSS 7.94865f
C21 a_615_n3098.t0 VSS 0.03295f $ **FLOATING
C22 a_615_n3098.t2 VSS 0.03565f $ **FLOATING
C23 a_615_n3098.t1 VSS 0.03444f $ **FLOATING
C24 a_615_n3098.n0 VSS 0.86053f $ **FLOATING
C25 VDD.n0 VSS 0.03131f $ **FLOATING
C26 VDD.n1 VSS 0.03742f $ **FLOATING
C27 VDD.t3 VSS 0.33629f $ **FLOATING
C28 VDD.n3 VSS 0.24644f $ **FLOATING
C29 VDD.n4 VSS 0.03846f $ **FLOATING
C30 VDD.n5 VSS 0.03846f $ **FLOATING
C31 VDD.n7 VSS 0.24644f $ **FLOATING
C32 VDD.n8 VSS 0.03846f $ **FLOATING
C33 VDD.n9 VSS 0.02633f $ **FLOATING
C34 VDD.n10 VSS 0.03732f $ **FLOATING
C35 VDD.n11 VSS 0.03131f $ **FLOATING
C36 VDD.n12 VSS 0.03742f $ **FLOATING
C37 VDD.t2 VSS 0.33629f $ **FLOATING
C38 VDD.n14 VSS 0.24644f $ **FLOATING
C39 VDD.n15 VSS 0.03846f $ **FLOATING
C40 VDD.n16 VSS 0.03846f $ **FLOATING
C41 VDD.n18 VSS 0.24644f $ **FLOATING
C42 VDD.n19 VSS 0.03846f $ **FLOATING
C43 VDD.n20 VSS 0.02633f $ **FLOATING
C44 VDD.n21 VSS 0.03343f $ **FLOATING
C45 VDD.n22 VSS 0.27113f $ **FLOATING
C46 VDD.n23 VSS 0.03052f $ **FLOATING
C47 VDD.n24 VSS 0.03664f $ **FLOATING
C48 VDD.t0 VSS 0.32624f $ **FLOATING
C49 VDD.n26 VSS 0.24079f $ **FLOATING
C50 VDD.n27 VSS 0.03764f $ **FLOATING
C51 VDD.n28 VSS 0.03764f $ **FLOATING
C52 VDD.n30 VSS 0.24079f $ **FLOATING
C53 VDD.n31 VSS 0.03764f $ **FLOATING
C54 VDD.n32 VSS 0.02592f $ **FLOATING
C55 VDD.n33 VSS 0.03316f $ **FLOATING
C56 VDD.n34 VSS 0.12659f $ **FLOATING
C57 VDD.t1 VSS 0.0512f $ **FLOATING
C58 VDD.n35 VSS 0.21902f $ **FLOATING
C59 VDD.n36 VSS 0.03052f $ **FLOATING
C60 VDD.n37 VSS 0.03664f $ **FLOATING
C61 VDD.t4 VSS 0.32624f $ **FLOATING
C62 VDD.n39 VSS 0.24079f $ **FLOATING
C63 VDD.n40 VSS 0.03764f $ **FLOATING
C64 VDD.n41 VSS 0.03764f $ **FLOATING
C65 VDD.n43 VSS 0.24079f $ **FLOATING
C66 VDD.n44 VSS 0.03764f $ **FLOATING
C67 VDD.n45 VSS 0.02592f $ **FLOATING
C68 VDD.n46 VSS 0.03316f $ **FLOATING
C69 VDD.n47 VSS 0.11533f $ **FLOATING
C70 VDD.t5 VSS 0.0512f $ **FLOATING
C71 VDD.n48 VSS 0.22254f $ **FLOATING
C72 SA_OUTB.t2 VSS 0.24113f $ **FLOATING
C73 SA_OUTB.t1 VSS 0.09441f $ **FLOATING
C74 SA_OUTB.n0 VSS 2.00982f $ **FLOATING
C75 SA_OUTB.t0 VSS 0.21227f $ **FLOATING
C76 SA_OUTB.n1 VSS 1.3092f $ **FLOATING
C77 SA_OUTB.t3 VSS 0.09565f $ **FLOATING
C78 SA_OUTB.n2 VSS 0.27621f $ **FLOATING
C79 SA_OUTB.t4 VSS 0.13807f $ **FLOATING
C80 SA_OUTB.n3 VSS 1.16837f $ **FLOATING
C81 SA_OUT.t2 VSS 0.2189f $ **FLOATING
C82 SA_OUT.t3 VSS 0.10516f $ **FLOATING
C83 SA_OUT.n0 VSS 1.65276f $ **FLOATING
C84 SA_OUT.t4 VSS 0.13928f $ **FLOATING
C85 SA_OUT.n1 VSS 0.96808f $ **FLOATING
C86 SA_OUT.t1 VSS 0.1236f $ **FLOATING
C87 SA_OUT.n2 VSS 0.86981f $ **FLOATING
C88 SA_OUT.t0 VSS 0.20044f $ **FLOATING
C89 SA_OUT.n3 VSS 0.85697f $ **FLOATING
C90 SCLK.t1 VSS 0.13416f $ **FLOATING
C91 SCLK.t0 VSS 0.09497f $ **FLOATING
C92 SCLK.n0 VSS 1.51559f $ **FLOATING
C93 SCLK.t2 VSS 0.13374f $ **FLOATING
C94 SCLK.n1 VSS 1.41652f $ **FLOATING
C95 BL.t0 VSS 0.36035f $ **FLOATING
C96 BLB.t0 VSS 0.27905f $ **FLOATING
.ends
