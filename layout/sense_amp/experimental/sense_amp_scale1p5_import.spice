* Experimental physical sense amplifier: 1.5x regenerative latch/tail sizing.
.subckt sense_amp_scale1p5_sram6t VDD VSS BL BLB SCLK SA_OUT SA_OUTB
XMP1      SA_OUT  SA_OUTB VDD    VDD sky130_fd_pr__pfet_01v8 l=0.15 w=1.89 nf=1 guard=1 full_metal=0 viasrc=100 viadrn=100 viagate=100 viagt=100
XMN1      SA_OUT  SA_OUTB NTAIL  VSS sky130_fd_pr__nfet_01v8 l=0.15 w=0.975 nf=1 guard=1 full_metal=0 viasrc=100 viadrn=100 viagate=100 viagt=100
XMP2      SA_OUTB SA_OUT  VDD    VDD sky130_fd_pr__pfet_01v8 l=0.15 w=1.89 nf=1 guard=1 full_metal=0 viasrc=100 viadrn=100 viagate=100 viagt=100
XMN2      SA_OUTB SA_OUT  NTAIL  VSS sky130_fd_pr__nfet_01v8 l=0.15 w=0.975 nf=1 guard=1 full_metal=0 viasrc=100 viadrn=100 viagate=100 viagt=100
XMSAMPBL  BL      SCLK    SA_OUT VDD sky130_fd_pr__pfet_01v8 l=0.15 w=2.00 nf=1 guard=1 full_metal=0 viasrc=100 viadrn=100 viagate=100 viagt=100
XMSAMPBLB SA_OUTB SCLK    BLB    VDD sky130_fd_pr__pfet_01v8 l=0.15 w=2.00 nf=1 guard=1 full_metal=0 viasrc=100 viadrn=100 viagate=100 viagt=100
XMTAIL    NTAIL   SCLK    VSS    VSS sky130_fd_pr__nfet_01v8 l=0.15 w=0.975 nf=1 guard=1 full_metal=0 viasrc=100 viadrn=100 viagate=100 viagt=100
.ends sense_amp_scale1p5_sram6t
