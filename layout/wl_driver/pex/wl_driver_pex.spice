* NGSPICE file created from wl_driver_flat.ext - technology: sky130A

.subckt wl_driver_flat VDD VSS WL_IN WL
X0 VSS.t3 WL_IN.t0 a_227_n1042.t0 VSS.t2 sky130_fd_pr__nfet_01v8 ad=0.1218 pd=1.42 as=0.1218 ps=1.42 w=0.42 l=0.15
X1 VDD.t1 WL_IN.t1 a_227_n1042.t1 VDD.t0 sky130_fd_pr__pfet_01v8 ad=0.1218 pd=1.42 as=0.1218 ps=1.42 w=0.42 l=0.15
X2 VSS.t1 a_227_n1042.t2 WL.t0 VSS.t0 sky130_fd_pr__nfet_01v8 ad=0.2436 pd=2.26 as=0.2436 ps=2.26 w=0.84 l=0.15
X3 VDD.t3 a_227_n1042.t3 WL.t1 VDD.t2 sky130_fd_pr__pfet_01v8 ad=0.2436 pd=2.26 as=0.2436 ps=2.26 w=0.84 l=0.15
C0 VDD WL_IN 2.02518f
C1 VDD WL 0.24883f
C2 WL_IN WL 0.1678f
R0 WL.n0 WL.t1 341.731
R1 WL.n0 WL.t0 127.841
R2 WL WL.n0 1.27812
R3 WL_IN.n0 WL_IN.t1 311.418
R4 WL_IN.n0 WL_IN.t0 301.378
R5 WL_IN WL_IN.n0 0.43525
R6 VDD.n8 VDD.n7 1380
R7 VDD.n5 VDD.n3 1380
R8 VDD.n20 VDD.n19 1231.76
R9 VDD.n17 VDD.n15 1231.76
R10 VDD.n24 VDD.t1 671.861
R11 VDD.n11 VDD.t3 340.688
R12 VDD.n15 VDD.n14 247.977
R13 VDD.n19 VDD.n18 247.977
R14 VDD.n3 VDD.n2 223.581
R15 VDD.n7 VDD.n6 223.581
R16 VDD.n11 VDD.n10 189.012
R17 VDD.n4 VDD.n1 147.201
R18 VDD.n4 VDD.n0 147.201
R19 VDD.n9 VDD.n1 146.071
R20 VDD.n16 VDD.n13 131.388
R21 VDD.n16 VDD.n12 131.388
R22 VDD.n23 VDD.n22 131
R23 VDD.n21 VDD.n13 130.26
R24 VDD.n17 VDD.n16 92.5005
R25 VDD.n21 VDD.n20 92.5005
R26 VDD.n5 VDD.n4 92.5005
R27 VDD.n9 VDD.n8 92.5005
R28 VDD.n10 VDD.n0 86.5887
R29 VDD.n8 VDD.n2 72.6454
R30 VDD.n6 VDD.n5 72.6454
R31 VDD.n22 VDD.n12 70.777
R32 VDD.n20 VDD.n14 68.7187
R33 VDD.n18 VDD.n17 68.7187
R34 VDD.n22 VDD.n21 50.5605
R35 VDD.n10 VDD.n9 50.5605
R36 VDD.n19 VDD.n13 46.2505
R37 VDD.n15 VDD.n12 46.2505
R38 VDD.n7 VDD.n1 37.0005
R39 VDD.n3 VDD.n0 37.0005
R40 VDD.n18 VDD.t0 18.6229
R41 VDD.t0 VDD.n14 18.6229
R42 VDD.n6 VDD.t2 14.9873
R43 VDD.t2 VDD.n2 14.9873
R44 VDD.n23 VDD.n11 0.5833
R45 VDD VDD.n24 0.532383
R46 VDD.n24 VDD.n23 0.3577
R47 VSS.n18 VSS.n15 40639.1
R48 VSS.n14 VSS.n6 2213.35
R49 VSS.n10 VSS.n6 2213.35
R50 VSS.n14 VSS.n7 2213.35
R51 VSS.n10 VSS.n7 2213.35
R52 VSS.n20 VSS.n3 1970
R53 VSS.n17 VSS.n3 1970
R54 VSS.n20 VSS.n4 1970
R55 VSS.n17 VSS.n4 1970
R56 VSS.n19 VSS.n5 1671.51
R57 VSS.n15 VSS.t0 298.755
R58 VSS.t0 VSS.n5 298.755
R59 VSS.n19 VSS.t2 298.755
R60 VSS.t2 VSS.n18 298.755
R61 VSS.n4 VSS.n2 292.5
R62 VSS.t2 VSS.n4 292.5
R63 VSS.n3 VSS.n1 292.5
R64 VSS.t2 VSS.n3 292.5
R65 VSS.n12 VSS.n7 292.5
R66 VSS.n7 VSS.t0 292.5
R67 VSS.n9 VSS.n6 292.5
R68 VSS.n6 VSS.t0 292.5
R69 VSS.n24 VSS.t3 245.071
R70 VSS.n17 VSS.n16 146.25
R71 VSS.n18 VSS.n17 146.25
R72 VSS.n21 VSS.n20 146.25
R73 VSS.n20 VSS.n19 146.25
R74 VSS.n12 VSS.n11 143.812
R75 VSS.n13 VSS.n12 143.812
R76 VSS.n11 VSS.n9 142.683
R77 VSS.n21 VSS.n2 128
R78 VSS.n16 VSS.n2 128
R79 VSS.n0 VSS.t1 127.189
R80 VSS.n16 VSS.n1 126.871
R81 VSS.n11 VSS.n10 117.001
R82 VSS.n10 VSS.n5 117.001
R83 VSS.n14 VSS.n13 117.001
R84 VSS.n15 VSS.n14 117.001
R85 VSS.n8 VSS.n0 93.5908
R86 VSS.n23 VSS.n22 86.8401
R87 VSS.n13 VSS.n8 83.2005
R88 VSS.n22 VSS.n21 67.3887
R89 VSS.n22 VSS.n1 50.5605
R90 VSS.n9 VSS.n8 50.5605
R91 VSS VSS.n24 0.767383
R92 VSS.n23 VSS.n0 0.692967
R93 VSS.n24 VSS.n23 0.248033
R94 a_227_n1042.t0 a_227_n1042.n1 245.904
R95 a_227_n1042.n1 a_227_n1042.n0 0.802633
R96 a_227_n1042.n0 a_227_n1042.t2 365.646
R97 a_227_n1042.n0 a_227_n1042.t3 380.469
R98 a_227_n1042.n1 a_227_n1042.t1 672.721
C3 WL VSS 1.85772f
C4 WL_IN VSS 1.70777f
C5 VDD VSS 4.23566f
C6 a_227_n1042.t0 VSS 0.03981f $ **FLOATING
C7 a_227_n1042.t1 VSS 0.03437f $ **FLOATING
C8 a_227_n1042.t3 VSS 0.08695f $ **FLOATING
C9 a_227_n1042.n0 VSS 1.59251f $ **FLOATING
C10 a_227_n1042.t2 VSS 0.08353f $ **FLOATING
C11 a_227_n1042.n1 VSS 1.56012f $ **FLOATING
C12 VDD.n0 VSS 0.02758f $ **FLOATING
C13 VDD.n1 VSS 0.03505f $ **FLOATING
C14 VDD.t2 VSS 0.2979f $ **FLOATING
C15 VDD.n3 VSS 0.21308f $ **FLOATING
C16 VDD.n4 VSS 0.03574f $ **FLOATING
C17 VDD.n5 VSS 0.03574f $ **FLOATING
C18 VDD.n7 VSS 0.21308f $ **FLOATING
C19 VDD.n8 VSS 0.03574f $ **FLOATING
C20 VDD.n9 VSS 0.02638f $ **FLOATING
C21 VDD.n10 VSS 0.05172f $ **FLOATING
C22 VDD.t3 VSS 0.02598f $ **FLOATING
C23 VDD.n11 VSS 0.49379f $ **FLOATING
C24 VDD.n12 VSS 0.024f $ **FLOATING
C25 VDD.n13 VSS 0.03155f $ **FLOATING
C26 VDD.t0 VSS 0.25964f $ **FLOATING
C27 VDD.n15 VSS 0.1834f $ **FLOATING
C28 VDD.n16 VSS 0.03195f $ **FLOATING
C29 VDD.n17 VSS 0.03195f $ **FLOATING
C30 VDD.n19 VSS 0.1834f $ **FLOATING
C31 VDD.n20 VSS 0.03195f $ **FLOATING
C32 VDD.n21 VSS 0.02448f $ **FLOATING
C33 VDD.n22 VSS 0.04163f $ **FLOATING
C34 VDD.n23 VSS 0.21286f $ **FLOATING
C35 VDD.t1 VSS 0.01276f $ **FLOATING
C36 VDD.n24 VSS 0.23313f $ **FLOATING
C37 WL_IN.t0 VSS 0.1015f $ **FLOATING
C38 WL_IN.t1 VSS 0.08221f $ **FLOATING
C39 WL_IN.n0 VSS 2.57087f $ **FLOATING
C40 WL.t0 VSS 0.08067f $ **FLOATING
C41 WL.t1 VSS 0.07112f $ **FLOATING
C42 WL.n0 VSS 1.88168f $ **FLOATING
.ends
