* NGSPICE file created from wl_driver_s1p68_s2p5p04_flat.ext - technology: sky130A

.subckt wl_driver_s1p68_s2p5p04_flat VDD VSS WL_IN WL
X0 VSS.t1 a_227_n1168.t2 WL.t0 VSS.t0 sky130_fd_pr__nfet_01v8 ad=1.4616 pd=10.66 as=1.4616 ps=10.66 w=5.04 l=0.15
X1 VSS.t3 WL_IN.t0 a_227_n1168.t0 VSS.t2 sky130_fd_pr__nfet_01v8 ad=0.4872 pd=3.94 as=0.4872 ps=3.94 w=1.68 l=0.15
X2 VDD.t1 a_227_n1168.t3 WL.t1 VDD.t0 sky130_fd_pr__pfet_01v8 ad=1.4616 pd=10.66 as=1.4616 ps=10.66 w=5.04 l=0.15
X3 VDD.t3 WL_IN.t1 a_227_n1168.t1 VDD.t2 sky130_fd_pr__pfet_01v8 ad=0.4872 pd=3.94 as=0.4872 ps=3.94 w=1.68 l=0.15
C0 WL VDD 1.28413f
C1 WL WL_IN 0.15562f
C2 VDD WL_IN 2.30499f
R0 WL.n0 WL.t1 57.9799
R1 WL.n0 WL.t0 26.7658
R2 WL WL.n0 0.908607
R3 WL_IN.n0 WL_IN.t1 509.627
R4 WL_IN.n0 WL_IN.t0 499.103
R5 WL_IN WL_IN.n0 4.11985
R6 VDD.n0 VDD.t0 192.837
R7 VDD.n1 VDD.t2 189.296
R8 VDD.n2 VDD.t3 145.452
R9 VDD.n0 VDD.t1 57.2359
R10 VDD.n1 VDD.n0 0.421262
R11 VDD VDD.n2 0.384893
R12 VDD.n2 VDD.n1 0.251167
R13 VSS.n10 VSS.n9 113849
R14 VSS.n8 VSS.n4 4646.88
R15 VSS.n6 VSS.n4 4646.88
R16 VSS.n8 VSS.n7 4646.88
R17 VSS.n7 VSS.n6 4646.88
R18 VSS.n12 VSS.n2 2700.06
R19 VSS.n11 VSS.n2 2700.06
R20 VSS.n11 VSS.n1 2700.06
R21 VSS.n12 VSS.n1 2700.06
R22 VSS.n5 VSS.n3 1953.59
R23 VSS.n9 VSS.t0 349.171
R24 VSS.n5 VSS.t0 349.171
R25 VSS.t2 VSS.n3 349.171
R26 VSS.t2 VSS.n10 349.171
R27 VSS.n4 VSS.n0 306.214
R28 VSS.n13 VSS.n12 305.462
R29 VSS.n7 VSS.t0 292.5
R30 VSS.n4 VSS.t0 292.5
R31 VSS.t2 VSS.n11 292.5
R32 VSS.n12 VSS.t2 292.5
R33 VSS.n10 VSS.n2 83.5719
R34 VSS.n3 VSS.n1 83.5719
R35 VSS.n14 VSS.t3 58.6572
R36 VSS.n6 VSS.n5 34.4123
R37 VSS.n9 VSS.n8 34.4123
R38 VSS.n0 VSS.t1 26.3004
R39 VSS VSS.n14 0.55275
R40 VSS.n13 VSS.n0 0.499595
R41 VSS.n14 VSS.n13 0.172833
R42 a_227_n1168.t0 a_227_n1168.n1 59.2525
R43 a_227_n1168.n1 a_227_n1168.n0 3.98793
R44 a_227_n1168.n1 a_227_n1168.t1 146.066
R45 a_227_n1168.n0 a_227_n1168.t2 1036.6
R46 a_227_n1168.n0 a_227_n1168.t3 1051.8
C3 WL VSS 3.3158f
C4 WL_IN VSS 3.38113f
C5 VDD VSS 6.13805f
C6 a_227_n1168.t0 VSS 0.1956f $ **FLOATING
C7 a_227_n1168.t3 VSS 0.19107f $ **FLOATING
C8 a_227_n1168.t2 VSS 0.18786f $ **FLOATING
C9 a_227_n1168.n0 VSS 1.61866f $ **FLOATING
C10 a_227_n1168.t1 VSS 0.15406f $ **FLOATING
C11 a_227_n1168.n1 VSS 3.16888f $ **FLOATING
C12 VDD.t0 VSS 1.85658f $ **FLOATING
C13 VDD.t1 VSS 0.21882f $ **FLOATING
C14 VDD.n0 VSS 0.98729f $ **FLOATING
C15 VDD.t2 VSS 1.0127f $ **FLOATING
C16 VDD.n1 VSS 0.4319f $ **FLOATING
C17 VDD.t3 VSS 0.06553f $ **FLOATING
C18 VDD.n2 VSS 0.43385f $ **FLOATING
C19 WL_IN.t0 VSS 0.10478f $ **FLOATING
C20 WL_IN.t1 VSS 0.10146f $ **FLOATING
C21 WL_IN.n0 VSS 1.84361f $ **FLOATING
C22 WL.t0 VSS 0.53136f $ **FLOATING
C23 WL.t1 VSS 0.42612f $ **FLOATING
C24 WL.n0 VSS 2.59411f $ **FLOATING
.ends
