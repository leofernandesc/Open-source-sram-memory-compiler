* NGSPICE file created from wl_driver_s1p68_s2p5p04_flat.ext - technology: sky130A

.subckt wl_driver_s1p68_s2p5p04_flat VDD VSS WL_IN WL
X0 VSS a_227_n1168# WL VSS sky130_fd_pr__nfet_01v8 ad=1.4616 pd=10.66 as=1.4616 ps=10.66 w=5.04 l=0.15
X1 VSS WL_IN a_227_n1168# VSS sky130_fd_pr__nfet_01v8 ad=0.4872 pd=3.94 as=0.4872 ps=3.94 w=1.68 l=0.15
X2 VDD a_227_n1168# WL VDD sky130_fd_pr__pfet_01v8 ad=1.4616 pd=10.66 as=1.4616 ps=10.66 w=5.04 l=0.15
X3 VDD WL_IN a_227_n1168# VDD sky130_fd_pr__pfet_01v8 ad=0.4872 pd=3.94 as=0.4872 ps=3.94 w=1.68 l=0.15
.ends
