* Structural LVS reference for one physical 8-bit SRAM row.
.subckt row_8_wl_reference VDD VSS WL BL0 BLB0 BL1 BLB1 BL2 BLB2 BL3 BLB3 BL4 BLB4 BL5 BLB5 BL6 BLB6 BL7 BLB7
XBC0 VDD BL0 BLB0 VSS WL bitcell_6t_flat
XBC1 VDD BL1 BLB1 VSS WL bitcell_6t_flat
XBC2 VDD BL2 BLB2 VSS WL bitcell_6t_flat
XBC3 VDD BL3 BLB3 VSS WL bitcell_6t_flat
XBC4 VDD BL4 BLB4 VSS WL bitcell_6t_flat
XBC5 VDD BL5 BLB5 VSS WL bitcell_6t_flat
XBC6 VDD BL6 BLB6 VSS WL bitcell_6t_flat
XBC7 VDD BL7 BLB7 VSS WL bitcell_6t_flat
.ends row_8_wl_reference
