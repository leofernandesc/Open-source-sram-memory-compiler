* NGSPICE file created from row_8_wl_flat.ext - technology: sky130A

.subckt row_8_wl_flat VDD VSS WL BL0 BLB0 BL1 BLB1 BL2 BLB2 BL3 BLB3 BL4 BLB4 BL5
+ BLB5 BL6 BLB6 BL7 BLB7
X0 a_3686_940.t2 a_3733_1036.t3 VSS.t23 VSS.t22 sky130_fd_pr__nfet_01v8 ad=0.3591 pd=3.09 as=0.3591 ps=3.09 w=1.26 l=0.15
X1 BLB3.t0 WL.t8 a_9906_940.t2 VSS.t39 sky130_fd_pr__nfet_01v8 ad=0.171 pd=1.77 as=0.171 ps=1.77 w=0.6 l=0.15
X2 a_16173_1036.t0 a_16126_940.t3 VSS.t11 VSS.t10 sky130_fd_pr__nfet_01v8 ad=0.3591 pd=3.09 as=0.3591 ps=3.09 w=1.26 l=0.15
X3 a_6796_940.t0 a_6843_1036.t4 VDD.t13 VDD.t12 sky130_fd_pr__pfet_01v8 ad=0.1197 pd=1.41 as=0.1197 ps=1.41 w=0.42 l=0.15
X4 a_13063_1036.t0 a_13016_940.t4 VDD.t19 VDD.t18 sky130_fd_pr__pfet_01v8 ad=0.1197 pd=1.41 as=0.1197 ps=1.41 w=0.42 l=0.15
X5 a_3733_1036.t0 a_3686_940.t3 VSS.t25 VSS.t24 sky130_fd_pr__nfet_01v8 ad=0.3591 pd=3.09 as=0.3591 ps=3.09 w=1.26 l=0.15
X6 BL2.t0 WL.t11 a_6843_1036.t2 VSS.t36 sky130_fd_pr__nfet_01v8 ad=0.171 pd=1.77 as=0.171 ps=1.77 w=0.6 l=0.15
X7 a_9906_940.t1 a_9953_1036.t3 VSS.t13 VSS.t12 sky130_fd_pr__nfet_01v8 ad=0.3591 pd=3.09 as=0.3591 ps=3.09 w=1.26 l=0.15
X8 a_19236_940.t1 a_19283_1036.t4 VDD.t3 VDD.t2 sky130_fd_pr__pfet_01v8 ad=0.1197 pd=1.41 as=0.1197 ps=1.41 w=0.42 l=0.15
X9 BLB7.t0 WL.t0 a_22346_940.t0 VSS.t47 sky130_fd_pr__nfet_01v8 ad=0.171 pd=1.77 as=0.171 ps=1.77 w=0.6 l=0.15
X10 BLB6.t0 WL.t2 a_19236_940.t0 VSS.t45 sky130_fd_pr__nfet_01v8 ad=0.171 pd=1.77 as=0.171 ps=1.77 w=0.6 l=0.15
X11 a_576_940.t1 a_623_1036.t3 VSS.t5 VSS.t4 sky130_fd_pr__nfet_01v8 ad=0.3591 pd=3.09 as=0.3591 ps=3.09 w=1.26 l=0.15
X12 a_13063_1036.t1 a_13016_940.t3 VSS.t31 VSS.t30 sky130_fd_pr__nfet_01v8 ad=0.3591 pd=3.09 as=0.3591 ps=3.09 w=1.26 l=0.15
X13 a_22346_940.t1 a_22393_1036.t4 VDD.t1 VDD.t0 sky130_fd_pr__pfet_01v8 ad=0.1197 pd=1.41 as=0.1197 ps=1.41 w=0.42 l=0.15
X14 BLB2.t0 WL.t10 a_6796_940.t2 VSS.t37 sky130_fd_pr__nfet_01v8 ad=0.171 pd=1.77 as=0.171 ps=1.77 w=0.6 l=0.15
X15 a_16173_1036.t1 a_16126_940.t4 VDD.t5 VDD.t4 sky130_fd_pr__pfet_01v8 ad=0.1197 pd=1.41 as=0.1197 ps=1.41 w=0.42 l=0.15
X16 BL7.t0 WL.t1 a_22393_1036.t2 VSS.t46 sky130_fd_pr__nfet_01v8 ad=0.171 pd=1.77 as=0.171 ps=1.77 w=0.6 l=0.15
X17 a_22346_940.t2 a_22393_1036.t3 VSS.t1 VSS.t0 sky130_fd_pr__nfet_01v8 ad=0.3591 pd=3.09 as=0.3591 ps=3.09 w=1.26 l=0.15
X18 a_3733_1036.t1 a_3686_940.t4 VDD.t29 VDD.t28 sky130_fd_pr__pfet_01v8 ad=0.1197 pd=1.41 as=0.1197 ps=1.41 w=0.42 l=0.15
X19 a_3686_940.t1 a_3733_1036.t4 VDD.t23 VDD.t22 sky130_fd_pr__pfet_01v8 ad=0.1197 pd=1.41 as=0.1197 ps=1.41 w=0.42 l=0.15
X20 a_623_1036.t0 a_576_940.t3 VSS.t27 VSS.t26 sky130_fd_pr__nfet_01v8 ad=0.3591 pd=3.09 as=0.3591 ps=3.09 w=1.26 l=0.15
X21 BL1.t0 WL.t13 a_3733_1036.t2 VSS.t34 sky130_fd_pr__nfet_01v8 ad=0.171 pd=1.77 as=0.171 ps=1.77 w=0.6 l=0.15
X22 BLB5.t0 WL.t4 a_16126_940.t2 VSS.t43 sky130_fd_pr__nfet_01v8 ad=0.171 pd=1.77 as=0.171 ps=1.77 w=0.6 l=0.15
X23 a_16126_940.t0 a_16173_1036.t4 VDD.t17 VDD.t16 sky130_fd_pr__pfet_01v8 ad=0.1197 pd=1.41 as=0.1197 ps=1.41 w=0.42 l=0.15
X24 a_19283_1036.t1 a_19236_940.t4 VDD.t25 VDD.t24 sky130_fd_pr__pfet_01v8 ad=0.1197 pd=1.41 as=0.1197 ps=1.41 w=0.42 l=0.15
X25 BL5.t0 WL.t5 a_16173_1036.t2 VSS.t42 sky130_fd_pr__nfet_01v8 ad=0.171 pd=1.77 as=0.171 ps=1.77 w=0.6 l=0.15
X26 a_9953_1036.t0 a_9906_940.t3 VSS.t15 VSS.t14 sky130_fd_pr__nfet_01v8 ad=0.3591 pd=3.09 as=0.3591 ps=3.09 w=1.26 l=0.15
X27 a_22393_1036.t1 a_22346_940.t4 VDD.t9 VDD.t8 sky130_fd_pr__pfet_01v8 ad=0.1197 pd=1.41 as=0.1197 ps=1.41 w=0.42 l=0.15
X28 BLB1.t0 WL.t12 a_3686_940.t0 VSS.t35 sky130_fd_pr__nfet_01v8 ad=0.171 pd=1.77 as=0.171 ps=1.77 w=0.6 l=0.15
X29 a_6843_1036.t1 a_6796_940.t4 VDD.t21 VDD.t20 sky130_fd_pr__pfet_01v8 ad=0.1197 pd=1.41 as=0.1197 ps=1.41 w=0.42 l=0.15
X30 a_16126_940.t1 a_16173_1036.t3 VSS.t7 VSS.t6 sky130_fd_pr__nfet_01v8 ad=0.3591 pd=3.09 as=0.3591 ps=3.09 w=1.26 l=0.15
X31 BL6.t0 WL.t3 a_19283_1036.t2 VSS.t44 sky130_fd_pr__nfet_01v8 ad=0.171 pd=1.77 as=0.171 ps=1.77 w=0.6 l=0.15
X32 a_576_940.t0 a_623_1036.t4 VDD.t31 VDD.t30 sky130_fd_pr__pfet_01v8 ad=0.1197 pd=1.41 as=0.1197 ps=1.41 w=0.42 l=0.15
X33 a_19236_940.t2 a_19283_1036.t3 VSS.t9 VSS.t8 sky130_fd_pr__nfet_01v8 ad=0.3591 pd=3.09 as=0.3591 ps=3.09 w=1.26 l=0.15
X34 BL0.t0 WL.t15 a_623_1036.t2 VSS.t32 sky130_fd_pr__nfet_01v8 ad=0.171 pd=1.77 as=0.171 ps=1.77 w=0.6 l=0.15
X35 a_6796_940.t1 a_6843_1036.t3 VSS.t17 VSS.t16 sky130_fd_pr__nfet_01v8 ad=0.3591 pd=3.09 as=0.3591 ps=3.09 w=1.26 l=0.15
X36 BLB4.t0 WL.t6 a_13016_940.t2 VSS.t41 sky130_fd_pr__nfet_01v8 ad=0.171 pd=1.77 as=0.171 ps=1.77 w=0.6 l=0.15
X37 a_19283_1036.t0 a_19236_940.t3 VSS.t19 VSS.t18 sky130_fd_pr__nfet_01v8 ad=0.3591 pd=3.09 as=0.3591 ps=3.09 w=1.26 l=0.15
X38 a_9953_1036.t1 a_9906_940.t4 VDD.t11 VDD.t10 sky130_fd_pr__pfet_01v8 ad=0.1197 pd=1.41 as=0.1197 ps=1.41 w=0.42 l=0.15
X39 a_13016_940.t0 a_13063_1036.t4 VDD.t7 VDD.t6 sky130_fd_pr__pfet_01v8 ad=0.1197 pd=1.41 as=0.1197 ps=1.41 w=0.42 l=0.15
X40 a_22393_1036.t0 a_22346_940.t3 VSS.t3 VSS.t2 sky130_fd_pr__nfet_01v8 ad=0.3591 pd=3.09 as=0.3591 ps=3.09 w=1.26 l=0.15
X41 a_9906_940.t0 a_9953_1036.t4 VDD.t27 VDD.t26 sky130_fd_pr__pfet_01v8 ad=0.1197 pd=1.41 as=0.1197 ps=1.41 w=0.42 l=0.15
X42 a_623_1036.t1 a_576_940.t4 VDD.t15 VDD.t14 sky130_fd_pr__pfet_01v8 ad=0.1197 pd=1.41 as=0.1197 ps=1.41 w=0.42 l=0.15
X43 BL3.t0 WL.t9 a_9953_1036.t2 VSS.t38 sky130_fd_pr__nfet_01v8 ad=0.171 pd=1.77 as=0.171 ps=1.77 w=0.6 l=0.15
X44 BL4.t0 WL.t7 a_13063_1036.t2 VSS.t40 sky130_fd_pr__nfet_01v8 ad=0.171 pd=1.77 as=0.171 ps=1.77 w=0.6 l=0.15
X45 BLB0.t0 WL.t14 a_576_940.t2 VSS.t33 sky130_fd_pr__nfet_01v8 ad=0.171 pd=1.77 as=0.171 ps=1.77 w=0.6 l=0.15
X46 a_6843_1036.t0 a_6796_940.t3 VSS.t21 VSS.t20 sky130_fd_pr__nfet_01v8 ad=0.3591 pd=3.09 as=0.3591 ps=3.09 w=1.26 l=0.15
X47 a_13016_940.t1 a_13063_1036.t3 VSS.t29 VSS.t28 sky130_fd_pr__nfet_01v8 ad=0.3591 pd=3.09 as=0.3591 ps=3.09 w=1.26 l=0.15
C0 BLB7 WL 0.42083f
C1 BL6 BLB5 0.00137f
C2 VDD BLB0 0.00348f
C3 BLB1 BLB2 0.03174f
C4 WL BLB4 0.42239f
C5 VDD BLB1 0.00348f
C6 BLB7 BL7 1.72651f
C7 WL BL5 2.42459f
C8 WL BLB2 0.42239f
C9 VDD BLB6 0.00348f
C10 BLB3 WL 0.42239f
C11 VDD WL 0.06322f
C12 BL6 BL5 0.03171f
C13 VDD BL1 0.00345f
C14 VDD BL6 0.00345f
C15 BL7 VDD 0.00345f
C16 BLB1 BLB0 0.03174f
C17 BL3 BLB2 0.00137f
C18 BLB3 BL3 1.72651f
C19 BL3 VDD 0.00345f
C20 VDD BL0 0.00345f
C21 BL4 WL 2.42459f
C22 BLB2 BL2 1.72651f
C23 VDD BL2 0.00345f
C24 BLB4 BLB5 0.03174f
C25 WL BLB0 0.42239f
C26 BL1 BLB0 0.00137f
C27 WL BLB1 0.42239f
C28 BL5 BLB5 1.72651f
C29 BL1 BLB1 1.72651f
C30 BL4 BL3 0.03171f
C31 VDD BLB5 0.00348f
C32 WL BLB6 0.42239f
C33 BLB7 VDD 0.00303f
C34 BL0 BLB0 1.72651f
C35 BL5 BLB4 0.00137f
C36 BLB6 BL6 1.72651f
C37 WL BL1 2.42459f
C38 BLB3 BLB4 0.03174f
C39 VDD BLB4 0.00348f
C40 WL BL6 2.42459f
C41 BL7 BLB6 0.00137f
C42 BL7 WL 2.42459f
C43 BLB1 BL2 0.00137f
C44 BL7 BL6 0.03171f
C45 VDD BL5 0.00345f
C46 BLB3 BLB2 0.03174f
C47 VDD BLB2 0.00348f
C48 BL3 WL 2.42459f
C49 BLB3 VDD 0.00348f
C50 WL BL0 2.42459f
C51 WL BL2 2.42459f
C52 BL1 BL0 0.03171f
C53 BL4 BLB4 1.72651f
C54 BL1 BL2 0.03171f
C55 BL4 BL5 0.03171f
C56 BLB6 BLB5 0.03174f
C57 BLB3 BL4 0.00137f
C58 BL4 VDD 0.00345f
C59 WL BLB5 0.42239f
C60 BL3 BL2 0.03171f
C61 BLB7 BLB6 0.03174f
R0 BLB7.n0 BLB7.t0 233.885
R1 BLB7.n0 BLB7 3.42812
R2 BLB7 BLB7.n0 0.0151875
R3 BL7.n0 BL7.t0 233.452
R4 BL7.n0 BL7 3.42812
R5 BL7 BL7.n0 0.0151875
R6 BLB6.n0 BLB6.t0 233.885
R7 BLB6.n0 BLB6 3.42812
R8 BLB6 BLB6.n0 0.0151875
R9 BL6.n0 BL6.t0 233.452
R10 BL6.n0 BL6 3.42812
R11 BL6 BL6.n0 0.0151875
R12 BLB5.n0 BLB5.t0 233.885
R13 BLB5.n0 BLB5 3.42812
R14 BLB5 BLB5.n0 0.0151875
R15 BL5.n0 BL5.t0 233.452
R16 BL5.n0 BL5 3.42812
R17 BL5 BL5.n0 0.0151875
R18 BLB4.n0 BLB4.t0 233.885
R19 BLB4.n0 BLB4 3.42812
R20 BLB4 BLB4.n0 0.0151875
R21 BL4.n0 BL4.t0 233.452
R22 BL4.n0 BL4 3.42812
R23 BL4 BL4.n0 0.0151875
R24 BLB3.n0 BLB3.t0 233.885
R25 BLB3.n0 BLB3 3.42812
R26 BLB3 BLB3.n0 0.0151875
R27 BL3.n0 BL3.t0 233.452
R28 BL3.n0 BL3 3.42812
R29 BL3 BL3.n0 0.0151875
R30 BLB2.n0 BLB2.t0 233.885
R31 BLB2.n0 BLB2 3.42812
R32 BLB2 BLB2.n0 0.0151875
R33 BL2.n0 BL2.t0 233.452
R34 BL2.n0 BL2 3.42812
R35 BL2 BL2.n0 0.0151875
R36 BLB1.n0 BLB1.t0 233.885
R37 BLB1.n0 BLB1 3.42812
R38 BLB1 BLB1.n0 0.0151875
R39 BL1.n0 BL1.t0 233.452
R40 BL1.n0 BL1 3.42812
R41 BL1 BL1.n0 0.0151875
R42 BLB0.n0 BLB0.t0 233.885
R43 BLB0.n0 BLB0 3.42812
R44 BLB0 BLB0.n0 0.0151875
R45 BL0.n0 BL0.t0 233.452
R46 BL0.n0 BL0 3.42812
R47 BL0 BL0.n0 0.0151875
R48 WL.n1 WL.t14 330.012
R49 WL.n4 WL.t12 330.012
R50 WL.n7 WL.t10 330.012
R51 WL.n10 WL.t8 330.012
R52 WL.n13 WL.t6 330.012
R53 WL.n16 WL.t4 330.012
R54 WL.n19 WL.t2 330.012
R55 WL.n0 WL.t0 330.012
R56 WL.n1 WL.t15 329.848
R57 WL.n4 WL.t13 329.848
R58 WL.n7 WL.t11 329.848
R59 WL.n10 WL.t9 329.848
R60 WL.n13 WL.t7 329.848
R61 WL.n16 WL.t5 329.848
R62 WL.n19 WL.t3 329.848
R63 WL.n0 WL.t1 329.848
R64 WL.n22 WL.n21 5.23762
R65 WL.n21 WL.n20 3.4105
R66 WL.n18 WL.n17 3.4105
R67 WL.n15 WL.n14 3.4105
R68 WL.n12 WL.n11 3.4105
R69 WL.n9 WL.n8 3.4105
R70 WL.n6 WL.n5 3.4105
R71 WL.n3 WL.n2 3.4105
R72 WL.n21 WL.n18 1.82762
R73 WL.n18 WL.n15 1.82762
R74 WL.n15 WL.n12 1.82762
R75 WL.n12 WL.n9 1.82762
R76 WL.n9 WL.n6 1.82762
R77 WL.n6 WL.n3 1.82762
R78 WL.n2 WL.n1 1.4575
R79 WL.n5 WL.n4 1.4575
R80 WL.n8 WL.n7 1.4575
R81 WL.n11 WL.n10 1.4575
R82 WL.n14 WL.n13 1.4575
R83 WL.n17 WL.n16 1.4575
R84 WL.n20 WL.n19 1.4575
R85 WL.n22 WL.n0 1.4575
R86 WL.n3 WL 0.170875
R87 WL.n2 WL 0.0151875
R88 WL.n5 WL 0.0151875
R89 WL.n8 WL 0.0151875
R90 WL.n11 WL 0.0151875
R91 WL.n14 WL 0.0151875
R92 WL.n17 WL 0.0151875
R93 WL.n20 WL 0.0151875
R94 WL WL.n22 0.0151875
R95 VDD.n13 VDD.n5 1224.71
R96 VDD.n9 VDD.n6 1224.71
R97 VDD.n13 VDD.n6 1224.71
R98 VDD.n20 VDD.n2 1224.71
R99 VDD.n20 VDD.n3 1224.71
R100 VDD.n16 VDD.n3 1224.71
R101 VDD.n16 VDD.n2 1224.71
R102 VDD.n36 VDD.n28 1224.71
R103 VDD.n32 VDD.n29 1224.71
R104 VDD.n36 VDD.n29 1224.71
R105 VDD.n43 VDD.n25 1224.71
R106 VDD.n43 VDD.n26 1224.71
R107 VDD.n39 VDD.n26 1224.71
R108 VDD.n39 VDD.n25 1224.71
R109 VDD.n59 VDD.n51 1224.71
R110 VDD.n55 VDD.n52 1224.71
R111 VDD.n59 VDD.n52 1224.71
R112 VDD.n66 VDD.n48 1224.71
R113 VDD.n66 VDD.n49 1224.71
R114 VDD.n62 VDD.n49 1224.71
R115 VDD.n62 VDD.n48 1224.71
R116 VDD.n82 VDD.n74 1224.71
R117 VDD.n78 VDD.n75 1224.71
R118 VDD.n82 VDD.n75 1224.71
R119 VDD.n89 VDD.n71 1224.71
R120 VDD.n89 VDD.n72 1224.71
R121 VDD.n85 VDD.n72 1224.71
R122 VDD.n85 VDD.n71 1224.71
R123 VDD.n105 VDD.n97 1224.71
R124 VDD.n101 VDD.n98 1224.71
R125 VDD.n105 VDD.n98 1224.71
R126 VDD.n112 VDD.n94 1224.71
R127 VDD.n112 VDD.n95 1224.71
R128 VDD.n108 VDD.n95 1224.71
R129 VDD.n108 VDD.n94 1224.71
R130 VDD.n128 VDD.n120 1224.71
R131 VDD.n124 VDD.n121 1224.71
R132 VDD.n128 VDD.n121 1224.71
R133 VDD.n135 VDD.n117 1224.71
R134 VDD.n135 VDD.n118 1224.71
R135 VDD.n131 VDD.n118 1224.71
R136 VDD.n131 VDD.n117 1224.71
R137 VDD.n151 VDD.n143 1224.71
R138 VDD.n147 VDD.n144 1224.71
R139 VDD.n151 VDD.n144 1224.71
R140 VDD.n158 VDD.n140 1224.71
R141 VDD.n158 VDD.n141 1224.71
R142 VDD.n154 VDD.n141 1224.71
R143 VDD.n154 VDD.n140 1224.71
R144 VDD.n174 VDD.n166 1224.71
R145 VDD.n170 VDD.n167 1224.71
R146 VDD.n174 VDD.n167 1224.71
R147 VDD.n181 VDD.n163 1224.71
R148 VDD.n181 VDD.n164 1224.71
R149 VDD.n177 VDD.n164 1224.71
R150 VDD.n177 VDD.n163 1224.71
R151 VDD.n1 VDD.t31 669.717
R152 VDD.n24 VDD.t23 669.717
R153 VDD.n47 VDD.t13 669.717
R154 VDD.n70 VDD.t27 669.717
R155 VDD.n93 VDD.t7 669.717
R156 VDD.n116 VDD.t17 669.717
R157 VDD.n139 VDD.t3 669.717
R158 VDD.n0 VDD.t1 669.717
R159 VDD.n1 VDD.t15 669.297
R160 VDD.n24 VDD.t29 669.297
R161 VDD.n47 VDD.t21 669.297
R162 VDD.n70 VDD.t11 669.297
R163 VDD.n93 VDD.t19 669.297
R164 VDD.n116 VDD.t5 669.297
R165 VDD.n139 VDD.t25 669.297
R166 VDD.n0 VDD.t9 669.297
R167 VDD VDD.n21 615.63
R168 VDD VDD.n44 615.63
R169 VDD VDD.n67 615.63
R170 VDD VDD.n90 615.63
R171 VDD VDD.n113 615.63
R172 VDD VDD.n136 615.63
R173 VDD VDD.n159 615.63
R174 VDD VDD.n182 615.63
R175 VDD.n14 VDD.t30 319.38
R176 VDD.n15 VDD.t14 319.38
R177 VDD.n21 VDD.t14 319.38
R178 VDD.n37 VDD.t22 319.38
R179 VDD.n38 VDD.t28 319.38
R180 VDD.n44 VDD.t28 319.38
R181 VDD.n60 VDD.t12 319.38
R182 VDD.n61 VDD.t20 319.38
R183 VDD.n67 VDD.t20 319.38
R184 VDD.n83 VDD.t26 319.38
R185 VDD.n84 VDD.t10 319.38
R186 VDD.n90 VDD.t10 319.38
R187 VDD.n106 VDD.t6 319.38
R188 VDD.n107 VDD.t18 319.38
R189 VDD.n113 VDD.t18 319.38
R190 VDD.n129 VDD.t16 319.38
R191 VDD.n130 VDD.t4 319.38
R192 VDD.n136 VDD.t4 319.38
R193 VDD.n152 VDD.t2 319.38
R194 VDD.n153 VDD.t24 319.38
R195 VDD.n159 VDD.t24 319.38
R196 VDD.n175 VDD.t0 319.38
R197 VDD.n176 VDD.t8 319.38
R198 VDD.n182 VDD.t8 319.38
R199 VDD.n9 VDD.n8 266.092
R200 VDD.n32 VDD.n31 266.092
R201 VDD.n55 VDD.n54 266.092
R202 VDD.n78 VDD.n77 266.092
R203 VDD.n101 VDD.n100 266.092
R204 VDD.n124 VDD.n123 266.092
R205 VDD.n147 VDD.n146 266.092
R206 VDD.n170 VDD.n169 266.092
R207 VDD.n10 VDD.n7 130.636
R208 VDD.n12 VDD.n7 130.636
R209 VDD.n11 VDD.n10 130.636
R210 VDD.n12 VDD.n11 130.636
R211 VDD.n19 VDD.n4 130.636
R212 VDD.n19 VDD.n18 130.636
R213 VDD.n18 VDD.n17 130.636
R214 VDD.n17 VDD.n4 130.636
R215 VDD.n33 VDD.n30 130.636
R216 VDD.n35 VDD.n30 130.636
R217 VDD.n34 VDD.n33 130.636
R218 VDD.n35 VDD.n34 130.636
R219 VDD.n42 VDD.n27 130.636
R220 VDD.n42 VDD.n41 130.636
R221 VDD.n41 VDD.n40 130.636
R222 VDD.n40 VDD.n27 130.636
R223 VDD.n56 VDD.n53 130.636
R224 VDD.n58 VDD.n53 130.636
R225 VDD.n57 VDD.n56 130.636
R226 VDD.n58 VDD.n57 130.636
R227 VDD.n65 VDD.n50 130.636
R228 VDD.n65 VDD.n64 130.636
R229 VDD.n64 VDD.n63 130.636
R230 VDD.n63 VDD.n50 130.636
R231 VDD.n79 VDD.n76 130.636
R232 VDD.n81 VDD.n76 130.636
R233 VDD.n80 VDD.n79 130.636
R234 VDD.n81 VDD.n80 130.636
R235 VDD.n88 VDD.n73 130.636
R236 VDD.n88 VDD.n87 130.636
R237 VDD.n87 VDD.n86 130.636
R238 VDD.n86 VDD.n73 130.636
R239 VDD.n102 VDD.n99 130.636
R240 VDD.n104 VDD.n99 130.636
R241 VDD.n103 VDD.n102 130.636
R242 VDD.n104 VDD.n103 130.636
R243 VDD.n111 VDD.n96 130.636
R244 VDD.n111 VDD.n110 130.636
R245 VDD.n110 VDD.n109 130.636
R246 VDD.n109 VDD.n96 130.636
R247 VDD.n125 VDD.n122 130.636
R248 VDD.n127 VDD.n122 130.636
R249 VDD.n126 VDD.n125 130.636
R250 VDD.n127 VDD.n126 130.636
R251 VDD.n134 VDD.n119 130.636
R252 VDD.n134 VDD.n133 130.636
R253 VDD.n133 VDD.n132 130.636
R254 VDD.n132 VDD.n119 130.636
R255 VDD.n148 VDD.n145 130.636
R256 VDD.n150 VDD.n145 130.636
R257 VDD.n149 VDD.n148 130.636
R258 VDD.n150 VDD.n149 130.636
R259 VDD.n157 VDD.n142 130.636
R260 VDD.n157 VDD.n156 130.636
R261 VDD.n156 VDD.n155 130.636
R262 VDD.n155 VDD.n142 130.636
R263 VDD.n171 VDD.n168 130.636
R264 VDD.n173 VDD.n168 130.636
R265 VDD.n172 VDD.n171 130.636
R266 VDD.n173 VDD.n172 130.636
R267 VDD.n180 VDD.n165 130.636
R268 VDD.n180 VDD.n179 130.636
R269 VDD.n179 VDD.n178 130.636
R270 VDD.n178 VDD.n165 130.636
R271 VDD.n15 VDD.n14 111.885
R272 VDD.n38 VDD.n37 111.885
R273 VDD.n61 VDD.n60 111.885
R274 VDD.n84 VDD.n83 111.885
R275 VDD.n107 VDD.n106 111.885
R276 VDD.n130 VDD.n129 111.885
R277 VDD.n153 VDD.n152 111.885
R278 VDD.n176 VDD.n175 111.885
R279 VDD.n4 VDD.n2 92.5005
R280 VDD.n2 VDD.t14 92.5005
R281 VDD.n11 VDD.n6 92.5005
R282 VDD.n6 VDD.t30 92.5005
R283 VDD.n7 VDD.n5 92.5005
R284 VDD.n18 VDD.n3 92.5005
R285 VDD.n3 VDD.t14 92.5005
R286 VDD.n27 VDD.n25 92.5005
R287 VDD.n25 VDD.t28 92.5005
R288 VDD.n34 VDD.n29 92.5005
R289 VDD.n29 VDD.t22 92.5005
R290 VDD.n30 VDD.n28 92.5005
R291 VDD.n41 VDD.n26 92.5005
R292 VDD.n26 VDD.t28 92.5005
R293 VDD.n50 VDD.n48 92.5005
R294 VDD.n48 VDD.t20 92.5005
R295 VDD.n57 VDD.n52 92.5005
R296 VDD.n52 VDD.t12 92.5005
R297 VDD.n53 VDD.n51 92.5005
R298 VDD.n64 VDD.n49 92.5005
R299 VDD.n49 VDD.t20 92.5005
R300 VDD.n73 VDD.n71 92.5005
R301 VDD.n71 VDD.t10 92.5005
R302 VDD.n80 VDD.n75 92.5005
R303 VDD.n75 VDD.t26 92.5005
R304 VDD.n76 VDD.n74 92.5005
R305 VDD.n87 VDD.n72 92.5005
R306 VDD.n72 VDD.t10 92.5005
R307 VDD.n96 VDD.n94 92.5005
R308 VDD.n94 VDD.t18 92.5005
R309 VDD.n103 VDD.n98 92.5005
R310 VDD.n98 VDD.t6 92.5005
R311 VDD.n99 VDD.n97 92.5005
R312 VDD.n110 VDD.n95 92.5005
R313 VDD.n95 VDD.t18 92.5005
R314 VDD.n119 VDD.n117 92.5005
R315 VDD.n117 VDD.t4 92.5005
R316 VDD.n126 VDD.n121 92.5005
R317 VDD.n121 VDD.t16 92.5005
R318 VDD.n122 VDD.n120 92.5005
R319 VDD.n133 VDD.n118 92.5005
R320 VDD.n118 VDD.t4 92.5005
R321 VDD.n142 VDD.n140 92.5005
R322 VDD.n140 VDD.t24 92.5005
R323 VDD.n149 VDD.n144 92.5005
R324 VDD.n144 VDD.t2 92.5005
R325 VDD.n145 VDD.n143 92.5005
R326 VDD.n156 VDD.n141 92.5005
R327 VDD.n141 VDD.t24 92.5005
R328 VDD.n165 VDD.n163 92.5005
R329 VDD.n163 VDD.t8 92.5005
R330 VDD.n172 VDD.n167 92.5005
R331 VDD.n167 VDD.t0 92.5005
R332 VDD.n168 VDD.n166 92.5005
R333 VDD.n179 VDD.n164 92.5005
R334 VDD.n164 VDD.t8 92.5005
R335 VDD.n8 VDD.n5 67.3191
R336 VDD.n31 VDD.n28 67.3191
R337 VDD.n54 VDD.n51 67.3191
R338 VDD.n77 VDD.n74 67.3191
R339 VDD.n100 VDD.n97 67.3191
R340 VDD.n123 VDD.n120 67.3191
R341 VDD.n146 VDD.n143 67.3191
R342 VDD.n169 VDD.n166 67.3191
R343 VDD.n13 VDD.n12 46.2505
R344 VDD.n14 VDD.n13 46.2505
R345 VDD.n10 VDD.n9 46.2505
R346 VDD.n20 VDD.n19 46.2505
R347 VDD.n21 VDD.n20 46.2505
R348 VDD.n17 VDD.n16 46.2505
R349 VDD.n16 VDD.n15 46.2505
R350 VDD.n36 VDD.n35 46.2505
R351 VDD.n37 VDD.n36 46.2505
R352 VDD.n33 VDD.n32 46.2505
R353 VDD.n43 VDD.n42 46.2505
R354 VDD.n44 VDD.n43 46.2505
R355 VDD.n40 VDD.n39 46.2505
R356 VDD.n39 VDD.n38 46.2505
R357 VDD.n59 VDD.n58 46.2505
R358 VDD.n60 VDD.n59 46.2505
R359 VDD.n56 VDD.n55 46.2505
R360 VDD.n66 VDD.n65 46.2505
R361 VDD.n67 VDD.n66 46.2505
R362 VDD.n63 VDD.n62 46.2505
R363 VDD.n62 VDD.n61 46.2505
R364 VDD.n82 VDD.n81 46.2505
R365 VDD.n83 VDD.n82 46.2505
R366 VDD.n79 VDD.n78 46.2505
R367 VDD.n89 VDD.n88 46.2505
R368 VDD.n90 VDD.n89 46.2505
R369 VDD.n86 VDD.n85 46.2505
R370 VDD.n85 VDD.n84 46.2505
R371 VDD.n105 VDD.n104 46.2505
R372 VDD.n106 VDD.n105 46.2505
R373 VDD.n102 VDD.n101 46.2505
R374 VDD.n112 VDD.n111 46.2505
R375 VDD.n113 VDD.n112 46.2505
R376 VDD.n109 VDD.n108 46.2505
R377 VDD.n108 VDD.n107 46.2505
R378 VDD.n128 VDD.n127 46.2505
R379 VDD.n129 VDD.n128 46.2505
R380 VDD.n125 VDD.n124 46.2505
R381 VDD.n135 VDD.n134 46.2505
R382 VDD.n136 VDD.n135 46.2505
R383 VDD.n132 VDD.n131 46.2505
R384 VDD.n131 VDD.n130 46.2505
R385 VDD.n151 VDD.n150 46.2505
R386 VDD.n152 VDD.n151 46.2505
R387 VDD.n148 VDD.n147 46.2505
R388 VDD.n158 VDD.n157 46.2505
R389 VDD.n159 VDD.n158 46.2505
R390 VDD.n155 VDD.n154 46.2505
R391 VDD.n154 VDD.n153 46.2505
R392 VDD.n174 VDD.n173 46.2505
R393 VDD.n175 VDD.n174 46.2505
R394 VDD.n171 VDD.n170 46.2505
R395 VDD.n181 VDD.n180 46.2505
R396 VDD.n182 VDD.n181 46.2505
R397 VDD.n178 VDD.n177 46.2505
R398 VDD.n177 VDD.n176 46.2505
R399 VDD.n8 VDD.t30 20.0984
R400 VDD.n31 VDD.t22 20.0984
R401 VDD.n54 VDD.t12 20.0984
R402 VDD.n77 VDD.t26 20.0984
R403 VDD.n100 VDD.t6 20.0984
R404 VDD.n123 VDD.t16 20.0984
R405 VDD.n146 VDD.t2 20.0984
R406 VDD.n169 VDD.t0 20.0984
R407 VDD.n162 VDD.n161 5.23762
R408 VDD.n161 VDD.n160 3.4105
R409 VDD.n138 VDD.n137 3.4105
R410 VDD.n115 VDD.n114 3.4105
R411 VDD.n92 VDD.n91 3.4105
R412 VDD.n69 VDD.n68 3.4105
R413 VDD.n46 VDD.n45 3.4105
R414 VDD.n23 VDD.n22 3.4105
R415 VDD.n161 VDD.n138 1.82762
R416 VDD.n138 VDD.n115 1.82762
R417 VDD.n115 VDD.n92 1.82762
R418 VDD.n92 VDD.n69 1.82762
R419 VDD.n69 VDD.n46 1.82762
R420 VDD.n46 VDD.n23 1.82762
R421 VDD.n22 VDD.n1 0.219833
R422 VDD.n45 VDD.n24 0.219833
R423 VDD.n68 VDD.n47 0.219833
R424 VDD.n91 VDD.n70 0.219833
R425 VDD.n114 VDD.n93 0.219833
R426 VDD.n137 VDD.n116 0.219833
R427 VDD.n160 VDD.n139 0.219833
R428 VDD.n162 VDD.n0 0.219833
R429 VDD.n23 VDD 0.170875
R430 VDD.n22 VDD 0.0151875
R431 VDD.n45 VDD 0.0151875
R432 VDD.n68 VDD 0.0151875
R433 VDD.n91 VDD 0.0151875
R434 VDD.n114 VDD 0.0151875
R435 VDD.n137 VDD 0.0151875
R436 VDD.n160 VDD 0.0151875
R437 VDD VDD.n162 0.0151875
R438 VSS.n219 VSS.n218 35830.5
R439 VSS.n203 VSS.n168 17392.1
R440 VSS.n271 VSS.n270 17392.1
R441 VSS.n313 VSS.n312 17392.1
R442 VSS.n128 VSS.n93 17392.1
R443 VSS.n366 VSS.n365 17392.1
R444 VSS.n408 VSS.n407 17392.1
R445 VSS.n409 VSS.n408 8630.22
R446 VSS.n367 VSS.n366 8630.22
R447 VSS.n121 VSS.n93 8630.22
R448 VSS.n314 VSS.n313 8630.22
R449 VSS.n272 VSS.n271 8630.22
R450 VSS.n196 VSS.n168 8630.22
R451 VSS.t45 VSS.n52 8612.49
R452 VSS.n439 VSS.n52 7978.76
R453 VSS.t33 VSS.n203 6688
R454 VSS.n270 VSS.t35 6688
R455 VSS.n312 VSS.t37 6688
R456 VSS.t39 VSS.n128 6688
R457 VSS.n365 VSS.t41 6688
R458 VSS.n407 VSS.t43 6688
R459 VSS.n203 VSS.n202 4683.87
R460 VSS.n270 VSS.n158 4683.87
R461 VSS.n312 VSS.n144 4683.87
R462 VSS.n128 VSS.n127 4683.87
R463 VSS.n365 VSS.n82 4683.87
R464 VSS.n407 VSS.n68 4683.87
R465 VSS.n249 VSS.n168 3104.57
R466 VSS.n271 VSS.n156 3104.57
R467 VSS.n313 VSS.n142 3104.57
R468 VSS.n344 VSS.n93 3104.57
R469 VSS.n366 VSS.n80 3104.57
R470 VSS.n408 VSS.n66 3104.57
R471 VSS.n46 VSS.n5 2450.91
R472 VSS.n50 VSS.n5 2450.91
R473 VSS.n46 VSS.n6 2450.91
R474 VSS.n50 VSS.n6 2450.91
R475 VSS.n39 VSS.n8 2450.91
R476 VSS.n43 VSS.n8 2450.91
R477 VSS.n39 VSS.n9 2450.91
R478 VSS.n43 VSS.n9 2450.91
R479 VSS.n414 VSS.n63 2450.91
R480 VSS.n414 VSS.n64 2450.91
R481 VSS.n410 VSS.n63 2450.91
R482 VSS.n410 VSS.n64 2450.91
R483 VSS.n421 VSS.n60 2450.91
R484 VSS.n421 VSS.n61 2450.91
R485 VSS.n417 VSS.n60 2450.91
R486 VSS.n417 VSS.n61 2450.91
R487 VSS.n372 VSS.n77 2450.91
R488 VSS.n372 VSS.n78 2450.91
R489 VSS.n368 VSS.n77 2450.91
R490 VSS.n368 VSS.n78 2450.91
R491 VSS.n379 VSS.n74 2450.91
R492 VSS.n379 VSS.n75 2450.91
R493 VSS.n375 VSS.n74 2450.91
R494 VSS.n375 VSS.n75 2450.91
R495 VSS.n122 VSS.n95 2450.91
R496 VSS.n126 VSS.n95 2450.91
R497 VSS.n122 VSS.n96 2450.91
R498 VSS.n126 VSS.n96 2450.91
R499 VSS.n114 VSS.n98 2450.91
R500 VSS.n114 VSS.n99 2450.91
R501 VSS.n118 VSS.n98 2450.91
R502 VSS.n118 VSS.n99 2450.91
R503 VSS.n319 VSS.n139 2450.91
R504 VSS.n319 VSS.n140 2450.91
R505 VSS.n315 VSS.n139 2450.91
R506 VSS.n315 VSS.n140 2450.91
R507 VSS.n326 VSS.n136 2450.91
R508 VSS.n326 VSS.n137 2450.91
R509 VSS.n322 VSS.n136 2450.91
R510 VSS.n322 VSS.n137 2450.91
R511 VSS.n277 VSS.n153 2450.91
R512 VSS.n277 VSS.n154 2450.91
R513 VSS.n273 VSS.n153 2450.91
R514 VSS.n273 VSS.n154 2450.91
R515 VSS.n284 VSS.n150 2450.91
R516 VSS.n284 VSS.n151 2450.91
R517 VSS.n280 VSS.n150 2450.91
R518 VSS.n280 VSS.n151 2450.91
R519 VSS.n197 VSS.n170 2450.91
R520 VSS.n201 VSS.n170 2450.91
R521 VSS.n197 VSS.n171 2450.91
R522 VSS.n201 VSS.n171 2450.91
R523 VSS.n189 VSS.n173 2450.91
R524 VSS.n189 VSS.n174 2450.91
R525 VSS.n193 VSS.n173 2450.91
R526 VSS.n193 VSS.n174 2450.91
R527 VSS.n224 VSS.n214 2450.91
R528 VSS.n224 VSS.n215 2450.91
R529 VSS.n220 VSS.n214 2450.91
R530 VSS.n220 VSS.n215 2450.91
R531 VSS.n231 VSS.n211 2450.91
R532 VSS.n231 VSS.n212 2450.91
R533 VSS.n227 VSS.n211 2450.91
R534 VSS.n227 VSS.n212 2450.91
R535 VSS.n217 VSS.n207 2094.97
R536 VSS.n218 VSS.n217 2094.97
R537 VSS.n179 VSS.n169 2094.97
R538 VSS.n202 VSS.n169 2094.97
R539 VSS.n157 VSS.n146 2094.97
R540 VSS.n158 VSS.n157 2094.97
R541 VSS.n143 VSS.n132 2094.97
R542 VSS.n144 VSS.n143 2094.97
R543 VSS.n104 VSS.n94 2094.97
R544 VSS.n127 VSS.n94 2094.97
R545 VSS.n81 VSS.n70 2094.97
R546 VSS.n82 VSS.n81 2094.97
R547 VSS.n67 VSS.n56 2094.97
R548 VSS.n68 VSS.n67 2094.97
R549 VSS.n32 VSS.n11 2068.5
R550 VSS.n36 VSS.n11 2068.5
R551 VSS.n32 VSS.n12 2068.5
R552 VSS.n36 VSS.n12 2068.5
R553 VSS.n428 VSS.n57 2068.5
R554 VSS.n428 VSS.n58 2068.5
R555 VSS.n424 VSS.n57 2068.5
R556 VSS.n424 VSS.n58 2068.5
R557 VSS.n432 VSS.n3 2068.5
R558 VSS.n432 VSS.n53 2068.5
R559 VSS.n386 VSS.n71 2068.5
R560 VSS.n386 VSS.n72 2068.5
R561 VSS.n382 VSS.n71 2068.5
R562 VSS.n382 VSS.n72 2068.5
R563 VSS.n392 VSS.n69 2068.5
R564 VSS.n406 VSS.n392 2068.5
R565 VSS.n107 VSS.n101 2068.5
R566 VSS.n107 VSS.n102 2068.5
R567 VSS.n111 VSS.n101 2068.5
R568 VSS.n111 VSS.n102 2068.5
R569 VSS.n87 VSS.n83 2068.5
R570 VSS.n364 VSS.n87 2068.5
R571 VSS.n333 VSS.n133 2068.5
R572 VSS.n333 VSS.n134 2068.5
R573 VSS.n329 VSS.n133 2068.5
R574 VSS.n329 VSS.n134 2068.5
R575 VSS.n337 VSS.n91 2068.5
R576 VSS.n337 VSS.n129 2068.5
R577 VSS.n291 VSS.n147 2068.5
R578 VSS.n291 VSS.n148 2068.5
R579 VSS.n287 VSS.n147 2068.5
R580 VSS.n287 VSS.n148 2068.5
R581 VSS.n297 VSS.n145 2068.5
R582 VSS.n311 VSS.n297 2068.5
R583 VSS.n182 VSS.n176 2068.5
R584 VSS.n182 VSS.n177 2068.5
R585 VSS.n186 VSS.n176 2068.5
R586 VSS.n186 VSS.n177 2068.5
R587 VSS.n163 VSS.n159 2068.5
R588 VSS.n269 VSS.n163 2068.5
R589 VSS.n238 VSS.n208 2068.5
R590 VSS.n238 VSS.n209 2068.5
R591 VSS.n234 VSS.n208 2068.5
R592 VSS.n234 VSS.n209 2068.5
R593 VSS.n242 VSS.n166 2068.5
R594 VSS.n242 VSS.n204 2068.5
R595 VSS.n29 VSS.n14 2068.5
R596 VSS.n29 VSS.n15 2068.5
R597 VSS.n436 VSS.n53 1778.79
R598 VSS.n406 VSS.n391 1778.79
R599 VSS.n364 VSS.n86 1778.79
R600 VSS.n341 VSS.n129 1778.79
R601 VSS.n311 VSS.n296 1778.79
R602 VSS.n269 VSS.n162 1778.79
R603 VSS.n246 VSS.n204 1778.79
R604 VSS.n25 VSS.n15 1778.79
R605 VSS.n52 VSS.n51 1279.04
R606 VSS.n440 VSS.n3 1060.74
R607 VSS.n398 VSS.n69 1060.74
R608 VSS.n356 VSS.n83 1060.74
R609 VSS.n345 VSS.n91 1060.74
R610 VSS.n303 VSS.n145 1060.74
R611 VSS.n261 VSS.n159 1060.74
R612 VSS.n250 VSS.n166 1060.74
R613 VSS.n22 VSS.n14 1060.74
R614 VSS.n240 VSS.n207 999.226
R615 VSS.n180 VSS.n179 999.226
R616 VSS.n293 VSS.n146 999.226
R617 VSS.n335 VSS.n132 999.226
R618 VSS.n105 VSS.n104 999.226
R619 VSS.n388 VSS.n70 999.226
R620 VSS.n430 VSS.n56 999.226
R621 VSS.n247 VSS.t33 701.321
R622 VSS.n239 VSS.t32 701.321
R623 VSS.n233 VSS.t32 701.321
R624 VSS.n232 VSS.t4 701.321
R625 VSS.n226 VSS.t4 701.321
R626 VSS.n225 VSS.t26 701.321
R627 VSS.n219 VSS.t26 701.321
R628 VSS.t35 VSS.n161 701.321
R629 VSS.n181 VSS.t34 701.321
R630 VSS.n187 VSS.t34 701.321
R631 VSS.n188 VSS.t22 701.321
R632 VSS.n194 VSS.t22 701.321
R633 VSS.t24 VSS.n195 701.321
R634 VSS.t24 VSS.n196 701.321
R635 VSS.t37 VSS.n295 701.321
R636 VSS.n292 VSS.t36 701.321
R637 VSS.n286 VSS.t36 701.321
R638 VSS.n285 VSS.t16 701.321
R639 VSS.n279 VSS.t16 701.321
R640 VSS.n278 VSS.t20 701.321
R641 VSS.n272 VSS.t20 701.321
R642 VSS.n342 VSS.t39 701.321
R643 VSS.n334 VSS.t38 701.321
R644 VSS.n328 VSS.t38 701.321
R645 VSS.n327 VSS.t12 701.321
R646 VSS.n321 VSS.t12 701.321
R647 VSS.n320 VSS.t14 701.321
R648 VSS.n314 VSS.t14 701.321
R649 VSS.t41 VSS.n85 701.321
R650 VSS.n106 VSS.t40 701.321
R651 VSS.n112 VSS.t40 701.321
R652 VSS.n113 VSS.t28 701.321
R653 VSS.n119 VSS.t28 701.321
R654 VSS.t30 VSS.n120 701.321
R655 VSS.t30 VSS.n121 701.321
R656 VSS.t43 VSS.n390 701.321
R657 VSS.n387 VSS.t42 701.321
R658 VSS.n381 VSS.t42 701.321
R659 VSS.n380 VSS.t6 701.321
R660 VSS.n374 VSS.t6 701.321
R661 VSS.n373 VSS.t10 701.321
R662 VSS.n367 VSS.t10 701.321
R663 VSS.n437 VSS.t45 701.321
R664 VSS.n429 VSS.t44 701.321
R665 VSS.n423 VSS.t44 701.321
R666 VSS.n422 VSS.t8 701.321
R667 VSS.n416 VSS.t8 701.321
R668 VSS.n415 VSS.t18 701.321
R669 VSS.n409 VSS.t18 701.321
R670 VSS.n436 VSS.n4 568.865
R671 VSS.n400 VSS.n391 568.865
R672 VSS.n358 VSS.n86 568.865
R673 VSS.n341 VSS.n92 568.865
R674 VSS.n305 VSS.n296 568.865
R675 VSS.n263 VSS.n162 568.865
R676 VSS.n246 VSS.n167 568.865
R677 VSS.n25 VSS.n18 568.865
R678 VSS.n241 VSS.t33 392.502
R679 VSS.t35 VSS.n160 392.502
R680 VSS.t37 VSS.n294 392.502
R681 VSS.n336 VSS.t39 392.502
R682 VSS.t41 VSS.n84 392.502
R683 VSS.t43 VSS.n389 392.502
R684 VSS.n431 VSS.t45 392.502
R685 VSS.n24 VSS.t47 392.5
R686 VSS.n30 VSS.t47 392.5
R687 VSS.n31 VSS.t46 392.5
R688 VSS.n37 VSS.t46 392.5
R689 VSS.n38 VSS.t0 392.5
R690 VSS.n44 VSS.t0 392.5
R691 VSS.n45 VSS.t2 392.5
R692 VSS.n51 VSS.t2 392.5
R693 VSS.n24 VSS.n23 301.348
R694 VSS.n248 VSS.n247 294.822
R695 VSS.n262 VSS.n161 294.822
R696 VSS.n304 VSS.n295 294.822
R697 VSS.n343 VSS.n342 294.822
R698 VSS.n357 VSS.n85 294.822
R699 VSS.n399 VSS.n390 294.822
R700 VSS.n438 VSS.n437 294.822
R701 VSS.n244 VSS.n204 292.5
R702 VSS.n204 VSS.t33 292.5
R703 VSS.n236 VSS.n209 292.5
R704 VSS.n209 VSS.n207 292.5
R705 VSS.n229 VSS.n212 292.5
R706 VSS.n217 VSS.n212 292.5
R707 VSS.n222 VSS.n215 292.5
R708 VSS.n218 VSS.n215 292.5
R709 VSS.n167 VSS.n165 292.5
R710 VSS.n248 VSS.n167 292.5
R711 VSS.n251 VSS.n250 292.5
R712 VSS.n250 VSS.n249 292.5
R713 VSS.n206 VSS.n166 292.5
R714 VSS.t33 VSS.n166 292.5
R715 VSS.n210 VSS.n208 292.5
R716 VSS.n208 VSS.t32 292.5
R717 VSS.n213 VSS.n211 292.5
R718 VSS.n211 VSS.t4 292.5
R719 VSS.n216 VSS.n214 292.5
R720 VSS.n214 VSS.t26 292.5
R721 VSS.n269 VSS.n268 292.5
R722 VSS.t35 VSS.n269 292.5
R723 VSS.n184 VSS.n177 292.5
R724 VSS.n179 VSS.n177 292.5
R725 VSS.n191 VSS.n174 292.5
R726 VSS.n174 VSS.n169 292.5
R727 VSS.n201 VSS.n200 292.5
R728 VSS.n202 VSS.n201 292.5
R729 VSS.n264 VSS.n263 292.5
R730 VSS.n263 VSS.n262 292.5
R731 VSS.n261 VSS.n260 292.5
R732 VSS.n261 VSS.n156 292.5
R733 VSS.n266 VSS.n159 292.5
R734 VSS.t35 VSS.n159 292.5
R735 VSS.n178 VSS.n176 292.5
R736 VSS.n176 VSS.t34 292.5
R737 VSS.n175 VSS.n173 292.5
R738 VSS.n173 VSS.t22 292.5
R739 VSS.n198 VSS.n197 292.5
R740 VSS.n197 VSS.t24 292.5
R741 VSS.n311 VSS.n310 292.5
R742 VSS.t37 VSS.n311 292.5
R743 VSS.n289 VSS.n148 292.5
R744 VSS.n148 VSS.n146 292.5
R745 VSS.n282 VSS.n151 292.5
R746 VSS.n157 VSS.n151 292.5
R747 VSS.n275 VSS.n154 292.5
R748 VSS.n158 VSS.n154 292.5
R749 VSS.n306 VSS.n305 292.5
R750 VSS.n305 VSS.n304 292.5
R751 VSS.n303 VSS.n302 292.5
R752 VSS.n303 VSS.n142 292.5
R753 VSS.n308 VSS.n145 292.5
R754 VSS.t37 VSS.n145 292.5
R755 VSS.n149 VSS.n147 292.5
R756 VSS.n147 VSS.t36 292.5
R757 VSS.n152 VSS.n150 292.5
R758 VSS.n150 VSS.t16 292.5
R759 VSS.n155 VSS.n153 292.5
R760 VSS.n153 VSS.t20 292.5
R761 VSS.n339 VSS.n129 292.5
R762 VSS.n129 VSS.t39 292.5
R763 VSS.n331 VSS.n134 292.5
R764 VSS.n134 VSS.n132 292.5
R765 VSS.n324 VSS.n137 292.5
R766 VSS.n143 VSS.n137 292.5
R767 VSS.n317 VSS.n140 292.5
R768 VSS.n144 VSS.n140 292.5
R769 VSS.n92 VSS.n90 292.5
R770 VSS.n343 VSS.n92 292.5
R771 VSS.n346 VSS.n345 292.5
R772 VSS.n345 VSS.n344 292.5
R773 VSS.n131 VSS.n91 292.5
R774 VSS.t39 VSS.n91 292.5
R775 VSS.n135 VSS.n133 292.5
R776 VSS.n133 VSS.t38 292.5
R777 VSS.n138 VSS.n136 292.5
R778 VSS.n136 VSS.t12 292.5
R779 VSS.n141 VSS.n139 292.5
R780 VSS.n139 VSS.t14 292.5
R781 VSS.n364 VSS.n363 292.5
R782 VSS.t41 VSS.n364 292.5
R783 VSS.n109 VSS.n102 292.5
R784 VSS.n104 VSS.n102 292.5
R785 VSS.n116 VSS.n99 292.5
R786 VSS.n99 VSS.n94 292.5
R787 VSS.n126 VSS.n125 292.5
R788 VSS.n127 VSS.n126 292.5
R789 VSS.n359 VSS.n358 292.5
R790 VSS.n358 VSS.n357 292.5
R791 VSS.n356 VSS.n355 292.5
R792 VSS.n356 VSS.n80 292.5
R793 VSS.n361 VSS.n83 292.5
R794 VSS.t41 VSS.n83 292.5
R795 VSS.n103 VSS.n101 292.5
R796 VSS.n101 VSS.t40 292.5
R797 VSS.n100 VSS.n98 292.5
R798 VSS.n98 VSS.t28 292.5
R799 VSS.n123 VSS.n122 292.5
R800 VSS.n122 VSS.t30 292.5
R801 VSS.n406 VSS.n405 292.5
R802 VSS.t43 VSS.n406 292.5
R803 VSS.n384 VSS.n72 292.5
R804 VSS.n72 VSS.n70 292.5
R805 VSS.n377 VSS.n75 292.5
R806 VSS.n81 VSS.n75 292.5
R807 VSS.n370 VSS.n78 292.5
R808 VSS.n82 VSS.n78 292.5
R809 VSS.n401 VSS.n400 292.5
R810 VSS.n400 VSS.n399 292.5
R811 VSS.n398 VSS.n397 292.5
R812 VSS.n398 VSS.n66 292.5
R813 VSS.n403 VSS.n69 292.5
R814 VSS.t43 VSS.n69 292.5
R815 VSS.n73 VSS.n71 292.5
R816 VSS.n71 VSS.t42 292.5
R817 VSS.n76 VSS.n74 292.5
R818 VSS.n74 VSS.t6 292.5
R819 VSS.n79 VSS.n77 292.5
R820 VSS.n77 VSS.t10 292.5
R821 VSS.n434 VSS.n53 292.5
R822 VSS.n53 VSS.t45 292.5
R823 VSS.n426 VSS.n58 292.5
R824 VSS.n58 VSS.n56 292.5
R825 VSS.n419 VSS.n61 292.5
R826 VSS.n67 VSS.n61 292.5
R827 VSS.n412 VSS.n64 292.5
R828 VSS.n68 VSS.n64 292.5
R829 VSS.n4 VSS.n2 292.5
R830 VSS.n438 VSS.n4 292.5
R831 VSS.n441 VSS.n440 292.5
R832 VSS.n440 VSS.n439 292.5
R833 VSS.n55 VSS.n3 292.5
R834 VSS.t45 VSS.n3 292.5
R835 VSS.n59 VSS.n57 292.5
R836 VSS.n57 VSS.t44 292.5
R837 VSS.n62 VSS.n60 292.5
R838 VSS.n60 VSS.t8 292.5
R839 VSS.n65 VSS.n63 292.5
R840 VSS.n63 VSS.t18 292.5
R841 VSS.n34 VSS.n12 292.5
R842 VSS.n12 VSS.t46 292.5
R843 VSS.n13 VSS.n11 292.5
R844 VSS.n11 VSS.t46 292.5
R845 VSS.n41 VSS.n9 292.5
R846 VSS.n9 VSS.t0 292.5
R847 VSS.n10 VSS.n8 292.5
R848 VSS.n8 VSS.t0 292.5
R849 VSS.n48 VSS.n6 292.5
R850 VSS.n6 VSS.t2 292.5
R851 VSS.n7 VSS.n5 292.5
R852 VSS.n5 VSS.t2 292.5
R853 VSS.n27 VSS.n15 292.5
R854 VSS.n15 VSS.t47 292.5
R855 VSS.n16 VSS.n14 292.5
R856 VSS.n14 VSS.t47 292.5
R857 VSS.n20 VSS.n18 292.5
R858 VSS.n22 VSS.n21 292.5
R859 VSS.n233 VSS.n232 245.685
R860 VSS.n226 VSS.n225 245.685
R861 VSS.n188 VSS.n187 245.685
R862 VSS.n195 VSS.n194 245.685
R863 VSS.n286 VSS.n285 245.685
R864 VSS.n279 VSS.n278 245.685
R865 VSS.n328 VSS.n327 245.685
R866 VSS.n321 VSS.n320 245.685
R867 VSS.n113 VSS.n112 245.685
R868 VSS.n120 VSS.n119 245.685
R869 VSS.n381 VSS.n380 245.685
R870 VSS.n374 VSS.n373 245.685
R871 VSS.n423 VSS.n422 245.685
R872 VSS.n416 VSS.n415 245.685
R873 VSS.n242 VSS.n241 203.855
R874 VSS.n163 VSS.n160 203.855
R875 VSS.n297 VSS.n294 203.855
R876 VSS.n337 VSS.n336 203.855
R877 VSS.n87 VSS.n84 203.855
R878 VSS.n392 VSS.n389 203.855
R879 VSS.n432 VSS.n431 203.855
R880 VSS.n246 VSS.n245 195
R881 VSS.n247 VSS.n246 195
R882 VSS.n164 VSS.n162 195
R883 VSS.n162 VSS.n161 195
R884 VSS.n298 VSS.n296 195
R885 VSS.n296 VSS.n295 195
R886 VSS.n341 VSS.n340 195
R887 VSS.n342 VSS.n341 195
R888 VSS.n88 VSS.n86 195
R889 VSS.n86 VSS.n85 195
R890 VSS.n393 VSS.n391 195
R891 VSS.n391 VSS.n390 195
R892 VSS.n436 VSS.n435 195
R893 VSS.n437 VSS.n436 195
R894 VSS.n26 VSS.n25 195
R895 VSS.n25 VSS.n24 195
R896 VSS.n47 VSS.n7 159.248
R897 VSS.n49 VSS.n7 159.248
R898 VSS.n48 VSS.n47 159.248
R899 VSS.n49 VSS.n48 159.248
R900 VSS.n40 VSS.n10 159.248
R901 VSS.n42 VSS.n10 159.248
R902 VSS.n41 VSS.n40 159.248
R903 VSS.n42 VSS.n41 159.248
R904 VSS.n413 VSS.n65 159.248
R905 VSS.n413 VSS.n412 159.248
R906 VSS.n411 VSS.n65 159.248
R907 VSS.n412 VSS.n411 159.248
R908 VSS.n420 VSS.n62 159.248
R909 VSS.n420 VSS.n419 159.248
R910 VSS.n418 VSS.n62 159.248
R911 VSS.n419 VSS.n418 159.248
R912 VSS.n371 VSS.n79 159.248
R913 VSS.n371 VSS.n370 159.248
R914 VSS.n369 VSS.n79 159.248
R915 VSS.n370 VSS.n369 159.248
R916 VSS.n378 VSS.n76 159.248
R917 VSS.n378 VSS.n377 159.248
R918 VSS.n376 VSS.n76 159.248
R919 VSS.n377 VSS.n376 159.248
R920 VSS.n123 VSS.n97 159.248
R921 VSS.n125 VSS.n97 159.248
R922 VSS.n124 VSS.n123 159.248
R923 VSS.n125 VSS.n124 159.248
R924 VSS.n115 VSS.n100 159.248
R925 VSS.n116 VSS.n115 159.248
R926 VSS.n117 VSS.n100 159.248
R927 VSS.n117 VSS.n116 159.248
R928 VSS.n318 VSS.n141 159.248
R929 VSS.n318 VSS.n317 159.248
R930 VSS.n316 VSS.n141 159.248
R931 VSS.n317 VSS.n316 159.248
R932 VSS.n325 VSS.n138 159.248
R933 VSS.n325 VSS.n324 159.248
R934 VSS.n323 VSS.n138 159.248
R935 VSS.n324 VSS.n323 159.248
R936 VSS.n276 VSS.n155 159.248
R937 VSS.n276 VSS.n275 159.248
R938 VSS.n274 VSS.n155 159.248
R939 VSS.n275 VSS.n274 159.248
R940 VSS.n283 VSS.n152 159.248
R941 VSS.n283 VSS.n282 159.248
R942 VSS.n281 VSS.n152 159.248
R943 VSS.n282 VSS.n281 159.248
R944 VSS.n198 VSS.n172 159.248
R945 VSS.n200 VSS.n172 159.248
R946 VSS.n199 VSS.n198 159.248
R947 VSS.n200 VSS.n199 159.248
R948 VSS.n190 VSS.n175 159.248
R949 VSS.n191 VSS.n190 159.248
R950 VSS.n192 VSS.n175 159.248
R951 VSS.n192 VSS.n191 159.248
R952 VSS.n223 VSS.n216 159.248
R953 VSS.n223 VSS.n222 159.248
R954 VSS.n221 VSS.n216 159.248
R955 VSS.n222 VSS.n221 159.248
R956 VSS.n230 VSS.n213 159.248
R957 VSS.n230 VSS.n229 159.248
R958 VSS.n228 VSS.n213 159.248
R959 VSS.n229 VSS.n228 159.248
R960 VSS.n243 VSS.n242 146.25
R961 VSS.n235 VSS.n234 146.25
R962 VSS.n234 VSS.n233 146.25
R963 VSS.n238 VSS.n237 146.25
R964 VSS.n239 VSS.n238 146.25
R965 VSS.n267 VSS.n163 146.25
R966 VSS.n186 VSS.n185 146.25
R967 VSS.n187 VSS.n186 146.25
R968 VSS.n183 VSS.n182 146.25
R969 VSS.n182 VSS.n181 146.25
R970 VSS.n309 VSS.n297 146.25
R971 VSS.n288 VSS.n287 146.25
R972 VSS.n287 VSS.n286 146.25
R973 VSS.n291 VSS.n290 146.25
R974 VSS.n292 VSS.n291 146.25
R975 VSS.n338 VSS.n337 146.25
R976 VSS.n330 VSS.n329 146.25
R977 VSS.n329 VSS.n328 146.25
R978 VSS.n333 VSS.n332 146.25
R979 VSS.n334 VSS.n333 146.25
R980 VSS.n362 VSS.n87 146.25
R981 VSS.n111 VSS.n110 146.25
R982 VSS.n112 VSS.n111 146.25
R983 VSS.n108 VSS.n107 146.25
R984 VSS.n107 VSS.n106 146.25
R985 VSS.n404 VSS.n392 146.25
R986 VSS.n383 VSS.n382 146.25
R987 VSS.n382 VSS.n381 146.25
R988 VSS.n386 VSS.n385 146.25
R989 VSS.n387 VSS.n386 146.25
R990 VSS.n433 VSS.n432 146.25
R991 VSS.n425 VSS.n424 146.25
R992 VSS.n424 VSS.n423 146.25
R993 VSS.n428 VSS.n427 146.25
R994 VSS.n429 VSS.n428 146.25
R995 VSS.n36 VSS.n35 146.25
R996 VSS.n37 VSS.n36 146.25
R997 VSS.n33 VSS.n32 146.25
R998 VSS.n32 VSS.n31 146.25
R999 VSS.n29 VSS.n28 146.25
R1000 VSS.n30 VSS.n29 146.25
R1001 VSS.n31 VSS.n30 137.5
R1002 VSS.n38 VSS.n37 137.5
R1003 VSS.n45 VSS.n44 137.5
R1004 VSS.n33 VSS.n13 134.4
R1005 VSS.n35 VSS.n13 134.4
R1006 VSS.n34 VSS.n33 134.4
R1007 VSS.n35 VSS.n34 134.4
R1008 VSS.n427 VSS.n59 134.4
R1009 VSS.n427 VSS.n426 134.4
R1010 VSS.n425 VSS.n59 134.4
R1011 VSS.n426 VSS.n425 134.4
R1012 VSS.n433 VSS.n55 134.4
R1013 VSS.n434 VSS.n433 134.4
R1014 VSS.n385 VSS.n73 134.4
R1015 VSS.n385 VSS.n384 134.4
R1016 VSS.n383 VSS.n73 134.4
R1017 VSS.n384 VSS.n383 134.4
R1018 VSS.n404 VSS.n403 134.4
R1019 VSS.n405 VSS.n404 134.4
R1020 VSS.n108 VSS.n103 134.4
R1021 VSS.n109 VSS.n108 134.4
R1022 VSS.n110 VSS.n103 134.4
R1023 VSS.n110 VSS.n109 134.4
R1024 VSS.n362 VSS.n361 134.4
R1025 VSS.n363 VSS.n362 134.4
R1026 VSS.n332 VSS.n135 134.4
R1027 VSS.n332 VSS.n331 134.4
R1028 VSS.n330 VSS.n135 134.4
R1029 VSS.n331 VSS.n330 134.4
R1030 VSS.n338 VSS.n131 134.4
R1031 VSS.n339 VSS.n338 134.4
R1032 VSS.n290 VSS.n149 134.4
R1033 VSS.n290 VSS.n289 134.4
R1034 VSS.n288 VSS.n149 134.4
R1035 VSS.n289 VSS.n288 134.4
R1036 VSS.n309 VSS.n308 134.4
R1037 VSS.n310 VSS.n309 134.4
R1038 VSS.n183 VSS.n178 134.4
R1039 VSS.n184 VSS.n183 134.4
R1040 VSS.n185 VSS.n178 134.4
R1041 VSS.n185 VSS.n184 134.4
R1042 VSS.n267 VSS.n266 134.4
R1043 VSS.n268 VSS.n267 134.4
R1044 VSS.n237 VSS.n210 134.4
R1045 VSS.n237 VSS.n236 134.4
R1046 VSS.n235 VSS.n210 134.4
R1047 VSS.n236 VSS.n235 134.4
R1048 VSS.n243 VSS.n206 134.4
R1049 VSS.n244 VSS.n243 134.4
R1050 VSS.n28 VSS.n27 134.4
R1051 VSS.n28 VSS.n16 134.4
R1052 VSS.n435 VSS.n434 115.576
R1053 VSS.n405 VSS.n393 115.576
R1054 VSS.n363 VSS.n88 115.576
R1055 VSS.n340 VSS.n339 115.576
R1056 VSS.n310 VSS.n298 115.576
R1057 VSS.n268 VSS.n164 115.576
R1058 VSS.n245 VSS.n244 115.576
R1059 VSS.n27 VSS.n26 115.576
R1060 VSS.n228 VSS.n227 97.5005
R1061 VSS.n227 VSS.n226 97.5005
R1062 VSS.n231 VSS.n230 97.5005
R1063 VSS.n232 VSS.n231 97.5005
R1064 VSS.n221 VSS.n220 97.5005
R1065 VSS.n220 VSS.n219 97.5005
R1066 VSS.n224 VSS.n223 97.5005
R1067 VSS.n225 VSS.n224 97.5005
R1068 VSS.n193 VSS.n192 97.5005
R1069 VSS.n194 VSS.n193 97.5005
R1070 VSS.n190 VSS.n189 97.5005
R1071 VSS.n189 VSS.n188 97.5005
R1072 VSS.n199 VSS.n171 97.5005
R1073 VSS.n196 VSS.n171 97.5005
R1074 VSS.n172 VSS.n170 97.5005
R1075 VSS.n195 VSS.n170 97.5005
R1076 VSS.n281 VSS.n280 97.5005
R1077 VSS.n280 VSS.n279 97.5005
R1078 VSS.n284 VSS.n283 97.5005
R1079 VSS.n285 VSS.n284 97.5005
R1080 VSS.n274 VSS.n273 97.5005
R1081 VSS.n273 VSS.n272 97.5005
R1082 VSS.n277 VSS.n276 97.5005
R1083 VSS.n278 VSS.n277 97.5005
R1084 VSS.n323 VSS.n322 97.5005
R1085 VSS.n322 VSS.n321 97.5005
R1086 VSS.n326 VSS.n325 97.5005
R1087 VSS.n327 VSS.n326 97.5005
R1088 VSS.n316 VSS.n315 97.5005
R1089 VSS.n315 VSS.n314 97.5005
R1090 VSS.n319 VSS.n318 97.5005
R1091 VSS.n320 VSS.n319 97.5005
R1092 VSS.n118 VSS.n117 97.5005
R1093 VSS.n119 VSS.n118 97.5005
R1094 VSS.n115 VSS.n114 97.5005
R1095 VSS.n114 VSS.n113 97.5005
R1096 VSS.n124 VSS.n96 97.5005
R1097 VSS.n121 VSS.n96 97.5005
R1098 VSS.n97 VSS.n95 97.5005
R1099 VSS.n120 VSS.n95 97.5005
R1100 VSS.n376 VSS.n375 97.5005
R1101 VSS.n375 VSS.n374 97.5005
R1102 VSS.n379 VSS.n378 97.5005
R1103 VSS.n380 VSS.n379 97.5005
R1104 VSS.n369 VSS.n368 97.5005
R1105 VSS.n368 VSS.n367 97.5005
R1106 VSS.n372 VSS.n371 97.5005
R1107 VSS.n373 VSS.n372 97.5005
R1108 VSS.n418 VSS.n417 97.5005
R1109 VSS.n417 VSS.n416 97.5005
R1110 VSS.n421 VSS.n420 97.5005
R1111 VSS.n422 VSS.n421 97.5005
R1112 VSS.n411 VSS.n410 97.5005
R1113 VSS.n410 VSS.n409 97.5005
R1114 VSS.n414 VSS.n413 97.5005
R1115 VSS.n415 VSS.n414 97.5005
R1116 VSS.n43 VSS.n42 97.5005
R1117 VSS.n44 VSS.n43 97.5005
R1118 VSS.n40 VSS.n39 97.5005
R1119 VSS.n39 VSS.n38 97.5005
R1120 VSS.n50 VSS.n49 97.5005
R1121 VSS.n51 VSS.n50 97.5005
R1122 VSS.n47 VSS.n46 97.5005
R1123 VSS.n46 VSS.n45 97.5005
R1124 VSS.n241 VSS.n240 90.001
R1125 VSS.n180 VSS.n160 90.001
R1126 VSS.n294 VSS.n293 90.001
R1127 VSS.n336 VSS.n335 90.001
R1128 VSS.n105 VSS.n84 90.001
R1129 VSS.n389 VSS.n388 90.001
R1130 VSS.n431 VSS.n430 90.001
R1131 VSS.n0 VSS.t3 87.5157
R1132 VSS.n443 VSS.t19 87.5157
R1133 VSS.n395 VSS.t11 87.5157
R1134 VSS.n353 VSS.t31 87.5157
R1135 VSS.n348 VSS.t15 87.5157
R1136 VSS.n300 VSS.t21 87.5157
R1137 VSS.n258 VSS.t25 87.5157
R1138 VSS.n253 VSS.t27 87.5157
R1139 VSS.n19 VSS.t1 87.4021
R1140 VSS.n442 VSS.t9 87.4021
R1141 VSS.n396 VSS.t7 87.4021
R1142 VSS.n354 VSS.t29 87.4021
R1143 VSS.n347 VSS.t13 87.4021
R1144 VSS.n301 VSS.t17 87.4021
R1145 VSS.n259 VSS.t23 87.4021
R1146 VSS.n252 VSS.t5 87.4021
R1147 VSS.n240 VSS.n239 84.8736
R1148 VSS.n181 VSS.n180 84.8736
R1149 VSS.n293 VSS.n292 84.8736
R1150 VSS.n335 VSS.n334 84.8736
R1151 VSS.n106 VSS.n105 84.8736
R1152 VSS.n388 VSS.n387 84.8736
R1153 VSS.n430 VSS.n429 84.8736
R1154 VSS.n440 VSS.n4 82.5754
R1155 VSS.n400 VSS.n398 82.5754
R1156 VSS.n358 VSS.n356 82.5754
R1157 VSS.n345 VSS.n92 82.5754
R1158 VSS.n305 VSS.n303 82.5754
R1159 VSS.n263 VSS.n261 82.5754
R1160 VSS.n250 VSS.n167 82.5754
R1161 VSS.n55 VSS.n54 67.3887
R1162 VSS.n403 VSS.n402 67.3887
R1163 VSS.n361 VSS.n360 67.3887
R1164 VSS.n131 VSS.n130 67.3887
R1165 VSS.n308 VSS.n307 67.3887
R1166 VSS.n266 VSS.n265 67.3887
R1167 VSS.n206 VSS.n205 67.3887
R1168 VSS.n17 VSS.n16 67.3887
R1169 VSS.n249 VSS.n248 62.5386
R1170 VSS.n262 VSS.n156 62.5386
R1171 VSS.n304 VSS.n142 62.5386
R1172 VSS.n344 VSS.n343 62.5386
R1173 VSS.n357 VSS.n80 62.5386
R1174 VSS.n399 VSS.n66 62.5386
R1175 VSS.n439 VSS.n438 62.5386
R1176 VSS.n442 VSS.n441 58.0587
R1177 VSS.n397 VSS.n396 58.0587
R1178 VSS.n355 VSS.n354 58.0587
R1179 VSS.n347 VSS.n346 58.0587
R1180 VSS.n302 VSS.n301 58.0587
R1181 VSS.n260 VSS.n259 58.0587
R1182 VSS.n252 VSS.n251 58.0587
R1183 VSS.n21 VSS.n19 58.0587
R1184 VSS.n23 VSS.n22 38.4926
R1185 VSS.n23 VSS.n18 34.379
R1186 VSS.n435 VSS.n54 33.1299
R1187 VSS.n402 VSS.n393 33.1299
R1188 VSS.n360 VSS.n88 33.1299
R1189 VSS.n340 VSS.n130 33.1299
R1190 VSS.n307 VSS.n298 33.1299
R1191 VSS.n265 VSS.n164 33.1299
R1192 VSS.n245 VSS.n205 33.1299
R1193 VSS.n26 VSS.n17 33.1299
R1194 VSS.n54 VSS.n2 6.03479
R1195 VSS.n402 VSS.n401 6.03479
R1196 VSS.n360 VSS.n359 6.03479
R1197 VSS.n130 VSS.n90 6.03479
R1198 VSS.n307 VSS.n306 6.03479
R1199 VSS.n265 VSS.n264 6.03479
R1200 VSS.n205 VSS.n165 6.03479
R1201 VSS.n20 VSS.n17 6.03479
R1202 VSS.n446 VSS.n445 5.23762
R1203 VSS.n445 VSS.n444 3.4105
R1204 VSS.n394 VSS.n1 3.4105
R1205 VSS.n352 VSS.n351 3.4105
R1206 VSS.n350 VSS.n349 3.4105
R1207 VSS.n299 VSS.n89 3.4105
R1208 VSS.n257 VSS.n256 3.4105
R1209 VSS.n255 VSS.n254 3.4105
R1210 VSS.n445 VSS.n1 1.82762
R1211 VSS.n351 VSS.n1 1.82762
R1212 VSS.n351 VSS.n350 1.82762
R1213 VSS.n350 VSS.n89 1.82762
R1214 VSS.n256 VSS.n89 1.82762
R1215 VSS.n256 VSS.n255 1.82762
R1216 VSS.n441 VSS.n2 1.2805
R1217 VSS.n401 VSS.n397 1.2805
R1218 VSS.n359 VSS.n355 1.2805
R1219 VSS.n346 VSS.n90 1.2805
R1220 VSS.n306 VSS.n302 1.2805
R1221 VSS.n264 VSS.n260 1.2805
R1222 VSS.n251 VSS.n165 1.2805
R1223 VSS.n21 VSS.n20 1.2805
R1224 VSS.n444 VSS.n443 0.783833
R1225 VSS.n395 VSS.n394 0.783833
R1226 VSS.n353 VSS.n352 0.783833
R1227 VSS.n349 VSS.n348 0.783833
R1228 VSS.n300 VSS.n299 0.783833
R1229 VSS.n258 VSS.n257 0.783833
R1230 VSS.n254 VSS.n253 0.783833
R1231 VSS.n446 VSS.n0 0.783833
R1232 VSS.n443 VSS.n442 0.290333
R1233 VSS.n396 VSS.n395 0.290333
R1234 VSS.n354 VSS.n353 0.290333
R1235 VSS.n348 VSS.n347 0.290333
R1236 VSS.n301 VSS.n300 0.290333
R1237 VSS.n259 VSS.n258 0.290333
R1238 VSS.n253 VSS.n252 0.290333
R1239 VSS.n19 VSS.n0 0.290333
R1240 VSS.n255 VSS 0.170875
R1241 VSS.n444 VSS 0.0151875
R1242 VSS.n394 VSS 0.0151875
R1243 VSS.n352 VSS 0.0151875
R1244 VSS.n349 VSS 0.0151875
R1245 VSS.n299 VSS 0.0151875
R1246 VSS.n257 VSS 0.0151875
R1247 VSS.n254 VSS 0.0151875
R1248 VSS VSS.n446 0.0151875
R1249 a_22393_1036.t1 a_22393_1036.n0 669.27
R1250 a_22393_1036.n0 a_22393_1036.n1 0.384333
R1251 a_22393_1036.n1 a_22393_1036.n2 0.1885
R1252 a_22393_1036.n2 a_22393_1036.t2 232.047
R1253 a_22393_1036.n2 a_22393_1036.t3 435.25
R1254 a_22393_1036.n1 a_22393_1036.t0 87.3032
R1255 a_22393_1036.n0 a_22393_1036.t4 314.149
R1256 a_22346_940.t1 a_22346_940.n2 668.986
R1257 a_22346_940.n2 a_22346_940.n0 0.196333
R1258 a_22346_940.n0 a_22346_940.n1 0.384333
R1259 a_22346_940.n1 a_22346_940.t0 232.115
R1260 a_22346_940.n1 a_22346_940.t2 87.1667
R1261 a_22346_940.n0 a_22346_940.t3 434.887
R1262 a_22346_940.n2 a_22346_940.t4 314.171
R1263 a_19283_1036.t1 a_19283_1036.n0 669.27
R1264 a_19283_1036.n0 a_19283_1036.n1 0.384333
R1265 a_19283_1036.n1 a_19283_1036.n2 0.1885
R1266 a_19283_1036.n2 a_19283_1036.t2 232.047
R1267 a_19283_1036.n2 a_19283_1036.t3 435.25
R1268 a_19283_1036.n1 a_19283_1036.t0 87.3032
R1269 a_19283_1036.n0 a_19283_1036.t4 314.149
R1270 a_19236_940.t1 a_19236_940.n2 668.986
R1271 a_19236_940.n2 a_19236_940.n0 0.196333
R1272 a_19236_940.n0 a_19236_940.n1 0.384333
R1273 a_19236_940.n1 a_19236_940.t0 232.115
R1274 a_19236_940.n1 a_19236_940.t2 87.1667
R1275 a_19236_940.n0 a_19236_940.t3 434.887
R1276 a_19236_940.n2 a_19236_940.t4 314.171
R1277 a_16173_1036.t1 a_16173_1036.n0 669.27
R1278 a_16173_1036.n0 a_16173_1036.n1 0.384333
R1279 a_16173_1036.n1 a_16173_1036.n2 0.1885
R1280 a_16173_1036.n2 a_16173_1036.t2 232.047
R1281 a_16173_1036.n2 a_16173_1036.t3 435.25
R1282 a_16173_1036.n1 a_16173_1036.t0 87.3032
R1283 a_16173_1036.n0 a_16173_1036.t4 314.149
R1284 a_16126_940.t0 a_16126_940.n2 668.986
R1285 a_16126_940.n2 a_16126_940.n0 0.196333
R1286 a_16126_940.n0 a_16126_940.n1 0.384333
R1287 a_16126_940.n1 a_16126_940.t2 232.115
R1288 a_16126_940.n1 a_16126_940.t1 87.1667
R1289 a_16126_940.n0 a_16126_940.t3 434.887
R1290 a_16126_940.n2 a_16126_940.t4 314.171
R1291 a_13063_1036.t0 a_13063_1036.n0 669.27
R1292 a_13063_1036.n0 a_13063_1036.n1 0.384333
R1293 a_13063_1036.n1 a_13063_1036.n2 0.1885
R1294 a_13063_1036.n2 a_13063_1036.t2 232.047
R1295 a_13063_1036.n2 a_13063_1036.t3 435.25
R1296 a_13063_1036.n1 a_13063_1036.t1 87.3032
R1297 a_13063_1036.n0 a_13063_1036.t4 314.149
R1298 a_13016_940.t0 a_13016_940.n2 668.986
R1299 a_13016_940.n2 a_13016_940.n0 0.196333
R1300 a_13016_940.n0 a_13016_940.n1 0.384333
R1301 a_13016_940.n1 a_13016_940.t2 232.115
R1302 a_13016_940.n1 a_13016_940.t1 87.1667
R1303 a_13016_940.n0 a_13016_940.t3 434.887
R1304 a_13016_940.n2 a_13016_940.t4 314.171
R1305 a_9953_1036.t1 a_9953_1036.n0 669.27
R1306 a_9953_1036.n0 a_9953_1036.n1 0.384333
R1307 a_9953_1036.n1 a_9953_1036.n2 0.1885
R1308 a_9953_1036.n2 a_9953_1036.t2 232.047
R1309 a_9953_1036.n2 a_9953_1036.t3 435.25
R1310 a_9953_1036.n1 a_9953_1036.t0 87.3032
R1311 a_9953_1036.n0 a_9953_1036.t4 314.149
R1312 a_9906_940.t0 a_9906_940.n2 668.986
R1313 a_9906_940.n2 a_9906_940.n0 0.196333
R1314 a_9906_940.n0 a_9906_940.n1 0.384333
R1315 a_9906_940.n1 a_9906_940.t2 232.115
R1316 a_9906_940.n1 a_9906_940.t1 87.1667
R1317 a_9906_940.n0 a_9906_940.t3 434.887
R1318 a_9906_940.n2 a_9906_940.t4 314.171
R1319 a_6843_1036.t1 a_6843_1036.n0 669.27
R1320 a_6843_1036.n0 a_6843_1036.n1 0.384333
R1321 a_6843_1036.n1 a_6843_1036.n2 0.1885
R1322 a_6843_1036.n2 a_6843_1036.t2 232.047
R1323 a_6843_1036.n2 a_6843_1036.t3 435.25
R1324 a_6843_1036.n1 a_6843_1036.t0 87.3032
R1325 a_6843_1036.n0 a_6843_1036.t4 314.149
R1326 a_6796_940.t0 a_6796_940.n2 668.986
R1327 a_6796_940.n2 a_6796_940.n0 0.196333
R1328 a_6796_940.n0 a_6796_940.n1 0.384333
R1329 a_6796_940.n1 a_6796_940.t2 232.115
R1330 a_6796_940.n1 a_6796_940.t1 87.1667
R1331 a_6796_940.n0 a_6796_940.t3 434.887
R1332 a_6796_940.n2 a_6796_940.t4 314.171
R1333 a_3733_1036.t1 a_3733_1036.n0 669.27
R1334 a_3733_1036.n0 a_3733_1036.n1 0.384333
R1335 a_3733_1036.n1 a_3733_1036.n2 0.1885
R1336 a_3733_1036.n2 a_3733_1036.t2 232.047
R1337 a_3733_1036.n2 a_3733_1036.t3 435.25
R1338 a_3733_1036.n1 a_3733_1036.t0 87.3032
R1339 a_3733_1036.n0 a_3733_1036.t4 314.149
R1340 a_3686_940.t1 a_3686_940.n2 668.986
R1341 a_3686_940.n2 a_3686_940.n0 0.196333
R1342 a_3686_940.n0 a_3686_940.n1 0.384333
R1343 a_3686_940.n1 a_3686_940.t0 232.115
R1344 a_3686_940.n1 a_3686_940.t2 87.1667
R1345 a_3686_940.n0 a_3686_940.t3 434.887
R1346 a_3686_940.n2 a_3686_940.t4 314.171
R1347 a_623_1036.t1 a_623_1036.n0 669.27
R1348 a_623_1036.n0 a_623_1036.n1 0.384333
R1349 a_623_1036.n1 a_623_1036.n2 0.1885
R1350 a_623_1036.n2 a_623_1036.t2 232.047
R1351 a_623_1036.n2 a_623_1036.t3 435.25
R1352 a_623_1036.n1 a_623_1036.t0 87.3032
R1353 a_623_1036.n0 a_623_1036.t4 314.149
R1354 a_576_940.t0 a_576_940.n2 668.986
R1355 a_576_940.n2 a_576_940.n0 0.196333
R1356 a_576_940.n0 a_576_940.n1 0.384333
R1357 a_576_940.n1 a_576_940.t2 232.115
R1358 a_576_940.n1 a_576_940.t1 87.1667
R1359 a_576_940.n0 a_576_940.t3 434.887
R1360 a_576_940.n2 a_576_940.t4 314.171
C62 BLB7 VSS 1.20736f
C63 BL7 VSS 0.41681f
C64 BLB6 VSS 1.19492f
C65 BL6 VSS 0.4048f
C66 BLB5 VSS 1.19492f
C67 BL5 VSS 0.4048f
C68 BLB4 VSS 1.19492f
C69 BL4 VSS 0.4048f
C70 BLB3 VSS 1.19492f
C71 BL3 VSS 0.4048f
C72 BLB2 VSS 1.19492f
C73 BL2 VSS 0.4048f
C74 BLB1 VSS 1.19492f
C75 BL1 VSS 0.4048f
C76 BLB0 VSS 1.20694f
C77 BL0 VSS 0.41683f
C78 WL VSS 41.75734f
C79 VDD VSS 37.15055f
C80 a_576_940.t0 VSS 0.0457f $ **FLOATING
C81 a_576_940.t4 VSS 0.10047f $ **FLOATING
C82 a_576_940.t3 VSS 0.12773f $ **FLOATING
C83 a_576_940.n0 VSS 0.4695f $ **FLOATING
C84 a_576_940.t1 VSS 0.16227f $ **FLOATING
C85 a_576_940.n1 VSS 1.88069f $ **FLOATING
C86 a_576_940.t2 VSS 0.07525f $ **FLOATING
C87 a_576_940.n2 VSS 1.3653f $ **FLOATING
C88 a_623_1036.t1 VSS 0.06189f $ **FLOATING
C89 a_623_1036.t4 VSS 0.13538f $ **FLOATING
C90 a_623_1036.n0 VSS 2.00198f $ **FLOATING
C91 a_623_1036.t0 VSS 0.22068f $ **FLOATING
C92 a_623_1036.n1 VSS 1.02318f $ **FLOATING
C93 a_623_1036.t3 VSS 0.17265f $ **FLOATING
C94 a_623_1036.n2 VSS 2.35325f $ **FLOATING
C95 a_623_1036.t2 VSS 0.10097f $ **FLOATING
C96 a_3686_940.t1 VSS 0.04607f $ **FLOATING
C97 a_3686_940.t4 VSS 0.10128f $ **FLOATING
C98 a_3686_940.t3 VSS 0.12876f $ **FLOATING
C99 a_3686_940.n0 VSS 0.47327f $ **FLOATING
C100 a_3686_940.t2 VSS 0.16357f $ **FLOATING
C101 a_3686_940.n1 VSS 1.89577f $ **FLOATING
C102 a_3686_940.t0 VSS 0.07585f $ **FLOATING
C103 a_3686_940.n2 VSS 1.37624f $ **FLOATING
C104 a_3733_1036.t1 VSS 0.06222f $ **FLOATING
C105 a_3733_1036.t4 VSS 0.13611f $ **FLOATING
C106 a_3733_1036.n0 VSS 2.01264f $ **FLOATING
C107 a_3733_1036.t0 VSS 0.22185f $ **FLOATING
C108 a_3733_1036.n1 VSS 1.02863f $ **FLOATING
C109 a_3733_1036.t3 VSS 0.17357f $ **FLOATING
C110 a_3733_1036.n2 VSS 2.36578f $ **FLOATING
C111 a_3733_1036.t2 VSS 0.10151f $ **FLOATING
C112 a_6796_940.t0 VSS 0.04607f $ **FLOATING
C113 a_6796_940.t4 VSS 0.10128f $ **FLOATING
C114 a_6796_940.t3 VSS 0.12876f $ **FLOATING
C115 a_6796_940.n0 VSS 0.47327f $ **FLOATING
C116 a_6796_940.t1 VSS 0.16357f $ **FLOATING
C117 a_6796_940.n1 VSS 1.89577f $ **FLOATING
C118 a_6796_940.t2 VSS 0.07585f $ **FLOATING
C119 a_6796_940.n2 VSS 1.37624f $ **FLOATING
C120 a_6843_1036.t1 VSS 0.06222f $ **FLOATING
C121 a_6843_1036.t4 VSS 0.13611f $ **FLOATING
C122 a_6843_1036.n0 VSS 2.01264f $ **FLOATING
C123 a_6843_1036.t0 VSS 0.22185f $ **FLOATING
C124 a_6843_1036.n1 VSS 1.02863f $ **FLOATING
C125 a_6843_1036.t3 VSS 0.17357f $ **FLOATING
C126 a_6843_1036.n2 VSS 2.36578f $ **FLOATING
C127 a_6843_1036.t2 VSS 0.10151f $ **FLOATING
C128 a_9906_940.t0 VSS 0.04607f $ **FLOATING
C129 a_9906_940.t4 VSS 0.10128f $ **FLOATING
C130 a_9906_940.t3 VSS 0.12876f $ **FLOATING
C131 a_9906_940.n0 VSS 0.47327f $ **FLOATING
C132 a_9906_940.t1 VSS 0.16357f $ **FLOATING
C133 a_9906_940.n1 VSS 1.89577f $ **FLOATING
C134 a_9906_940.t2 VSS 0.07585f $ **FLOATING
C135 a_9906_940.n2 VSS 1.37624f $ **FLOATING
C136 a_9953_1036.t1 VSS 0.06222f $ **FLOATING
C137 a_9953_1036.t4 VSS 0.13611f $ **FLOATING
C138 a_9953_1036.n0 VSS 2.01264f $ **FLOATING
C139 a_9953_1036.t0 VSS 0.22185f $ **FLOATING
C140 a_9953_1036.n1 VSS 1.02863f $ **FLOATING
C141 a_9953_1036.t3 VSS 0.17357f $ **FLOATING
C142 a_9953_1036.n2 VSS 2.36578f $ **FLOATING
C143 a_9953_1036.t2 VSS 0.10151f $ **FLOATING
C144 a_13016_940.t0 VSS 0.04607f $ **FLOATING
C145 a_13016_940.t4 VSS 0.10128f $ **FLOATING
C146 a_13016_940.t3 VSS 0.12876f $ **FLOATING
C147 a_13016_940.n0 VSS 0.47327f $ **FLOATING
C148 a_13016_940.t1 VSS 0.16357f $ **FLOATING
C149 a_13016_940.n1 VSS 1.89577f $ **FLOATING
C150 a_13016_940.t2 VSS 0.07585f $ **FLOATING
C151 a_13016_940.n2 VSS 1.37624f $ **FLOATING
C152 a_13063_1036.t0 VSS 0.06222f $ **FLOATING
C153 a_13063_1036.t4 VSS 0.13611f $ **FLOATING
C154 a_13063_1036.n0 VSS 2.01264f $ **FLOATING
C155 a_13063_1036.t1 VSS 0.22185f $ **FLOATING
C156 a_13063_1036.n1 VSS 1.02863f $ **FLOATING
C157 a_13063_1036.t3 VSS 0.17357f $ **FLOATING
C158 a_13063_1036.n2 VSS 2.36578f $ **FLOATING
C159 a_13063_1036.t2 VSS 0.10151f $ **FLOATING
C160 a_16126_940.t0 VSS 0.04607f $ **FLOATING
C161 a_16126_940.t4 VSS 0.10128f $ **FLOATING
C162 a_16126_940.t3 VSS 0.12876f $ **FLOATING
C163 a_16126_940.n0 VSS 0.47327f $ **FLOATING
C164 a_16126_940.t1 VSS 0.16357f $ **FLOATING
C165 a_16126_940.n1 VSS 1.89577f $ **FLOATING
C166 a_16126_940.t2 VSS 0.07585f $ **FLOATING
C167 a_16126_940.n2 VSS 1.37624f $ **FLOATING
C168 a_16173_1036.t1 VSS 0.06222f $ **FLOATING
C169 a_16173_1036.t4 VSS 0.13611f $ **FLOATING
C170 a_16173_1036.n0 VSS 2.01264f $ **FLOATING
C171 a_16173_1036.t0 VSS 0.22185f $ **FLOATING
C172 a_16173_1036.n1 VSS 1.02863f $ **FLOATING
C173 a_16173_1036.t3 VSS 0.17357f $ **FLOATING
C174 a_16173_1036.n2 VSS 2.36578f $ **FLOATING
C175 a_16173_1036.t2 VSS 0.10151f $ **FLOATING
C176 a_19236_940.t1 VSS 0.04607f $ **FLOATING
C177 a_19236_940.t4 VSS 0.10128f $ **FLOATING
C178 a_19236_940.t3 VSS 0.12876f $ **FLOATING
C179 a_19236_940.n0 VSS 0.47327f $ **FLOATING
C180 a_19236_940.t2 VSS 0.16357f $ **FLOATING
C181 a_19236_940.n1 VSS 1.89577f $ **FLOATING
C182 a_19236_940.t0 VSS 0.07585f $ **FLOATING
C183 a_19236_940.n2 VSS 1.37624f $ **FLOATING
C184 a_19283_1036.t1 VSS 0.06222f $ **FLOATING
C185 a_19283_1036.t4 VSS 0.13611f $ **FLOATING
C186 a_19283_1036.n0 VSS 2.01264f $ **FLOATING
C187 a_19283_1036.t0 VSS 0.22185f $ **FLOATING
C188 a_19283_1036.n1 VSS 1.02863f $ **FLOATING
C189 a_19283_1036.t3 VSS 0.17357f $ **FLOATING
C190 a_19283_1036.n2 VSS 2.36578f $ **FLOATING
C191 a_19283_1036.t2 VSS 0.10151f $ **FLOATING
C192 a_22346_940.t1 VSS 0.04532f $ **FLOATING
C193 a_22346_940.t4 VSS 0.09963f $ **FLOATING
C194 a_22346_940.t3 VSS 0.12667f $ **FLOATING
C195 a_22346_940.n0 VSS 0.46559f $ **FLOATING
C196 a_22346_940.t2 VSS 0.16092f $ **FLOATING
C197 a_22346_940.n1 VSS 1.86502f $ **FLOATING
C198 a_22346_940.t0 VSS 0.07462f $ **FLOATING
C199 a_22346_940.n2 VSS 1.35393f $ **FLOATING
C200 a_22393_1036.t1 VSS 0.06178f $ **FLOATING
C201 a_22393_1036.t4 VSS 0.13514f $ **FLOATING
C202 a_22393_1036.n0 VSS 1.99839f $ **FLOATING
C203 a_22393_1036.t0 VSS 0.22028f $ **FLOATING
C204 a_22393_1036.n1 VSS 1.02135f $ **FLOATING
C205 a_22393_1036.t3 VSS 0.17234f $ **FLOATING
C206 a_22393_1036.n2 VSS 2.34903f $ **FLOATING
C207 a_22393_1036.t2 VSS 0.10079f $ **FLOATING
C208 VDD.t1 VSS 0.01655f $ **FLOATING
C209 VDD.t9 VSS 0.01618f $ **FLOATING
C210 VDD.n0 VSS 0.8906f $ **FLOATING
C211 VDD.t31 VSS 0.01655f $ **FLOATING
C212 VDD.t15 VSS 0.01618f $ **FLOATING
C213 VDD.n1 VSS 0.8906f $ **FLOATING
C214 VDD.t14 VSS 0.31702f $ **FLOATING
C215 VDD.n2 VSS 0.04123f $ **FLOATING
C216 VDD.n3 VSS 0.04123f $ **FLOATING
C217 VDD.n4 VSS 0.04123f $ **FLOATING
C218 VDD.t30 VSS 0.20483f $ **FLOATING
C219 VDD.n5 VSS 0.04123f $ **FLOATING
C220 VDD.n6 VSS 0.04123f $ **FLOATING
C221 VDD.n7 VSS 0.04123f $ **FLOATING
C222 VDD.n9 VSS 0.14979f $ **FLOATING
C223 VDD.n10 VSS 0.04087f $ **FLOATING
C224 VDD.n11 VSS 0.04123f $ **FLOATING
C225 VDD.n12 VSS 0.04087f $ **FLOATING
C226 VDD.n13 VSS 0.04087f $ **FLOATING
C227 VDD.n14 VSS 0.15345f $ **FLOATING
C228 VDD.n15 VSS 0.16419f $ **FLOATING
C229 VDD.n16 VSS 0.04087f $ **FLOATING
C230 VDD.n17 VSS 0.04087f $ **FLOATING
C231 VDD.n18 VSS 0.04123f $ **FLOATING
C232 VDD.n19 VSS 0.04087f $ **FLOATING
C233 VDD.n20 VSS 0.04087f $ **FLOATING
C234 VDD.n21 VSS 0.21476f $ **FLOATING
C235 VDD.n22 VSS 0.03557f $ **FLOATING
C236 VDD.n23 VSS 0.45109f $ **FLOATING
C237 VDD.t23 VSS 0.01655f $ **FLOATING
C238 VDD.t29 VSS 0.01618f $ **FLOATING
C239 VDD.n24 VSS 0.8906f $ **FLOATING
C240 VDD.t28 VSS 0.31702f $ **FLOATING
C241 VDD.n25 VSS 0.04123f $ **FLOATING
C242 VDD.n26 VSS 0.04123f $ **FLOATING
C243 VDD.n27 VSS 0.04123f $ **FLOATING
C244 VDD.t22 VSS 0.20483f $ **FLOATING
C245 VDD.n28 VSS 0.04123f $ **FLOATING
C246 VDD.n29 VSS 0.04123f $ **FLOATING
C247 VDD.n30 VSS 0.04123f $ **FLOATING
C248 VDD.n32 VSS 0.14979f $ **FLOATING
C249 VDD.n33 VSS 0.04087f $ **FLOATING
C250 VDD.n34 VSS 0.04123f $ **FLOATING
C251 VDD.n35 VSS 0.04087f $ **FLOATING
C252 VDD.n36 VSS 0.04087f $ **FLOATING
C253 VDD.n37 VSS 0.15345f $ **FLOATING
C254 VDD.n38 VSS 0.16419f $ **FLOATING
C255 VDD.n39 VSS 0.04087f $ **FLOATING
C256 VDD.n40 VSS 0.04087f $ **FLOATING
C257 VDD.n41 VSS 0.04123f $ **FLOATING
C258 VDD.n42 VSS 0.04087f $ **FLOATING
C259 VDD.n43 VSS 0.04087f $ **FLOATING
C260 VDD.n44 VSS 0.21476f $ **FLOATING
C261 VDD.n45 VSS 0.03557f $ **FLOATING
C262 VDD.n46 VSS 0.82523f $ **FLOATING
C263 VDD.t13 VSS 0.01655f $ **FLOATING
C264 VDD.t21 VSS 0.01618f $ **FLOATING
C265 VDD.n47 VSS 0.8906f $ **FLOATING
C266 VDD.t20 VSS 0.31702f $ **FLOATING
C267 VDD.n48 VSS 0.04123f $ **FLOATING
C268 VDD.n49 VSS 0.04123f $ **FLOATING
C269 VDD.n50 VSS 0.04123f $ **FLOATING
C270 VDD.t12 VSS 0.20483f $ **FLOATING
C271 VDD.n51 VSS 0.04123f $ **FLOATING
C272 VDD.n52 VSS 0.04123f $ **FLOATING
C273 VDD.n53 VSS 0.04123f $ **FLOATING
C274 VDD.n55 VSS 0.14979f $ **FLOATING
C275 VDD.n56 VSS 0.04087f $ **FLOATING
C276 VDD.n57 VSS 0.04123f $ **FLOATING
C277 VDD.n58 VSS 0.04087f $ **FLOATING
C278 VDD.n59 VSS 0.04087f $ **FLOATING
C279 VDD.n60 VSS 0.15345f $ **FLOATING
C280 VDD.n61 VSS 0.16419f $ **FLOATING
C281 VDD.n62 VSS 0.04087f $ **FLOATING
C282 VDD.n63 VSS 0.04087f $ **FLOATING
C283 VDD.n64 VSS 0.04123f $ **FLOATING
C284 VDD.n65 VSS 0.04087f $ **FLOATING
C285 VDD.n66 VSS 0.04087f $ **FLOATING
C286 VDD.n67 VSS 0.21476f $ **FLOATING
C287 VDD.n68 VSS 0.03557f $ **FLOATING
C288 VDD.n69 VSS 0.82523f $ **FLOATING
C289 VDD.t27 VSS 0.01655f $ **FLOATING
C290 VDD.t11 VSS 0.01618f $ **FLOATING
C291 VDD.n70 VSS 0.8906f $ **FLOATING
C292 VDD.t10 VSS 0.31702f $ **FLOATING
C293 VDD.n71 VSS 0.04123f $ **FLOATING
C294 VDD.n72 VSS 0.04123f $ **FLOATING
C295 VDD.n73 VSS 0.04123f $ **FLOATING
C296 VDD.t26 VSS 0.20483f $ **FLOATING
C297 VDD.n74 VSS 0.04123f $ **FLOATING
C298 VDD.n75 VSS 0.04123f $ **FLOATING
C299 VDD.n76 VSS 0.04123f $ **FLOATING
C300 VDD.n78 VSS 0.14979f $ **FLOATING
C301 VDD.n79 VSS 0.04087f $ **FLOATING
C302 VDD.n80 VSS 0.04123f $ **FLOATING
C303 VDD.n81 VSS 0.04087f $ **FLOATING
C304 VDD.n82 VSS 0.04087f $ **FLOATING
C305 VDD.n83 VSS 0.15345f $ **FLOATING
C306 VDD.n84 VSS 0.16419f $ **FLOATING
C307 VDD.n85 VSS 0.04087f $ **FLOATING
C308 VDD.n86 VSS 0.04087f $ **FLOATING
C309 VDD.n87 VSS 0.04123f $ **FLOATING
C310 VDD.n88 VSS 0.04087f $ **FLOATING
C311 VDD.n89 VSS 0.04087f $ **FLOATING
C312 VDD.n90 VSS 0.21476f $ **FLOATING
C313 VDD.n91 VSS 0.03557f $ **FLOATING
C314 VDD.n92 VSS 0.82523f $ **FLOATING
C315 VDD.t7 VSS 0.01655f $ **FLOATING
C316 VDD.t19 VSS 0.01618f $ **FLOATING
C317 VDD.n93 VSS 0.8906f $ **FLOATING
C318 VDD.t18 VSS 0.31702f $ **FLOATING
C319 VDD.n94 VSS 0.04123f $ **FLOATING
C320 VDD.n95 VSS 0.04123f $ **FLOATING
C321 VDD.n96 VSS 0.04123f $ **FLOATING
C322 VDD.t6 VSS 0.20483f $ **FLOATING
C323 VDD.n97 VSS 0.04123f $ **FLOATING
C324 VDD.n98 VSS 0.04123f $ **FLOATING
C325 VDD.n99 VSS 0.04123f $ **FLOATING
C326 VDD.n101 VSS 0.14979f $ **FLOATING
C327 VDD.n102 VSS 0.04087f $ **FLOATING
C328 VDD.n103 VSS 0.04123f $ **FLOATING
C329 VDD.n104 VSS 0.04087f $ **FLOATING
C330 VDD.n105 VSS 0.04087f $ **FLOATING
C331 VDD.n106 VSS 0.15345f $ **FLOATING
C332 VDD.n107 VSS 0.16419f $ **FLOATING
C333 VDD.n108 VSS 0.04087f $ **FLOATING
C334 VDD.n109 VSS 0.04087f $ **FLOATING
C335 VDD.n110 VSS 0.04123f $ **FLOATING
C336 VDD.n111 VSS 0.04087f $ **FLOATING
C337 VDD.n112 VSS 0.04087f $ **FLOATING
C338 VDD.n113 VSS 0.21476f $ **FLOATING
C339 VDD.n114 VSS 0.03557f $ **FLOATING
C340 VDD.n115 VSS 0.82523f $ **FLOATING
C341 VDD.t17 VSS 0.01655f $ **FLOATING
C342 VDD.t5 VSS 0.01618f $ **FLOATING
C343 VDD.n116 VSS 0.8906f $ **FLOATING
C344 VDD.t4 VSS 0.31702f $ **FLOATING
C345 VDD.n117 VSS 0.04123f $ **FLOATING
C346 VDD.n118 VSS 0.04123f $ **FLOATING
C347 VDD.n119 VSS 0.04123f $ **FLOATING
C348 VDD.t16 VSS 0.20483f $ **FLOATING
C349 VDD.n120 VSS 0.04123f $ **FLOATING
C350 VDD.n121 VSS 0.04123f $ **FLOATING
C351 VDD.n122 VSS 0.04123f $ **FLOATING
C352 VDD.n124 VSS 0.14979f $ **FLOATING
C353 VDD.n125 VSS 0.04087f $ **FLOATING
C354 VDD.n126 VSS 0.04123f $ **FLOATING
C355 VDD.n127 VSS 0.04087f $ **FLOATING
C356 VDD.n128 VSS 0.04087f $ **FLOATING
C357 VDD.n129 VSS 0.15345f $ **FLOATING
C358 VDD.n130 VSS 0.16419f $ **FLOATING
C359 VDD.n131 VSS 0.04087f $ **FLOATING
C360 VDD.n132 VSS 0.04087f $ **FLOATING
C361 VDD.n133 VSS 0.04123f $ **FLOATING
C362 VDD.n134 VSS 0.04087f $ **FLOATING
C363 VDD.n135 VSS 0.04087f $ **FLOATING
C364 VDD.n136 VSS 0.21476f $ **FLOATING
C365 VDD.n137 VSS 0.03557f $ **FLOATING
C366 VDD.n138 VSS 0.82523f $ **FLOATING
C367 VDD.t3 VSS 0.01655f $ **FLOATING
C368 VDD.t25 VSS 0.01618f $ **FLOATING
C369 VDD.n139 VSS 0.8906f $ **FLOATING
C370 VDD.t24 VSS 0.31702f $ **FLOATING
C371 VDD.n140 VSS 0.04123f $ **FLOATING
C372 VDD.n141 VSS 0.04123f $ **FLOATING
C373 VDD.n142 VSS 0.04123f $ **FLOATING
C374 VDD.t2 VSS 0.20483f $ **FLOATING
C375 VDD.n143 VSS 0.04123f $ **FLOATING
C376 VDD.n144 VSS 0.04123f $ **FLOATING
C377 VDD.n145 VSS 0.04123f $ **FLOATING
C378 VDD.n147 VSS 0.14979f $ **FLOATING
C379 VDD.n148 VSS 0.04087f $ **FLOATING
C380 VDD.n149 VSS 0.04123f $ **FLOATING
C381 VDD.n150 VSS 0.04087f $ **FLOATING
C382 VDD.n151 VSS 0.04087f $ **FLOATING
C383 VDD.n152 VSS 0.15345f $ **FLOATING
C384 VDD.n153 VSS 0.16419f $ **FLOATING
C385 VDD.n154 VSS 0.04087f $ **FLOATING
C386 VDD.n155 VSS 0.04087f $ **FLOATING
C387 VDD.n156 VSS 0.04123f $ **FLOATING
C388 VDD.n157 VSS 0.04087f $ **FLOATING
C389 VDD.n158 VSS 0.04087f $ **FLOATING
C390 VDD.n159 VSS 0.21476f $ **FLOATING
C391 VDD.n160 VSS 0.03557f $ **FLOATING
C392 VDD.n161 VSS 1.60704f $ **FLOATING
C393 VDD.n162 VSS 0.45447f $ **FLOATING
C394 VDD.t8 VSS 0.31702f $ **FLOATING
C395 VDD.n163 VSS 0.04123f $ **FLOATING
C396 VDD.n164 VSS 0.04123f $ **FLOATING
C397 VDD.n165 VSS 0.04123f $ **FLOATING
C398 VDD.t0 VSS 0.20483f $ **FLOATING
C399 VDD.n166 VSS 0.04123f $ **FLOATING
C400 VDD.n167 VSS 0.04123f $ **FLOATING
C401 VDD.n168 VSS 0.04123f $ **FLOATING
C402 VDD.n170 VSS 0.14979f $ **FLOATING
C403 VDD.n171 VSS 0.04087f $ **FLOATING
C404 VDD.n172 VSS 0.04123f $ **FLOATING
C405 VDD.n173 VSS 0.04087f $ **FLOATING
C406 VDD.n174 VSS 0.04087f $ **FLOATING
C407 VDD.n175 VSS 0.15345f $ **FLOATING
C408 VDD.n176 VSS 0.16419f $ **FLOATING
C409 VDD.n177 VSS 0.04087f $ **FLOATING
C410 VDD.n178 VSS 0.04087f $ **FLOATING
C411 VDD.n179 VSS 0.04123f $ **FLOATING
C412 VDD.n180 VSS 0.04087f $ **FLOATING
C413 VDD.n181 VSS 0.04087f $ **FLOATING
C414 VDD.n182 VSS 0.21476f $ **FLOATING
C415 WL.t0 VSS 0.06608f $ **FLOATING
C416 WL.t1 VSS 0.06586f $ **FLOATING
C417 WL.n0 VSS 1.27792f $ **FLOATING
C418 WL.t14 VSS 0.06608f $ **FLOATING
C419 WL.t15 VSS 0.06586f $ **FLOATING
C420 WL.n1 VSS 1.27792f $ **FLOATING
C421 WL.n2 VSS 0.34053f $ **FLOATING
C422 WL.n3 VSS 0.7959f $ **FLOATING
C423 WL.t12 VSS 0.06608f $ **FLOATING
C424 WL.t13 VSS 0.06586f $ **FLOATING
C425 WL.n4 VSS 1.27792f $ **FLOATING
C426 WL.n5 VSS 0.34053f $ **FLOATING
C427 WL.n6 VSS 1.45602f $ **FLOATING
C428 WL.t10 VSS 0.06608f $ **FLOATING
C429 WL.t11 VSS 0.06586f $ **FLOATING
C430 WL.n7 VSS 1.27792f $ **FLOATING
C431 WL.n8 VSS 0.34053f $ **FLOATING
C432 WL.n9 VSS 1.45602f $ **FLOATING
C433 WL.t8 VSS 0.06608f $ **FLOATING
C434 WL.t9 VSS 0.06586f $ **FLOATING
C435 WL.n10 VSS 1.27792f $ **FLOATING
C436 WL.n11 VSS 0.34053f $ **FLOATING
C437 WL.n12 VSS 1.45602f $ **FLOATING
C438 WL.t6 VSS 0.06608f $ **FLOATING
C439 WL.t7 VSS 0.06586f $ **FLOATING
C440 WL.n13 VSS 1.27792f $ **FLOATING
C441 WL.n14 VSS 0.34053f $ **FLOATING
C442 WL.n15 VSS 1.45602f $ **FLOATING
C443 WL.t4 VSS 0.06608f $ **FLOATING
C444 WL.t5 VSS 0.06586f $ **FLOATING
C445 WL.n16 VSS 1.27792f $ **FLOATING
C446 WL.n17 VSS 0.34053f $ **FLOATING
C447 WL.n18 VSS 1.45602f $ **FLOATING
C448 WL.t2 VSS 0.06608f $ **FLOATING
C449 WL.t3 VSS 0.06586f $ **FLOATING
C450 WL.n19 VSS 1.27792f $ **FLOATING
C451 WL.n20 VSS 0.34053f $ **FLOATING
C452 WL.n21 VSS 2.83541f $ **FLOATING
C453 WL.n22 VSS 1.07963f $ **FLOATING
C454 BL0.t0 VSS 0.1643f $ **FLOATING
C455 BL0.n0 VSS 4.23337f $ **FLOATING
C456 BLB0.t0 VSS 0.08727f $ **FLOATING
C457 BLB0.n0 VSS 2.22358f $ **FLOATING
C458 BL1.t0 VSS 0.16554f $ **FLOATING
C459 BL1.n0 VSS 4.26552f $ **FLOATING
C460 BLB1.t0 VSS 0.08848f $ **FLOATING
C461 BLB1.n0 VSS 2.2544f $ **FLOATING
C462 BL2.t0 VSS 0.16554f $ **FLOATING
C463 BL2.n0 VSS 4.26552f $ **FLOATING
C464 BLB2.t0 VSS 0.08848f $ **FLOATING
C465 BLB2.n0 VSS 2.2544f $ **FLOATING
C466 BL3.t0 VSS 0.16554f $ **FLOATING
C467 BL3.n0 VSS 4.26552f $ **FLOATING
C468 BLB3.t0 VSS 0.08848f $ **FLOATING
C469 BLB3.n0 VSS 2.2544f $ **FLOATING
C470 BL4.t0 VSS 0.16554f $ **FLOATING
C471 BL4.n0 VSS 4.26552f $ **FLOATING
C472 BLB4.t0 VSS 0.08848f $ **FLOATING
C473 BLB4.n0 VSS 2.2544f $ **FLOATING
C474 BL5.t0 VSS 0.16554f $ **FLOATING
C475 BL5.n0 VSS 4.26552f $ **FLOATING
C476 BLB5.t0 VSS 0.08848f $ **FLOATING
C477 BLB5.n0 VSS 2.2544f $ **FLOATING
C478 BL6.t0 VSS 0.16554f $ **FLOATING
C479 BL6.n0 VSS 4.26552f $ **FLOATING
C480 BLB6.t0 VSS 0.08848f $ **FLOATING
C481 BLB6.n0 VSS 2.2544f $ **FLOATING
C482 BL7.t0 VSS 0.16435f $ **FLOATING
C483 BL7.n0 VSS 4.2347f $ **FLOATING
C484 BLB7.t0 VSS 0.08714f $ **FLOATING
C485 BLB7.n0 VSS 2.22029f $ **FLOATING
.ends
