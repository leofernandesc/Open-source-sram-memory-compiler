* NGSPICE file created from row_8_wl_flat.ext - technology: sky130A

.subckt row_8_wl_flat VDD VSS WL BL0 BLB0 BL1 BLB1 BL2 BLB2 BL3 BLB3 BL4 BLB4 BL5
+ BLB5 BL6 BLB6 BL7 BLB7
X0 a_665_916.t1 a_617_828.t4 VDD.t25 VDD.t24 sky130_fd_pr__pfet_01v8 ad=0.1218 pd=1.42 as=0.1218 ps=1.42 w=0.42 l=0.15
X1 a_14657_828.t1 a_14705_916.t3 VSS.t27 VSS.t26 sky130_fd_pr__nfet_01v8 ad=0.3654 pd=3.1 as=0.3654 ps=3.1 w=1.26 l=0.15
X2 a_7637_828.t0 a_7685_916.t4 VDD.t7 VDD.t6 sky130_fd_pr__pfet_01v8 ad=0.1218 pd=1.42 as=0.1218 ps=1.42 w=0.42 l=0.15
X3 a_11147_828.t0 a_11195_916.t4 VDD.t15 VDD.t14 sky130_fd_pr__pfet_01v8 ad=0.1218 pd=1.42 as=0.1218 ps=1.42 w=0.42 l=0.15
X4 a_14705_916.t0 a_14657_828.t3 VSS.t7 VSS.t6 sky130_fd_pr__nfet_01v8 ad=0.3654 pd=3.1 as=0.3654 ps=3.1 w=1.26 l=0.15
X5 a_617_828.t2 WL.t14 BLB0.t0 VSS.t31 sky130_fd_pr__nfet_01v8 ad=0.174 pd=1.78 as=0.174 ps=1.78 w=0.6 l=0.15
X6 a_21677_828.t2 a_21725_916.t3 VSS.t13 VSS.t12 sky130_fd_pr__nfet_01v8 ad=0.3654 pd=3.1 as=0.3654 ps=3.1 w=1.26 l=0.15
X7 a_665_916.t2 WL.t15 BL0.t0 VSS.t30 sky130_fd_pr__nfet_01v8 ad=0.174 pd=1.78 as=0.174 ps=1.78 w=0.6 l=0.15
X8 a_4175_916.t0 a_4127_828.t4 VDD.t23 VDD.t22 sky130_fd_pr__pfet_01v8 ad=0.1218 pd=1.42 as=0.1218 ps=1.42 w=0.42 l=0.15
X9 a_665_916.t0 a_617_828.t3 VSS.t25 VSS.t24 sky130_fd_pr__nfet_01v8 ad=0.3654 pd=3.1 as=0.3654 ps=3.1 w=1.26 l=0.15
X10 a_11195_916.t2 WL.t9 BL3.t0 VSS.t36 sky130_fd_pr__nfet_01v8 ad=0.174 pd=1.78 as=0.174 ps=1.78 w=0.6 l=0.15
X11 a_18167_828.t2 WL.t4 BLB5.t0 VSS.t41 sky130_fd_pr__nfet_01v8 ad=0.174 pd=1.78 as=0.174 ps=1.78 w=0.6 l=0.15
X12 a_21725_916.t0 a_21677_828.t3 VSS.t3 VSS.t2 sky130_fd_pr__nfet_01v8 ad=0.3654 pd=3.1 as=0.3654 ps=3.1 w=1.26 l=0.15
X13 a_25187_828.t1 a_25235_916.t4 VDD.t9 VDD.t8 sky130_fd_pr__pfet_01v8 ad=0.1218 pd=1.42 as=0.1218 ps=1.42 w=0.42 l=0.15
X14 a_617_828.t0 a_665_916.t4 VDD.t29 VDD.t28 sky130_fd_pr__pfet_01v8 ad=0.1218 pd=1.42 as=0.1218 ps=1.42 w=0.42 l=0.15
X15 a_21677_828.t1 a_21725_916.t4 VDD.t1 VDD.t0 sky130_fd_pr__pfet_01v8 ad=0.1218 pd=1.42 as=0.1218 ps=1.42 w=0.42 l=0.15
X16 a_7637_828.t1 a_7685_916.t3 VSS.t19 VSS.t18 sky130_fd_pr__nfet_01v8 ad=0.3654 pd=3.1 as=0.3654 ps=3.1 w=1.26 l=0.15
X17 a_7685_916.t1 a_7637_828.t3 VSS.t21 VSS.t20 sky130_fd_pr__nfet_01v8 ad=0.3654 pd=3.1 as=0.3654 ps=3.1 w=1.26 l=0.15
X18 a_18215_916.t1 a_18167_828.t3 VSS.t5 VSS.t4 sky130_fd_pr__nfet_01v8 ad=0.3654 pd=3.1 as=0.3654 ps=3.1 w=1.26 l=0.15
X19 a_25187_828.t0 WL.t0 BLB7.t0 VSS.t45 sky130_fd_pr__nfet_01v8 ad=0.174 pd=1.78 as=0.174 ps=1.78 w=0.6 l=0.15
X20 a_25235_916.t1 WL.t1 BL7.t0 VSS.t44 sky130_fd_pr__nfet_01v8 ad=0.174 pd=1.78 as=0.174 ps=1.78 w=0.6 l=0.15
X21 a_7685_916.t0 a_7637_828.t4 VDD.t19 VDD.t18 sky130_fd_pr__pfet_01v8 ad=0.1218 pd=1.42 as=0.1218 ps=1.42 w=0.42 l=0.15
X22 a_11147_828.t2 WL.t8 BLB3.t0 VSS.t37 sky130_fd_pr__nfet_01v8 ad=0.174 pd=1.78 as=0.174 ps=1.78 w=0.6 l=0.15
X23 a_4175_916.t2 WL.t13 BL1.t0 VSS.t32 sky130_fd_pr__nfet_01v8 ad=0.174 pd=1.78 as=0.174 ps=1.78 w=0.6 l=0.15
X24 a_4127_828.t1 a_4175_916.t4 VDD.t21 VDD.t20 sky130_fd_pr__pfet_01v8 ad=0.1218 pd=1.42 as=0.1218 ps=1.42 w=0.42 l=0.15
X25 a_617_828.t1 a_665_916.t3 VSS.t9 VSS.t8 sky130_fd_pr__nfet_01v8 ad=0.3654 pd=3.1 as=0.3654 ps=3.1 w=1.26 l=0.15
X26 a_18215_916.t0 a_18167_828.t4 VDD.t5 VDD.t4 sky130_fd_pr__pfet_01v8 ad=0.1218 pd=1.42 as=0.1218 ps=1.42 w=0.42 l=0.15
X27 a_11195_916.t1 a_11147_828.t3 VSS.t17 VSS.t16 sky130_fd_pr__nfet_01v8 ad=0.3654 pd=3.1 as=0.3654 ps=3.1 w=1.26 l=0.15
X28 a_18167_828.t1 a_18215_916.t3 VSS.t11 VSS.t10 sky130_fd_pr__nfet_01v8 ad=0.3654 pd=3.1 as=0.3654 ps=3.1 w=1.26 l=0.15
X29 a_14657_828.t0 a_14705_916.t4 VDD.t11 VDD.t10 sky130_fd_pr__pfet_01v8 ad=0.1218 pd=1.42 as=0.1218 ps=1.42 w=0.42 l=0.15
X30 a_21725_916.t1 a_21677_828.t4 VDD.t13 VDD.t12 sky130_fd_pr__pfet_01v8 ad=0.1218 pd=1.42 as=0.1218 ps=1.42 w=0.42 l=0.15
X31 a_4127_828.t0 WL.t12 BLB1.t0 VSS.t33 sky130_fd_pr__nfet_01v8 ad=0.174 pd=1.78 as=0.174 ps=1.78 w=0.6 l=0.15
X32 a_14657_828.t2 WL.t6 BLB4.t0 VSS.t39 sky130_fd_pr__nfet_01v8 ad=0.174 pd=1.78 as=0.174 ps=1.78 w=0.6 l=0.15
X33 a_14705_916.t2 WL.t7 BL4.t0 VSS.t38 sky130_fd_pr__nfet_01v8 ad=0.174 pd=1.78 as=0.174 ps=1.78 w=0.6 l=0.15
X34 a_25235_916.t2 a_25187_828.t3 VSS.t47 VSS.t46 sky130_fd_pr__nfet_01v8 ad=0.3654 pd=3.1 as=0.3654 ps=3.1 w=1.26 l=0.15
X35 a_11195_916.t0 a_11147_828.t4 VDD.t17 VDD.t16 sky130_fd_pr__pfet_01v8 ad=0.1218 pd=1.42 as=0.1218 ps=1.42 w=0.42 l=0.15
X36 a_11147_828.t1 a_11195_916.t3 VSS.t15 VSS.t14 sky130_fd_pr__nfet_01v8 ad=0.3654 pd=3.1 as=0.3654 ps=3.1 w=1.26 l=0.15
X37 a_4175_916.t1 a_4127_828.t3 VSS.t29 VSS.t28 sky130_fd_pr__nfet_01v8 ad=0.3654 pd=3.1 as=0.3654 ps=3.1 w=1.26 l=0.15
X38 a_21677_828.t0 WL.t2 BLB6.t0 VSS.t43 sky130_fd_pr__nfet_01v8 ad=0.174 pd=1.78 as=0.174 ps=1.78 w=0.6 l=0.15
X39 a_18167_828.t0 a_18215_916.t4 VDD.t3 VDD.t2 sky130_fd_pr__pfet_01v8 ad=0.1218 pd=1.42 as=0.1218 ps=1.42 w=0.42 l=0.15
X40 a_21725_916.t2 WL.t3 BL6.t0 VSS.t42 sky130_fd_pr__nfet_01v8 ad=0.174 pd=1.78 as=0.174 ps=1.78 w=0.6 l=0.15
X41 a_25235_916.t0 a_25187_828.t4 VDD.t31 VDD.t30 sky130_fd_pr__pfet_01v8 ad=0.1218 pd=1.42 as=0.1218 ps=1.42 w=0.42 l=0.15
X42 a_7637_828.t2 WL.t10 BLB2.t0 VSS.t35 sky130_fd_pr__nfet_01v8 ad=0.174 pd=1.78 as=0.174 ps=1.78 w=0.6 l=0.15
X43 a_25187_828.t2 a_25235_916.t3 VSS.t1 VSS.t0 sky130_fd_pr__nfet_01v8 ad=0.3654 pd=3.1 as=0.3654 ps=3.1 w=1.26 l=0.15
X44 a_7685_916.t2 WL.t11 BL2.t0 VSS.t34 sky130_fd_pr__nfet_01v8 ad=0.174 pd=1.78 as=0.174 ps=1.78 w=0.6 l=0.15
X45 a_14705_916.t1 a_14657_828.t4 VDD.t27 VDD.t26 sky130_fd_pr__pfet_01v8 ad=0.1218 pd=1.42 as=0.1218 ps=1.42 w=0.42 l=0.15
X46 a_4127_828.t2 a_4175_916.t3 VSS.t23 VSS.t22 sky130_fd_pr__nfet_01v8 ad=0.3654 pd=3.1 as=0.3654 ps=3.1 w=1.26 l=0.15
X47 a_18215_916.t2 WL.t5 BL5.t0 VSS.t40 sky130_fd_pr__nfet_01v8 ad=0.174 pd=1.78 as=0.174 ps=1.78 w=0.6 l=0.15
C0 BLB3 VDD 0
C1 BLB5 BL5 1.91166f
C2 BLB5 BLB4 0.05276f
C3 WL BL1 2.23979f
C4 WL BL0 2.23979f
C5 BLB2 BL3 0
C6 BLB0 BL1 0
C7 WL BL5 2.23979f
C8 BLB0 BL0 1.91166f
C9 BLB5 BL6 0
C10 WL BLB4 0.28215f
C11 WL BL3 2.23979f
C12 WL BL6 2.23979f
C13 WL BLB2 0.28215f
C14 WL BLB5 0.28215f
C15 BL2 BL1 0.05235f
C16 BLB0 WL 0.28215f
C17 VDD BL1 0
C18 BL0 VDD 0
C19 BL5 VDD 0
C20 BLB1 BL1 1.91166f
C21 BL3 BL2 0.05235f
C22 BLB4 VDD 0
C23 BLB2 BL2 1.91166f
C24 BL3 VDD 0
C25 BL6 VDD 0
C26 BLB2 VDD 0
C27 BLB5 VDD 0
C28 WL BL2 2.23979f
C29 BLB2 BLB1 0.05276f
C30 BLB3 BL4 0
C31 WL VDD 0.03118f
C32 BLB0 VDD 0
C33 WL BLB1 0.28215f
C34 BLB0 BLB1 0.05276f
C35 BLB6 BL6 1.91166f
C36 BL7 BL6 0.05235f
C37 WL BLB7 0.28212f
C38 BLB6 BLB5 0.05276f
C39 VDD BL2 0
C40 BLB1 BL2 0
C41 BLB6 WL 0.28215f
C42 BL7 WL 2.23979f
C43 VDD BLB1 0
C44 BL5 BL4 0.05235f
C45 BLB4 BL4 1.91166f
C46 BL3 BL4 0.05235f
C47 VDD BLB7 0
C48 BLB4 BLB3 0.05276f
C49 BL3 BLB3 1.91166f
C50 BLB6 VDD 0
C51 WL BL4 2.23979f
C52 BL7 VDD 0
C53 BLB2 BLB3 0.05276f
C54 WL BLB3 0.28215f
C55 BLB6 BLB7 0.05276f
C56 BL7 BLB7 1.91166f
C57 BL0 BL1 0.05235f
C58 BLB6 BL7 0
C59 BL4 VDD 0
C60 BLB4 BL5 0
C61 BL6 BL5 0.05235f
R0 BLB7.n0 BLB7.t0 233.899
R1 BLB7.n0 BLB7 3.42617
R2 BLB7 BLB7.n0 0.0135556
R3 BL7.n0 BL7.t0 233.581
R4 BL7.n0 BL7 3.42617
R5 BL7 BL7.n0 0.0135556
R6 BLB6.n0 BLB6.t0 233.899
R7 BLB6.n0 BLB6 3.42617
R8 BLB6 BLB6.n0 0.0135556
R9 BL6.n0 BL6.t0 233.581
R10 BL6.n0 BL6 3.42617
R11 BL6 BL6.n0 0.0135556
R12 BLB5.n0 BLB5.t0 233.899
R13 BLB5.n0 BLB5 3.42617
R14 BLB5 BLB5.n0 0.0135556
R15 BL5.n0 BL5.t0 233.581
R16 BL5.n0 BL5 3.42617
R17 BL5 BL5.n0 0.0135556
R18 BLB4.n0 BLB4.t0 233.899
R19 BLB4.n0 BLB4 3.42617
R20 BLB4 BLB4.n0 0.0135556
R21 BL4.n0 BL4.t0 233.581
R22 BL4.n0 BL4 3.42617
R23 BL4 BL4.n0 0.0135556
R24 BLB3.n0 BLB3.t0 233.899
R25 BLB3.n0 BLB3 3.42617
R26 BLB3 BLB3.n0 0.0135556
R27 BL3.n0 BL3.t0 233.581
R28 BL3.n0 BL3 3.42617
R29 BL3 BL3.n0 0.0135556
R30 BLB2.n0 BLB2.t0 233.899
R31 BLB2.n0 BLB2 3.42617
R32 BLB2 BLB2.n0 0.0135556
R33 BL2.n0 BL2.t0 233.581
R34 BL2.n0 BL2 3.42617
R35 BL2 BL2.n0 0.0135556
R36 BLB1.n0 BLB1.t0 233.899
R37 BLB1.n0 BLB1 3.42617
R38 BLB1 BLB1.n0 0.0135556
R39 BL1.n0 BL1.t0 233.581
R40 BL1.n0 BL1 3.42617
R41 BL1 BL1.n0 0.0135556
R42 BLB0.n0 BLB0.t0 233.899
R43 BLB0.n0 BLB0 3.42617
R44 BLB0 BLB0.n0 0.0135556
R45 BL0.n0 BL0.t0 233.581
R46 BL0.n0 BL0 3.42617
R47 BL0 BL0.n0 0.0135556
R48 WL.n1 WL.t15 319.156
R49 WL.n4 WL.t13 319.156
R50 WL.n7 WL.t11 319.156
R51 WL.n10 WL.t9 319.156
R52 WL.n13 WL.t7 319.156
R53 WL.n16 WL.t5 319.156
R54 WL.n19 WL.t3 319.156
R55 WL.n0 WL.t1 319.156
R56 WL.n1 WL.t14 317.147
R57 WL.n4 WL.t12 317.147
R58 WL.n7 WL.t10 317.147
R59 WL.n10 WL.t8 317.147
R60 WL.n13 WL.t6 317.147
R61 WL.n16 WL.t4 317.147
R62 WL.n19 WL.t2 317.147
R63 WL.n0 WL.t0 317.147
R64 WL.n2 WL.n1 13.4945
R65 WL.n5 WL.n4 13.4945
R66 WL.n8 WL.n7 13.4945
R67 WL.n11 WL.n10 13.4945
R68 WL.n14 WL.n13 13.4945
R69 WL.n17 WL.n16 13.4945
R70 WL.n20 WL.n19 13.4945
R71 WL.n22 WL.n0 13.4945
R72 WL.n22 WL.n21 5.46479
R73 WL.n21 WL.n20 3.4105
R74 WL.n18 WL.n17 3.4105
R75 WL.n15 WL.n14 3.4105
R76 WL.n12 WL.n11 3.4105
R77 WL.n9 WL.n8 3.4105
R78 WL.n6 WL.n5 3.4105
R79 WL.n3 WL.n2 3.4105
R80 WL.n21 WL.n18 2.05479
R81 WL.n18 WL.n15 2.05479
R82 WL.n15 WL.n12 2.05479
R83 WL.n12 WL.n9 2.05479
R84 WL.n9 WL.n6 2.05479
R85 WL.n6 WL.n3 2.05479
R86 WL.n3 WL 0.166958
R87 WL.n2 WL 0.0135556
R88 WL.n5 WL 0.0135556
R89 WL.n8 WL 0.0135556
R90 WL.n11 WL 0.0135556
R91 WL.n14 WL 0.0135556
R92 WL.n17 WL 0.0135556
R93 WL.n20 WL 0.0135556
R94 WL WL.n22 0.0135556
R95 VDD.n3 VDD.t29 671.755
R96 VDD.n8 VDD.t21 671.755
R97 VDD.n13 VDD.t7 671.755
R98 VDD.n18 VDD.t15 671.755
R99 VDD.n23 VDD.t11 671.755
R100 VDD.n28 VDD.t3 671.755
R101 VDD.n33 VDD.t1 671.755
R102 VDD.n0 VDD.t9 671.755
R103 VDD.n5 VDD.t25 671.547
R104 VDD.n10 VDD.t23 671.547
R105 VDD.n15 VDD.t19 671.547
R106 VDD.n20 VDD.t17 671.547
R107 VDD.n25 VDD.t27 671.547
R108 VDD.n30 VDD.t5 671.547
R109 VDD.n35 VDD.t13 671.547
R110 VDD.n2 VDD.t31 671.547
R111 VDD.n3 VDD.t28 186.004
R112 VDD.n8 VDD.t20 186.004
R113 VDD.n13 VDD.t6 186.004
R114 VDD.n18 VDD.t14 186.004
R115 VDD.n23 VDD.t10 186.004
R116 VDD.n28 VDD.t2 186.004
R117 VDD.n33 VDD.t0 186.004
R118 VDD.n0 VDD.t8 186.004
R119 VDD.n4 VDD.t24 185.75
R120 VDD.n9 VDD.t22 185.75
R121 VDD.n14 VDD.t18 185.75
R122 VDD.n19 VDD.t16 185.75
R123 VDD.n24 VDD.t26 185.75
R124 VDD.n29 VDD.t4 185.75
R125 VDD.n34 VDD.t12 185.75
R126 VDD.n1 VDD.t30 185.75
R127 VDD.n38 VDD.n37 5.46479
R128 VDD.n37 VDD.n36 3.4105
R129 VDD.n32 VDD.n31 3.4105
R130 VDD.n27 VDD.n26 3.4105
R131 VDD.n22 VDD.n21 3.4105
R132 VDD.n17 VDD.n16 3.4105
R133 VDD.n12 VDD.n11 3.4105
R134 VDD.n7 VDD.n6 3.4105
R135 VDD.n37 VDD.n32 2.05479
R136 VDD.n32 VDD.n27 2.05479
R137 VDD.n27 VDD.n22 2.05479
R138 VDD.n22 VDD.n17 2.05479
R139 VDD.n17 VDD.n12 2.05479
R140 VDD.n12 VDD.n7 2.05479
R141 VDD.n4 VDD.n3 0.269071
R142 VDD.n9 VDD.n8 0.269071
R143 VDD.n14 VDD.n13 0.269071
R144 VDD.n19 VDD.n18 0.269071
R145 VDD.n24 VDD.n23 0.269071
R146 VDD.n29 VDD.n28 0.269071
R147 VDD.n34 VDD.n33 0.269071
R148 VDD.n1 VDD.n0 0.269071
R149 VDD.n7 VDD 0.166958
R150 VDD.n6 VDD.n5 0.127512
R151 VDD.n11 VDD.n10 0.127512
R152 VDD.n16 VDD.n15 0.127512
R153 VDD.n21 VDD.n20 0.127512
R154 VDD.n26 VDD.n25 0.127512
R155 VDD.n31 VDD.n30 0.127512
R156 VDD.n36 VDD.n35 0.127512
R157 VDD.n38 VDD.n2 0.127512
R158 VDD.n5 VDD.n4 0.0900238
R159 VDD.n10 VDD.n9 0.0900238
R160 VDD.n15 VDD.n14 0.0900238
R161 VDD.n20 VDD.n19 0.0900238
R162 VDD.n25 VDD.n24 0.0900238
R163 VDD.n30 VDD.n29 0.0900238
R164 VDD.n35 VDD.n34 0.0900238
R165 VDD.n2 VDD.n1 0.0900238
R166 VDD.n6 VDD 0.0135556
R167 VDD.n11 VDD 0.0135556
R168 VDD.n16 VDD 0.0135556
R169 VDD.n21 VDD 0.0135556
R170 VDD.n26 VDD 0.0135556
R171 VDD.n31 VDD 0.0135556
R172 VDD.n36 VDD 0.0135556
R173 VDD VDD.n38 0.0135556
R174 VSS.n77 VSS.n39 13299.1
R175 VSS.n82 VSS.n39 8261.87
R176 VSS.n105 VSS.n34 8261.87
R177 VSS.n128 VSS.n29 8261.87
R178 VSS.n151 VSS.n24 8261.87
R179 VSS.n174 VSS.n19 8261.87
R180 VSS.n197 VSS.n8 8261.87
R181 VSS.n263 VSS.n214 8261.87
R182 VSS.n250 VSS.n226 8261.87
R183 VSS.n88 VSS.n39 6428.13
R184 VSS.n111 VSS.n34 6428.13
R185 VSS.n99 VSS.n34 6428.13
R186 VSS.n134 VSS.n29 6428.13
R187 VSS.n122 VSS.n29 6428.13
R188 VSS.n157 VSS.n24 6428.13
R189 VSS.n145 VSS.n24 6428.13
R190 VSS.n180 VSS.n19 6428.13
R191 VSS.n168 VSS.n19 6428.13
R192 VSS.n203 VSS.n8 6428.13
R193 VSS.n191 VSS.n8 6428.13
R194 VSS.n263 VSS.n262 6428.13
R195 VSS.n264 VSS.n263 6428.13
R196 VSS.n250 VSS.n249 6428.13
R197 VSS.n251 VSS.n250 6428.13
R198 VSS.n233 VSS.n229 2456.71
R199 VSS.n233 VSS.n230 2456.71
R200 VSS.n232 VSS.n229 2456.71
R201 VSS.n232 VSS.n230 2456.71
R202 VSS.n240 VSS.n236 2456.71
R203 VSS.n240 VSS.n237 2456.71
R204 VSS.n239 VSS.n236 2456.71
R205 VSS.n239 VSS.n237 2456.71
R206 VSS.n267 VSS.n3 2456.71
R207 VSS.n267 VSS.n4 2456.71
R208 VSS.n266 VSS.n3 2456.71
R209 VSS.n266 VSS.n4 2456.71
R210 VSS.n221 VSS.n217 2456.71
R211 VSS.n221 VSS.n218 2456.71
R212 VSS.n220 VSS.n217 2456.71
R213 VSS.n220 VSS.n218 2456.71
R214 VSS.n195 VSS.n16 2456.71
R215 VSS.n193 VSS.n16 2456.71
R216 VSS.n195 VSS.n194 2456.71
R217 VSS.n194 VSS.n193 2456.71
R218 VSS.n201 VSS.n9 2456.71
R219 VSS.n199 VSS.n9 2456.71
R220 VSS.n201 VSS.n200 2456.71
R221 VSS.n200 VSS.n199 2456.71
R222 VSS.n172 VSS.n21 2456.71
R223 VSS.n170 VSS.n21 2456.71
R224 VSS.n172 VSS.n171 2456.71
R225 VSS.n171 VSS.n170 2456.71
R226 VSS.n178 VSS.n20 2456.71
R227 VSS.n176 VSS.n20 2456.71
R228 VSS.n178 VSS.n177 2456.71
R229 VSS.n177 VSS.n176 2456.71
R230 VSS.n149 VSS.n26 2456.71
R231 VSS.n147 VSS.n26 2456.71
R232 VSS.n149 VSS.n148 2456.71
R233 VSS.n148 VSS.n147 2456.71
R234 VSS.n155 VSS.n25 2456.71
R235 VSS.n153 VSS.n25 2456.71
R236 VSS.n155 VSS.n154 2456.71
R237 VSS.n154 VSS.n153 2456.71
R238 VSS.n126 VSS.n31 2456.71
R239 VSS.n124 VSS.n31 2456.71
R240 VSS.n126 VSS.n125 2456.71
R241 VSS.n125 VSS.n124 2456.71
R242 VSS.n132 VSS.n30 2456.71
R243 VSS.n130 VSS.n30 2456.71
R244 VSS.n132 VSS.n131 2456.71
R245 VSS.n131 VSS.n130 2456.71
R246 VSS.n103 VSS.n36 2456.71
R247 VSS.n101 VSS.n36 2456.71
R248 VSS.n103 VSS.n102 2456.71
R249 VSS.n102 VSS.n101 2456.71
R250 VSS.n109 VSS.n35 2456.71
R251 VSS.n107 VSS.n35 2456.71
R252 VSS.n109 VSS.n108 2456.71
R253 VSS.n108 VSS.n107 2456.71
R254 VSS.n80 VSS.n76 2456.71
R255 VSS.n78 VSS.n76 2456.71
R256 VSS.n80 VSS.n79 2456.71
R257 VSS.n79 VSS.n78 2456.71
R258 VSS.n86 VSS.n40 2456.71
R259 VSS.n84 VSS.n40 2456.71
R260 VSS.n86 VSS.n85 2456.71
R261 VSS.n85 VSS.n84 2456.71
R262 VSS.n99 VSS.n98 2278.15
R263 VSS.n122 VSS.n121 2278.15
R264 VSS.n145 VSS.n144 2278.15
R265 VSS.n168 VSS.n167 2278.15
R266 VSS.n191 VSS.n190 2278.15
R267 VSS.n264 VSS.n213 2278.15
R268 VSS.n252 VSS.n251 2278.15
R269 VSS.n245 VSS.n228 2074.29
R270 VSS.n247 VSS.n228 2074.29
R271 VSS.n246 VSS.n245 2074.29
R272 VSS.n247 VSS.n246 2074.29
R273 VSS.n258 VSS.n216 2074.29
R274 VSS.n260 VSS.n216 2074.29
R275 VSS.n259 VSS.n258 2074.29
R276 VSS.n260 VSS.n259 2074.29
R277 VSS.n253 VSS.n224 2074.29
R278 VSS.n255 VSS.n224 2074.29
R279 VSS.n254 VSS.n253 2074.29
R280 VSS.n255 VSS.n254 2074.29
R281 VSS.n207 VSS.n7 2074.29
R282 VSS.n205 VSS.n7 2074.29
R283 VSS.n207 VSS.n206 2074.29
R284 VSS.n206 VSS.n205 2074.29
R285 VSS.n212 VSS.n6 2074.29
R286 VSS.n210 VSS.n6 2074.29
R287 VSS.n212 VSS.n211 2074.29
R288 VSS.n211 VSS.n210 2074.29
R289 VSS.n184 VSS.n18 2074.29
R290 VSS.n182 VSS.n18 2074.29
R291 VSS.n184 VSS.n183 2074.29
R292 VSS.n183 VSS.n182 2074.29
R293 VSS.n189 VSS.n17 2074.29
R294 VSS.n187 VSS.n17 2074.29
R295 VSS.n189 VSS.n188 2074.29
R296 VSS.n188 VSS.n187 2074.29
R297 VSS.n161 VSS.n23 2074.29
R298 VSS.n159 VSS.n23 2074.29
R299 VSS.n161 VSS.n160 2074.29
R300 VSS.n160 VSS.n159 2074.29
R301 VSS.n166 VSS.n22 2074.29
R302 VSS.n164 VSS.n22 2074.29
R303 VSS.n166 VSS.n165 2074.29
R304 VSS.n165 VSS.n164 2074.29
R305 VSS.n138 VSS.n28 2074.29
R306 VSS.n136 VSS.n28 2074.29
R307 VSS.n138 VSS.n137 2074.29
R308 VSS.n137 VSS.n136 2074.29
R309 VSS.n143 VSS.n27 2074.29
R310 VSS.n141 VSS.n27 2074.29
R311 VSS.n143 VSS.n142 2074.29
R312 VSS.n142 VSS.n141 2074.29
R313 VSS.n115 VSS.n33 2074.29
R314 VSS.n113 VSS.n33 2074.29
R315 VSS.n115 VSS.n114 2074.29
R316 VSS.n114 VSS.n113 2074.29
R317 VSS.n120 VSS.n32 2074.29
R318 VSS.n118 VSS.n32 2074.29
R319 VSS.n120 VSS.n119 2074.29
R320 VSS.n119 VSS.n118 2074.29
R321 VSS.n92 VSS.n38 2074.29
R322 VSS.n90 VSS.n38 2074.29
R323 VSS.n92 VSS.n91 2074.29
R324 VSS.n91 VSS.n90 2074.29
R325 VSS.n97 VSS.n37 2074.29
R326 VSS.n95 VSS.n37 2074.29
R327 VSS.n97 VSS.n96 2074.29
R328 VSS.n96 VSS.n95 2074.29
R329 VSS.n244 VSS.n243 682.918
R330 VSS.n243 VSS.n242 518.745
R331 VSS.n82 VSS.n81 501.663
R332 VSS.n105 VSS.n104 501.663
R333 VSS.n128 VSS.n127 501.663
R334 VSS.n151 VSS.n150 501.663
R335 VSS.n174 VSS.n173 501.663
R336 VSS.n197 VSS.n196 501.663
R337 VSS.n214 VSS.n5 501.663
R338 VSS.n231 VSS.n226 501.663
R339 VSS.n94 VSS.n93 482.471
R340 VSS.n117 VSS.n116 482.471
R341 VSS.n140 VSS.n139 482.471
R342 VSS.n163 VSS.n162 482.471
R343 VSS.n186 VSS.n185 482.471
R344 VSS.n209 VSS.n208 482.471
R345 VSS.n257 VSS.n256 482.471
R346 VSS.n87 VSS.t8 412.827
R347 VSS.n83 VSS.t8 412.827
R348 VSS.n81 VSS.t24 412.827
R349 VSS.n77 VSS.t24 412.827
R350 VSS.n110 VSS.t22 412.827
R351 VSS.n106 VSS.t22 412.827
R352 VSS.n104 VSS.t28 412.827
R353 VSS.n100 VSS.t28 412.827
R354 VSS.n133 VSS.t18 412.827
R355 VSS.n129 VSS.t18 412.827
R356 VSS.n127 VSS.t20 412.827
R357 VSS.n123 VSS.t20 412.827
R358 VSS.n156 VSS.t14 412.827
R359 VSS.n152 VSS.t14 412.827
R360 VSS.n150 VSS.t16 412.827
R361 VSS.n146 VSS.t16 412.827
R362 VSS.n179 VSS.t26 412.827
R363 VSS.n175 VSS.t26 412.827
R364 VSS.n173 VSS.t6 412.827
R365 VSS.n169 VSS.t6 412.827
R366 VSS.n202 VSS.t10 412.827
R367 VSS.n198 VSS.t10 412.827
R368 VSS.n196 VSS.t4 412.827
R369 VSS.n192 VSS.t4 412.827
R370 VSS.t12 VSS.n215 412.827
R371 VSS.t12 VSS.n219 412.827
R372 VSS.t2 VSS.n5 412.827
R373 VSS.t2 VSS.n265 412.827
R374 VSS.t0 VSS.n227 412.827
R375 VSS.t0 VSS.n238 412.827
R376 VSS.t46 VSS.n231 412.827
R377 VSS.t46 VSS.n225 412.827
R378 VSS.n88 VSS.n87 399.762
R379 VSS.n111 VSS.n110 399.762
R380 VSS.n134 VSS.n133 399.762
R381 VSS.n157 VSS.n156 399.762
R382 VSS.n180 VSS.n179 399.762
R383 VSS.n203 VSS.n202 399.762
R384 VSS.n262 VSS.n215 399.762
R385 VSS.n249 VSS.n227 399.762
R386 VSS.n41 VSS.n37 305.445
R387 VSS.n65 VSS.n32 305.445
R388 VSS.n58 VSS.n27 305.445
R389 VSS.n51 VSS.n22 305.445
R390 VSS.n44 VSS.n17 305.445
R391 VSS.n10 VSS.n6 305.445
R392 VSS.n224 VSS.n223 305.445
R393 VSS.n242 VSS.n228 304.949
R394 VSS.n41 VSS.n38 304.949
R395 VSS.n65 VSS.n33 304.949
R396 VSS.n58 VSS.n28 304.949
R397 VSS.n51 VSS.n23 304.949
R398 VSS.n44 VSS.n18 304.949
R399 VSS.n10 VSS.n7 304.949
R400 VSS.n223 VSS.n216 304.949
R401 VSS.n76 VSS.n75 304.048
R402 VSS.n68 VSS.n36 304.048
R403 VSS.n61 VSS.n31 304.048
R404 VSS.n54 VSS.n26 304.048
R405 VSS.n47 VSS.n21 304.048
R406 VSS.n16 VSS.n15 304.048
R407 VSS.n268 VSS.n267 304.048
R408 VSS.n234 VSS.n233 304.048
R409 VSS.n241 VSS.n240 303.976
R410 VSS.n222 VSS.n221 303.976
R411 VSS.n11 VSS.n9 303.976
R412 VSS.n45 VSS.n20 303.976
R413 VSS.n52 VSS.n25 303.976
R414 VSS.n59 VSS.n30 303.976
R415 VSS.n66 VSS.n35 303.976
R416 VSS.n42 VSS.n40 303.976
R417 VSS.n85 VSS.t8 292.5
R418 VSS.n40 VSS.t8 292.5
R419 VSS.n79 VSS.t24 292.5
R420 VSS.n76 VSS.t24 292.5
R421 VSS.n96 VSS.t31 292.5
R422 VSS.n37 VSS.t31 292.5
R423 VSS.n91 VSS.t30 292.5
R424 VSS.n38 VSS.t30 292.5
R425 VSS.n108 VSS.t22 292.5
R426 VSS.n35 VSS.t22 292.5
R427 VSS.n102 VSS.t28 292.5
R428 VSS.n36 VSS.t28 292.5
R429 VSS.n119 VSS.t33 292.5
R430 VSS.n32 VSS.t33 292.5
R431 VSS.n114 VSS.t32 292.5
R432 VSS.n33 VSS.t32 292.5
R433 VSS.n131 VSS.t18 292.5
R434 VSS.n30 VSS.t18 292.5
R435 VSS.n125 VSS.t20 292.5
R436 VSS.n31 VSS.t20 292.5
R437 VSS.n142 VSS.t35 292.5
R438 VSS.n27 VSS.t35 292.5
R439 VSS.n137 VSS.t34 292.5
R440 VSS.n28 VSS.t34 292.5
R441 VSS.n154 VSS.t14 292.5
R442 VSS.n25 VSS.t14 292.5
R443 VSS.n148 VSS.t16 292.5
R444 VSS.n26 VSS.t16 292.5
R445 VSS.n165 VSS.t37 292.5
R446 VSS.n22 VSS.t37 292.5
R447 VSS.n160 VSS.t36 292.5
R448 VSS.n23 VSS.t36 292.5
R449 VSS.n177 VSS.t26 292.5
R450 VSS.n20 VSS.t26 292.5
R451 VSS.n171 VSS.t6 292.5
R452 VSS.n21 VSS.t6 292.5
R453 VSS.n188 VSS.t39 292.5
R454 VSS.n17 VSS.t39 292.5
R455 VSS.n183 VSS.t38 292.5
R456 VSS.n18 VSS.t38 292.5
R457 VSS.n200 VSS.t10 292.5
R458 VSS.n9 VSS.t10 292.5
R459 VSS.n194 VSS.t4 292.5
R460 VSS.n16 VSS.t4 292.5
R461 VSS.n211 VSS.t41 292.5
R462 VSS.n6 VSS.t41 292.5
R463 VSS.n206 VSS.t40 292.5
R464 VSS.n7 VSS.t40 292.5
R465 VSS.t12 VSS.n220 292.5
R466 VSS.n221 VSS.t12 292.5
R467 VSS.t2 VSS.n266 292.5
R468 VSS.n267 VSS.t2 292.5
R469 VSS.n254 VSS.t43 292.5
R470 VSS.n224 VSS.t43 292.5
R471 VSS.n259 VSS.t42 292.5
R472 VSS.n216 VSS.t42 292.5
R473 VSS.t0 VSS.n239 292.5
R474 VSS.n240 VSS.t0 292.5
R475 VSS.t46 VSS.n232 292.5
R476 VSS.n233 VSS.t46 292.5
R477 VSS.n246 VSS.t44 292.5
R478 VSS.n228 VSS.t44 292.5
R479 VSS.n98 VSS.t31 268.418
R480 VSS.n94 VSS.t31 268.418
R481 VSS.n93 VSS.t30 268.418
R482 VSS.n89 VSS.t30 268.418
R483 VSS.n121 VSS.t33 268.418
R484 VSS.n117 VSS.t33 268.418
R485 VSS.n116 VSS.t32 268.418
R486 VSS.n112 VSS.t32 268.418
R487 VSS.n144 VSS.t35 268.418
R488 VSS.n140 VSS.t35 268.418
R489 VSS.n139 VSS.t34 268.418
R490 VSS.n135 VSS.t34 268.418
R491 VSS.n167 VSS.t37 268.418
R492 VSS.n163 VSS.t37 268.418
R493 VSS.n162 VSS.t36 268.418
R494 VSS.n158 VSS.t36 268.418
R495 VSS.n190 VSS.t39 268.418
R496 VSS.n186 VSS.t39 268.418
R497 VSS.n185 VSS.t38 268.418
R498 VSS.n181 VSS.t38 268.418
R499 VSS.n213 VSS.t41 268.418
R500 VSS.n209 VSS.t41 268.418
R501 VSS.n208 VSS.t40 268.418
R502 VSS.n204 VSS.t40 268.418
R503 VSS.n252 VSS.t43 268.418
R504 VSS.n256 VSS.t43 268.418
R505 VSS.n257 VSS.t42 268.418
R506 VSS.n261 VSS.t42 268.418
R507 VSS.n244 VSS.t44 268.418
R508 VSS.n248 VSS.t44 268.418
R509 VSS.n83 VSS.n82 240.381
R510 VSS.n106 VSS.n105 240.381
R511 VSS.n129 VSS.n128 240.381
R512 VSS.n152 VSS.n151 240.381
R513 VSS.n175 VSS.n174 240.381
R514 VSS.n198 VSS.n197 240.381
R515 VSS.n219 VSS.n214 240.381
R516 VSS.n238 VSS.n226 240.381
R517 VSS.n89 VSS.n88 222.548
R518 VSS.n112 VSS.n111 222.548
R519 VSS.n135 VSS.n134 222.548
R520 VSS.n158 VSS.n157 222.548
R521 VSS.n181 VSS.n180 222.548
R522 VSS.n204 VSS.n203 222.548
R523 VSS.n262 VSS.n261 222.548
R524 VSS.n249 VSS.n248 222.548
R525 VSS.n95 VSS.n94 146.25
R526 VSS.n98 VSS.n97 146.25
R527 VSS.n90 VSS.n89 146.25
R528 VSS.n93 VSS.n92 146.25
R529 VSS.n118 VSS.n117 146.25
R530 VSS.n121 VSS.n120 146.25
R531 VSS.n113 VSS.n112 146.25
R532 VSS.n116 VSS.n115 146.25
R533 VSS.n141 VSS.n140 146.25
R534 VSS.n144 VSS.n143 146.25
R535 VSS.n136 VSS.n135 146.25
R536 VSS.n139 VSS.n138 146.25
R537 VSS.n164 VSS.n163 146.25
R538 VSS.n167 VSS.n166 146.25
R539 VSS.n159 VSS.n158 146.25
R540 VSS.n162 VSS.n161 146.25
R541 VSS.n187 VSS.n186 146.25
R542 VSS.n190 VSS.n189 146.25
R543 VSS.n182 VSS.n181 146.25
R544 VSS.n185 VSS.n184 146.25
R545 VSS.n210 VSS.n209 146.25
R546 VSS.n213 VSS.n212 146.25
R547 VSS.n205 VSS.n204 146.25
R548 VSS.n208 VSS.n207 146.25
R549 VSS.n256 VSS.n255 146.25
R550 VSS.n253 VSS.n252 146.25
R551 VSS.n261 VSS.n260 146.25
R552 VSS.n258 VSS.n257 146.25
R553 VSS.n248 VSS.n247 146.25
R554 VSS.n245 VSS.n244 146.25
R555 VSS.n100 VSS.n99 138.481
R556 VSS.n123 VSS.n122 138.481
R557 VSS.n146 VSS.n145 138.481
R558 VSS.n169 VSS.n168 138.481
R559 VSS.n192 VSS.n191 138.481
R560 VSS.n265 VSS.n264 138.481
R561 VSS.n251 VSS.n225 138.481
R562 VSS.n84 VSS.n83 97.5005
R563 VSS.n87 VSS.n86 97.5005
R564 VSS.n78 VSS.n77 97.5005
R565 VSS.n81 VSS.n80 97.5005
R566 VSS.n107 VSS.n106 97.5005
R567 VSS.n110 VSS.n109 97.5005
R568 VSS.n101 VSS.n100 97.5005
R569 VSS.n104 VSS.n103 97.5005
R570 VSS.n130 VSS.n129 97.5005
R571 VSS.n133 VSS.n132 97.5005
R572 VSS.n124 VSS.n123 97.5005
R573 VSS.n127 VSS.n126 97.5005
R574 VSS.n153 VSS.n152 97.5005
R575 VSS.n156 VSS.n155 97.5005
R576 VSS.n147 VSS.n146 97.5005
R577 VSS.n150 VSS.n149 97.5005
R578 VSS.n176 VSS.n175 97.5005
R579 VSS.n179 VSS.n178 97.5005
R580 VSS.n170 VSS.n169 97.5005
R581 VSS.n173 VSS.n172 97.5005
R582 VSS.n199 VSS.n198 97.5005
R583 VSS.n202 VSS.n201 97.5005
R584 VSS.n193 VSS.n192 97.5005
R585 VSS.n196 VSS.n195 97.5005
R586 VSS.n219 VSS.n218 97.5005
R587 VSS.n217 VSS.n215 97.5005
R588 VSS.n265 VSS.n4 97.5005
R589 VSS.n5 VSS.n3 97.5005
R590 VSS.n238 VSS.n237 97.5005
R591 VSS.n236 VSS.n227 97.5005
R592 VSS.n230 VSS.n225 97.5005
R593 VSS.n231 VSS.n229 97.5005
R594 VSS.n0 VSS.t47 87.7129
R595 VSS.n269 VSS.t3 87.7129
R596 VSS.n14 VSS.t5 87.7129
R597 VSS.n48 VSS.t7 87.7129
R598 VSS.n55 VSS.t17 87.7129
R599 VSS.n62 VSS.t21 87.7129
R600 VSS.n69 VSS.t29 87.7129
R601 VSS.n74 VSS.t25 87.7129
R602 VSS.n235 VSS.t1 87.574
R603 VSS.n2 VSS.t13 87.574
R604 VSS.n12 VSS.t11 87.574
R605 VSS.n46 VSS.t27 87.574
R606 VSS.n53 VSS.t15 87.574
R607 VSS.n60 VSS.t19 87.574
R608 VSS.n67 VSS.t23 87.574
R609 VSS.n43 VSS.t9 87.574
R610 VSS.n243 VSS.t45 22.5063
R611 VSS.n272 VSS.n271 5.46479
R612 VSS.n271 VSS.n270 3.4105
R613 VSS.n13 VSS.n1 3.4105
R614 VSS.n50 VSS.n49 3.4105
R615 VSS.n57 VSS.n56 3.4105
R616 VSS.n64 VSS.n63 3.4105
R617 VSS.n71 VSS.n70 3.4105
R618 VSS.n73 VSS.n72 3.4105
R619 VSS.n271 VSS.n1 2.05479
R620 VSS.n50 VSS.n1 2.05479
R621 VSS.n57 VSS.n50 2.05479
R622 VSS.n64 VSS.n57 2.05479
R623 VSS.n71 VSS.n64 2.05479
R624 VSS.n72 VSS.n71 2.05479
R625 VSS.n223 VSS.n222 0.537643
R626 VSS.n11 VSS.n10 0.537643
R627 VSS.n45 VSS.n44 0.537643
R628 VSS.n52 VSS.n51 0.537643
R629 VSS.n59 VSS.n58 0.537643
R630 VSS.n66 VSS.n65 0.537643
R631 VSS.n42 VSS.n41 0.537643
R632 VSS.n242 VSS.n241 0.537643
R633 VSS.n268 VSS.n2 0.269071
R634 VSS.n15 VSS.n12 0.269071
R635 VSS.n47 VSS.n46 0.269071
R636 VSS.n54 VSS.n53 0.269071
R637 VSS.n61 VSS.n60 0.269071
R638 VSS.n68 VSS.n67 0.269071
R639 VSS.n75 VSS.n43 0.269071
R640 VSS.n235 VSS.n234 0.269071
R641 VSS.n72 VSS 0.166958
R642 VSS.n270 VSS.n269 0.127512
R643 VSS.n14 VSS.n13 0.127512
R644 VSS.n49 VSS.n48 0.127512
R645 VSS.n56 VSS.n55 0.127512
R646 VSS.n63 VSS.n62 0.127512
R647 VSS.n70 VSS.n69 0.127512
R648 VSS.n74 VSS.n73 0.127512
R649 VSS.n272 VSS.n0 0.127512
R650 VSS.n222 VSS.n2 0.0900238
R651 VSS.n269 VSS.n268 0.0900238
R652 VSS.n12 VSS.n11 0.0900238
R653 VSS.n15 VSS.n14 0.0900238
R654 VSS.n46 VSS.n45 0.0900238
R655 VSS.n48 VSS.n47 0.0900238
R656 VSS.n53 VSS.n52 0.0900238
R657 VSS.n55 VSS.n54 0.0900238
R658 VSS.n60 VSS.n59 0.0900238
R659 VSS.n62 VSS.n61 0.0900238
R660 VSS.n67 VSS.n66 0.0900238
R661 VSS.n69 VSS.n68 0.0900238
R662 VSS.n43 VSS.n42 0.0900238
R663 VSS.n75 VSS.n74 0.0900238
R664 VSS.n241 VSS.n235 0.0900238
R665 VSS.n234 VSS.n0 0.0900238
R666 VSS.n270 VSS 0.0135556
R667 VSS.n13 VSS 0.0135556
R668 VSS.n49 VSS 0.0135556
R669 VSS.n56 VSS 0.0135556
R670 VSS.n63 VSS 0.0135556
R671 VSS.n70 VSS 0.0135556
R672 VSS.n73 VSS 0.0135556
R673 VSS VSS.n272 0.0135556
R674 a_25235_916.t0 a_25235_916.n2 667.521
R675 a_25235_916.n2 a_25235_916.n0 4.34871
R676 a_25235_916.n0 a_25235_916.n1 0.179548
R677 a_25235_916.n1 a_25235_916.t1 233.82
R678 a_25235_916.n1 a_25235_916.t4 312.329
R679 a_25235_916.n0 a_25235_916.t3 433.293
R680 a_25235_916.n2 a_25235_916.t2 85.1015
R681 a_25187_828.t1 a_25187_828.n2 667.313
R682 a_25187_828.n2 a_25187_828.n1 3.85693
R683 a_25187_828.n1 a_25187_828.t0 234.183
R684 a_25187_828.n1 a_25187_828.n0 4.41538
R685 a_25187_828.n0 a_25187_828.t3 430.065
R686 a_25187_828.n0 a_25187_828.t4 308.337
R687 a_25187_828.n2 a_25187_828.t2 85.2404
R688 a_21725_916.t1 a_21725_916.n2 667.521
R689 a_21725_916.n2 a_21725_916.n0 4.34871
R690 a_21725_916.n0 a_21725_916.n1 0.179548
R691 a_21725_916.n1 a_21725_916.t2 233.82
R692 a_21725_916.n1 a_21725_916.t4 312.329
R693 a_21725_916.n0 a_21725_916.t3 433.293
R694 a_21725_916.n2 a_21725_916.t0 85.1015
R695 a_21677_828.t1 a_21677_828.n2 667.313
R696 a_21677_828.n2 a_21677_828.n1 3.85693
R697 a_21677_828.n1 a_21677_828.t0 234.183
R698 a_21677_828.n1 a_21677_828.n0 4.41538
R699 a_21677_828.n0 a_21677_828.t3 430.065
R700 a_21677_828.n0 a_21677_828.t4 308.337
R701 a_21677_828.n2 a_21677_828.t2 85.2404
R702 a_18215_916.t0 a_18215_916.n2 667.521
R703 a_18215_916.n2 a_18215_916.n0 4.34871
R704 a_18215_916.n0 a_18215_916.n1 0.179548
R705 a_18215_916.n1 a_18215_916.t2 233.82
R706 a_18215_916.n1 a_18215_916.t4 312.329
R707 a_18215_916.n0 a_18215_916.t3 433.293
R708 a_18215_916.n2 a_18215_916.t1 85.1015
R709 a_18167_828.t0 a_18167_828.n2 667.313
R710 a_18167_828.n2 a_18167_828.n1 3.85693
R711 a_18167_828.n1 a_18167_828.t2 234.183
R712 a_18167_828.n1 a_18167_828.n0 4.41538
R713 a_18167_828.n0 a_18167_828.t3 430.065
R714 a_18167_828.n0 a_18167_828.t4 308.337
R715 a_18167_828.n2 a_18167_828.t1 85.2404
R716 a_14705_916.t1 a_14705_916.n2 667.521
R717 a_14705_916.n2 a_14705_916.n0 4.34871
R718 a_14705_916.n0 a_14705_916.n1 0.179548
R719 a_14705_916.n1 a_14705_916.t2 233.82
R720 a_14705_916.n1 a_14705_916.t4 312.329
R721 a_14705_916.n0 a_14705_916.t3 433.293
R722 a_14705_916.n2 a_14705_916.t0 85.1015
R723 a_14657_828.t0 a_14657_828.n2 667.313
R724 a_14657_828.n2 a_14657_828.n1 3.85693
R725 a_14657_828.n1 a_14657_828.t2 234.183
R726 a_14657_828.n1 a_14657_828.n0 4.41538
R727 a_14657_828.n0 a_14657_828.t3 430.065
R728 a_14657_828.n0 a_14657_828.t4 308.337
R729 a_14657_828.n2 a_14657_828.t1 85.2404
R730 a_11195_916.t0 a_11195_916.n2 667.521
R731 a_11195_916.n2 a_11195_916.n0 4.34871
R732 a_11195_916.n0 a_11195_916.n1 0.179548
R733 a_11195_916.n1 a_11195_916.t2 233.82
R734 a_11195_916.n1 a_11195_916.t4 312.329
R735 a_11195_916.n0 a_11195_916.t3 433.293
R736 a_11195_916.n2 a_11195_916.t1 85.1015
R737 a_11147_828.t0 a_11147_828.n2 667.313
R738 a_11147_828.n2 a_11147_828.n1 3.85693
R739 a_11147_828.n1 a_11147_828.t2 234.183
R740 a_11147_828.n1 a_11147_828.n0 4.41538
R741 a_11147_828.n0 a_11147_828.t3 430.065
R742 a_11147_828.n0 a_11147_828.t4 308.337
R743 a_11147_828.n2 a_11147_828.t1 85.2404
R744 a_7685_916.t0 a_7685_916.n2 667.521
R745 a_7685_916.n2 a_7685_916.n0 4.34871
R746 a_7685_916.n0 a_7685_916.n1 0.179548
R747 a_7685_916.n1 a_7685_916.t2 233.82
R748 a_7685_916.n1 a_7685_916.t4 312.329
R749 a_7685_916.n0 a_7685_916.t3 433.293
R750 a_7685_916.n2 a_7685_916.t1 85.1015
R751 a_7637_828.t0 a_7637_828.n2 667.313
R752 a_7637_828.n2 a_7637_828.n1 3.85693
R753 a_7637_828.n1 a_7637_828.t2 234.183
R754 a_7637_828.n1 a_7637_828.n0 4.41538
R755 a_7637_828.n0 a_7637_828.t3 430.065
R756 a_7637_828.n0 a_7637_828.t4 308.337
R757 a_7637_828.n2 a_7637_828.t1 85.2404
R758 a_4175_916.t0 a_4175_916.n2 667.521
R759 a_4175_916.n2 a_4175_916.n0 4.34871
R760 a_4175_916.n0 a_4175_916.n1 0.179548
R761 a_4175_916.n1 a_4175_916.t2 233.82
R762 a_4175_916.n1 a_4175_916.t4 312.329
R763 a_4175_916.n0 a_4175_916.t3 433.293
R764 a_4175_916.n2 a_4175_916.t1 85.1015
R765 a_4127_828.t1 a_4127_828.n2 667.313
R766 a_4127_828.n2 a_4127_828.n1 3.85693
R767 a_4127_828.n1 a_4127_828.t0 234.183
R768 a_4127_828.n1 a_4127_828.n0 4.41538
R769 a_4127_828.n0 a_4127_828.t3 430.065
R770 a_4127_828.n0 a_4127_828.t4 308.337
R771 a_4127_828.n2 a_4127_828.t2 85.2404
R772 a_665_916.t1 a_665_916.n2 667.521
R773 a_665_916.n2 a_665_916.n0 4.34871
R774 a_665_916.n0 a_665_916.n1 0.179548
R775 a_665_916.n1 a_665_916.t2 233.82
R776 a_665_916.n1 a_665_916.t4 312.329
R777 a_665_916.n0 a_665_916.t3 433.293
R778 a_665_916.n2 a_665_916.t0 85.1015
R779 a_617_828.t0 a_617_828.n2 667.313
R780 a_617_828.n2 a_617_828.n1 3.85693
R781 a_617_828.n1 a_617_828.t2 234.183
R782 a_617_828.n1 a_617_828.n0 4.41538
R783 a_617_828.n0 a_617_828.t3 430.065
R784 a_617_828.n0 a_617_828.t4 308.337
R785 a_617_828.n2 a_617_828.t1 85.2404
C62 BLB7 VSS 1.61006f
C63 BL7 VSS 0.78425f
C64 BLB6 VSS 1.59355f
C65 BL6 VSS 0.7677f
C66 BLB5 VSS 1.59355f
C67 BL5 VSS 0.7677f
C68 BLB4 VSS 1.59355f
C69 BL4 VSS 0.7677f
C70 BLB3 VSS 1.59355f
C71 BL3 VSS 0.7677f
C72 BLB2 VSS 1.59355f
C73 BL2 VSS 0.7677f
C74 BLB1 VSS 1.59355f
C75 BL1 VSS 0.7677f
C76 BLB0 VSS 1.61746f
C77 BL0 VSS 0.79164f
C78 WL VSS 50.44416f
C79 VDD VSS 35.0965f
C80 a_617_828.t0 VSS 0.03088f $ **FLOATING
C81 a_617_828.t1 VSS 0.10846f $ **FLOATING
C82 a_617_828.t4 VSS 0.05853f $ **FLOATING
C83 a_617_828.n0 VSS 1.01725f $ **FLOATING
C84 a_617_828.t3 VSS 0.0788f $ **FLOATING
C85 a_617_828.t2 VSS 0.06606f $ **FLOATING
C86 a_617_828.n1 VSS 2.6811f $ **FLOATING
C87 a_617_828.n2 VSS 1.02567f $ **FLOATING
C88 a_665_916.t1 VSS 0.0401f $ **FLOATING
C89 a_665_916.t0 VSS 0.13908f $ **FLOATING
C90 a_665_916.t3 VSS 0.11025f $ **FLOATING
C91 a_665_916.n0 VSS 2.15543f $ **FLOATING
C92 a_665_916.t4 VSS 0.08209f $ **FLOATING
C93 a_665_916.n1 VSS 3.03317f $ **FLOATING
C94 a_665_916.t2 VSS 0.08383f $ **FLOATING
C95 a_665_916.n2 VSS 1.48036f $ **FLOATING
C96 a_4127_828.t1 VSS 0.03146f $ **FLOATING
C97 a_4127_828.t2 VSS 0.11052f $ **FLOATING
C98 a_4127_828.t4 VSS 0.05964f $ **FLOATING
C99 a_4127_828.n0 VSS 1.03648f $ **FLOATING
C100 a_4127_828.t3 VSS 0.08029f $ **FLOATING
C101 a_4127_828.t0 VSS 0.06731f $ **FLOATING
C102 a_4127_828.n1 VSS 2.7318f $ **FLOATING
C103 a_4127_828.n2 VSS 1.04507f $ **FLOATING
C104 a_4175_916.t0 VSS 0.04035f $ **FLOATING
C105 a_4175_916.t1 VSS 0.13995f $ **FLOATING
C106 a_4175_916.t3 VSS 0.11094f $ **FLOATING
C107 a_4175_916.n0 VSS 2.1689f $ **FLOATING
C108 a_4175_916.t4 VSS 0.0826f $ **FLOATING
C109 a_4175_916.n1 VSS 3.05213f $ **FLOATING
C110 a_4175_916.t2 VSS 0.08435f $ **FLOATING
C111 a_4175_916.n2 VSS 1.48961f $ **FLOATING
C112 a_7637_828.t0 VSS 0.03146f $ **FLOATING
C113 a_7637_828.t1 VSS 0.11052f $ **FLOATING
C114 a_7637_828.t4 VSS 0.05964f $ **FLOATING
C115 a_7637_828.n0 VSS 1.03648f $ **FLOATING
C116 a_7637_828.t3 VSS 0.08029f $ **FLOATING
C117 a_7637_828.t2 VSS 0.06731f $ **FLOATING
C118 a_7637_828.n1 VSS 2.7318f $ **FLOATING
C119 a_7637_828.n2 VSS 1.04507f $ **FLOATING
C120 a_7685_916.t0 VSS 0.04035f $ **FLOATING
C121 a_7685_916.t1 VSS 0.13995f $ **FLOATING
C122 a_7685_916.t3 VSS 0.11094f $ **FLOATING
C123 a_7685_916.n0 VSS 2.1689f $ **FLOATING
C124 a_7685_916.t4 VSS 0.0826f $ **FLOATING
C125 a_7685_916.n1 VSS 3.05213f $ **FLOATING
C126 a_7685_916.t2 VSS 0.08435f $ **FLOATING
C127 a_7685_916.n2 VSS 1.48961f $ **FLOATING
C128 a_11147_828.t0 VSS 0.03146f $ **FLOATING
C129 a_11147_828.t1 VSS 0.11052f $ **FLOATING
C130 a_11147_828.t4 VSS 0.05964f $ **FLOATING
C131 a_11147_828.n0 VSS 1.03648f $ **FLOATING
C132 a_11147_828.t3 VSS 0.08029f $ **FLOATING
C133 a_11147_828.t2 VSS 0.06731f $ **FLOATING
C134 a_11147_828.n1 VSS 2.7318f $ **FLOATING
C135 a_11147_828.n2 VSS 1.04507f $ **FLOATING
C136 a_11195_916.t0 VSS 0.04035f $ **FLOATING
C137 a_11195_916.t1 VSS 0.13995f $ **FLOATING
C138 a_11195_916.t3 VSS 0.11094f $ **FLOATING
C139 a_11195_916.n0 VSS 2.1689f $ **FLOATING
C140 a_11195_916.t4 VSS 0.0826f $ **FLOATING
C141 a_11195_916.n1 VSS 3.05213f $ **FLOATING
C142 a_11195_916.t2 VSS 0.08435f $ **FLOATING
C143 a_11195_916.n2 VSS 1.48961f $ **FLOATING
C144 a_14657_828.t0 VSS 0.03146f $ **FLOATING
C145 a_14657_828.t1 VSS 0.11052f $ **FLOATING
C146 a_14657_828.t4 VSS 0.05964f $ **FLOATING
C147 a_14657_828.n0 VSS 1.03648f $ **FLOATING
C148 a_14657_828.t3 VSS 0.08029f $ **FLOATING
C149 a_14657_828.t2 VSS 0.06731f $ **FLOATING
C150 a_14657_828.n1 VSS 2.7318f $ **FLOATING
C151 a_14657_828.n2 VSS 1.04507f $ **FLOATING
C152 a_14705_916.t1 VSS 0.04035f $ **FLOATING
C153 a_14705_916.t0 VSS 0.13995f $ **FLOATING
C154 a_14705_916.t3 VSS 0.11094f $ **FLOATING
C155 a_14705_916.n0 VSS 2.1689f $ **FLOATING
C156 a_14705_916.t4 VSS 0.0826f $ **FLOATING
C157 a_14705_916.n1 VSS 3.05213f $ **FLOATING
C158 a_14705_916.t2 VSS 0.08435f $ **FLOATING
C159 a_14705_916.n2 VSS 1.48961f $ **FLOATING
C160 a_18167_828.t0 VSS 0.03146f $ **FLOATING
C161 a_18167_828.t1 VSS 0.11052f $ **FLOATING
C162 a_18167_828.t4 VSS 0.05964f $ **FLOATING
C163 a_18167_828.n0 VSS 1.03648f $ **FLOATING
C164 a_18167_828.t3 VSS 0.08029f $ **FLOATING
C165 a_18167_828.t2 VSS 0.06731f $ **FLOATING
C166 a_18167_828.n1 VSS 2.7318f $ **FLOATING
C167 a_18167_828.n2 VSS 1.04507f $ **FLOATING
C168 a_18215_916.t0 VSS 0.04035f $ **FLOATING
C169 a_18215_916.t1 VSS 0.13995f $ **FLOATING
C170 a_18215_916.t3 VSS 0.11094f $ **FLOATING
C171 a_18215_916.n0 VSS 2.1689f $ **FLOATING
C172 a_18215_916.t4 VSS 0.0826f $ **FLOATING
C173 a_18215_916.n1 VSS 3.05213f $ **FLOATING
C174 a_18215_916.t2 VSS 0.08435f $ **FLOATING
C175 a_18215_916.n2 VSS 1.48961f $ **FLOATING
C176 a_21677_828.t1 VSS 0.03146f $ **FLOATING
C177 a_21677_828.t2 VSS 0.11052f $ **FLOATING
C178 a_21677_828.t4 VSS 0.05964f $ **FLOATING
C179 a_21677_828.n0 VSS 1.03648f $ **FLOATING
C180 a_21677_828.t3 VSS 0.08029f $ **FLOATING
C181 a_21677_828.t0 VSS 0.06731f $ **FLOATING
C182 a_21677_828.n1 VSS 2.7318f $ **FLOATING
C183 a_21677_828.n2 VSS 1.04507f $ **FLOATING
C184 a_21725_916.t1 VSS 0.04035f $ **FLOATING
C185 a_21725_916.t0 VSS 0.13995f $ **FLOATING
C186 a_21725_916.t3 VSS 0.11094f $ **FLOATING
C187 a_21725_916.n0 VSS 2.1689f $ **FLOATING
C188 a_21725_916.t4 VSS 0.0826f $ **FLOATING
C189 a_21725_916.n1 VSS 3.05213f $ **FLOATING
C190 a_21725_916.t2 VSS 0.08435f $ **FLOATING
C191 a_21725_916.n2 VSS 1.48961f $ **FLOATING
C192 a_25187_828.t1 VSS 0.03089f $ **FLOATING
C193 a_25187_828.t2 VSS 0.10852f $ **FLOATING
C194 a_25187_828.t4 VSS 0.05856f $ **FLOATING
C195 a_25187_828.n0 VSS 1.01773f $ **FLOATING
C196 a_25187_828.t3 VSS 0.07883f $ **FLOATING
C197 a_25187_828.t0 VSS 0.06609f $ **FLOATING
C198 a_25187_828.n1 VSS 2.68237f $ **FLOATING
C199 a_25187_828.n2 VSS 1.02616f $ **FLOATING
C200 a_25235_916.t0 VSS 0.04009f $ **FLOATING
C201 a_25235_916.t2 VSS 0.13904f $ **FLOATING
C202 a_25235_916.t3 VSS 0.11022f $ **FLOATING
C203 a_25235_916.n0 VSS 2.15482f $ **FLOATING
C204 a_25235_916.t4 VSS 0.08207f $ **FLOATING
C205 a_25235_916.n1 VSS 3.03232f $ **FLOATING
C206 a_25235_916.t1 VSS 0.0838f $ **FLOATING
C207 a_25235_916.n2 VSS 1.47994f $ **FLOATING
C208 VDD.t8 VSS 0.89151f $ **FLOATING
C209 VDD.t9 VSS 0.0198f $ **FLOATING
C210 VDD.n0 VSS 1.43372f $ **FLOATING
C211 VDD.t30 VSS 0.88992f $ **FLOATING
C212 VDD.n1 VSS 0.38286f $ **FLOATING
C213 VDD.t31 VSS 0.01967f $ **FLOATING
C214 VDD.n2 VSS 0.34543f $ **FLOATING
C215 VDD.t28 VSS 0.89151f $ **FLOATING
C216 VDD.t29 VSS 0.0198f $ **FLOATING
C217 VDD.n3 VSS 1.43372f $ **FLOATING
C218 VDD.t24 VSS 0.88992f $ **FLOATING
C219 VDD.n4 VSS 0.38286f $ **FLOATING
C220 VDD.t25 VSS 0.01967f $ **FLOATING
C221 VDD.n5 VSS 0.34543f $ **FLOATING
C222 VDD.n6 VSS 0.04304f $ **FLOATING
C223 VDD.n7 VSS 0.59294f $ **FLOATING
C224 VDD.t20 VSS 0.89151f $ **FLOATING
C225 VDD.t21 VSS 0.0198f $ **FLOATING
C226 VDD.n8 VSS 1.43372f $ **FLOATING
C227 VDD.t22 VSS 0.88992f $ **FLOATING
C228 VDD.n9 VSS 0.38286f $ **FLOATING
C229 VDD.t23 VSS 0.01967f $ **FLOATING
C230 VDD.n10 VSS 0.34543f $ **FLOATING
C231 VDD.n11 VSS 0.04304f $ **FLOATING
C232 VDD.n12 VSS 1.0903f $ **FLOATING
C233 VDD.t6 VSS 0.89151f $ **FLOATING
C234 VDD.t7 VSS 0.0198f $ **FLOATING
C235 VDD.n13 VSS 1.43372f $ **FLOATING
C236 VDD.t18 VSS 0.88992f $ **FLOATING
C237 VDD.n14 VSS 0.38286f $ **FLOATING
C238 VDD.t19 VSS 0.01967f $ **FLOATING
C239 VDD.n15 VSS 0.34543f $ **FLOATING
C240 VDD.n16 VSS 0.04304f $ **FLOATING
C241 VDD.n17 VSS 1.0903f $ **FLOATING
C242 VDD.t14 VSS 0.89151f $ **FLOATING
C243 VDD.t15 VSS 0.0198f $ **FLOATING
C244 VDD.n18 VSS 1.43372f $ **FLOATING
C245 VDD.t16 VSS 0.88992f $ **FLOATING
C246 VDD.n19 VSS 0.38286f $ **FLOATING
C247 VDD.t17 VSS 0.01967f $ **FLOATING
C248 VDD.n20 VSS 0.34543f $ **FLOATING
C249 VDD.n21 VSS 0.04304f $ **FLOATING
C250 VDD.n22 VSS 1.0903f $ **FLOATING
C251 VDD.t10 VSS 0.89151f $ **FLOATING
C252 VDD.t11 VSS 0.0198f $ **FLOATING
C253 VDD.n23 VSS 1.43372f $ **FLOATING
C254 VDD.t26 VSS 0.88992f $ **FLOATING
C255 VDD.n24 VSS 0.38286f $ **FLOATING
C256 VDD.t27 VSS 0.01967f $ **FLOATING
C257 VDD.n25 VSS 0.34543f $ **FLOATING
C258 VDD.n26 VSS 0.04304f $ **FLOATING
C259 VDD.n27 VSS 1.0903f $ **FLOATING
C260 VDD.t2 VSS 0.89151f $ **FLOATING
C261 VDD.t3 VSS 0.0198f $ **FLOATING
C262 VDD.n28 VSS 1.43372f $ **FLOATING
C263 VDD.t4 VSS 0.88992f $ **FLOATING
C264 VDD.n29 VSS 0.38286f $ **FLOATING
C265 VDD.t5 VSS 0.01967f $ **FLOATING
C266 VDD.n30 VSS 0.34543f $ **FLOATING
C267 VDD.n31 VSS 0.04304f $ **FLOATING
C268 VDD.n32 VSS 1.0903f $ **FLOATING
C269 VDD.t0 VSS 0.89151f $ **FLOATING
C270 VDD.t1 VSS 0.0198f $ **FLOATING
C271 VDD.n33 VSS 1.43372f $ **FLOATING
C272 VDD.t12 VSS 0.88992f $ **FLOATING
C273 VDD.n34 VSS 0.38286f $ **FLOATING
C274 VDD.t13 VSS 0.01967f $ **FLOATING
C275 VDD.n35 VSS 0.34543f $ **FLOATING
C276 VDD.n36 VSS 0.04304f $ **FLOATING
C277 VDD.n37 VSS 0.80463f $ **FLOATING
C278 WL.t1 VSS 0.04032f $ **FLOATING
C279 WL.t0 VSS 0.03979f $ **FLOATING
C280 WL.n0 VSS 0.51631f $ **FLOATING
C281 WL.t15 VSS 0.04032f $ **FLOATING
C282 WL.t14 VSS 0.03979f $ **FLOATING
C283 WL.n1 VSS 0.51631f $ **FLOATING
C284 WL.n2 VSS 1.36916f $ **FLOATING
C285 WL.n3 VSS 0.69559f $ **FLOATING
C286 WL.t13 VSS 0.04032f $ **FLOATING
C287 WL.t12 VSS 0.03979f $ **FLOATING
C288 WL.n4 VSS 0.51631f $ **FLOATING
C289 WL.n5 VSS 1.36916f $ **FLOATING
C290 WL.n6 VSS 1.27906f $ **FLOATING
C291 WL.t11 VSS 0.04032f $ **FLOATING
C292 WL.t10 VSS 0.03979f $ **FLOATING
C293 WL.n7 VSS 0.51631f $ **FLOATING
C294 WL.n8 VSS 1.36916f $ **FLOATING
C295 WL.n9 VSS 1.27906f $ **FLOATING
C296 WL.t9 VSS 0.04032f $ **FLOATING
C297 WL.t8 VSS 0.03979f $ **FLOATING
C298 WL.n10 VSS 0.51631f $ **FLOATING
C299 WL.n11 VSS 1.36916f $ **FLOATING
C300 WL.n12 VSS 1.27906f $ **FLOATING
C301 WL.t7 VSS 0.04032f $ **FLOATING
C302 WL.t6 VSS 0.03979f $ **FLOATING
C303 WL.n13 VSS 0.51631f $ **FLOATING
C304 WL.n14 VSS 1.36916f $ **FLOATING
C305 WL.n15 VSS 1.27906f $ **FLOATING
C306 WL.t5 VSS 0.04032f $ **FLOATING
C307 WL.t4 VSS 0.03979f $ **FLOATING
C308 WL.n16 VSS 0.51631f $ **FLOATING
C309 WL.n17 VSS 1.36916f $ **FLOATING
C310 WL.n18 VSS 1.27906f $ **FLOATING
C311 WL.t3 VSS 0.04032f $ **FLOATING
C312 WL.t2 VSS 0.03979f $ **FLOATING
C313 WL.n19 VSS 0.51631f $ **FLOATING
C314 WL.n20 VSS 1.36916f $ **FLOATING
C315 WL.n21 VSS 0.94393f $ **FLOATING
C316 WL.n22 VSS 1.16727f $ **FLOATING
C317 BL0.t0 VSS 0.11329f $ **FLOATING
C318 BL0.n0 VSS 4.31522f $ **FLOATING
C319 BLB0.t0 VSS 0.06255f $ **FLOATING
C320 BLB0.n0 VSS 2.33525f $ **FLOATING
C321 BL1.t0 VSS 0.11465f $ **FLOATING
C322 BL1.n0 VSS 4.36679f $ **FLOATING
C323 BLB1.t0 VSS 0.06393f $ **FLOATING
C324 BLB1.n0 VSS 2.38677f $ **FLOATING
C325 BL2.t0 VSS 0.11465f $ **FLOATING
C326 BL2.n0 VSS 4.36679f $ **FLOATING
C327 BLB2.t0 VSS 0.06393f $ **FLOATING
C328 BLB2.n0 VSS 2.38677f $ **FLOATING
C329 BL3.t0 VSS 0.11465f $ **FLOATING
C330 BL3.n0 VSS 4.36679f $ **FLOATING
C331 BLB3.t0 VSS 0.06393f $ **FLOATING
C332 BLB3.n0 VSS 2.38677f $ **FLOATING
C333 BL4.t0 VSS 0.11465f $ **FLOATING
C334 BL4.n0 VSS 4.36679f $ **FLOATING
C335 BLB4.t0 VSS 0.06393f $ **FLOATING
C336 BLB4.n0 VSS 2.38677f $ **FLOATING
C337 BL5.t0 VSS 0.11465f $ **FLOATING
C338 BL5.n0 VSS 4.36679f $ **FLOATING
C339 BLB5.t0 VSS 0.06393f $ **FLOATING
C340 BLB5.n0 VSS 2.38677f $ **FLOATING
C341 BL6.t0 VSS 0.11465f $ **FLOATING
C342 BL6.n0 VSS 4.36679f $ **FLOATING
C343 BLB6.t0 VSS 0.06393f $ **FLOATING
C344 BLB6.n0 VSS 2.38677f $ **FLOATING
C345 BL7.t0 VSS 0.11331f $ **FLOATING
C346 BL7.n0 VSS 4.31564f $ **FLOATING
C347 BLB7.t0 VSS 0.06254f $ **FLOATING
C348 BLB7.n0 VSS 2.3348f $ **FLOATING
.ends
