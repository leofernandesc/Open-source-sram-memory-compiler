* NGSPICE file created from precharge_w2p52_flat.ext - technology: sky130A

.subckt precharge_w2p52_flat VDD BL BLB PRECH VSS
X0 BLB.t0 PRECH.t0 BL.t0 VDD.t4 sky130_fd_pr__pfet_01v8 ad=0.7308 pd=5.62 as=0.7308 ps=5.62 w=2.52 l=0.15
X1 VDD.t1 PRECH.t2 BL.t1 VDD.t0 sky130_fd_pr__pfet_01v8 ad=0.7308 pd=5.62 as=0.7308 ps=5.62 w=2.52 l=0.15
X2 VDD.t3 PRECH.t1 BLB.t1 VDD.t2 sky130_fd_pr__pfet_01v8 ad=0.7308 pd=5.62 as=0.7308 ps=5.62 w=2.52 l=0.15
C0 VDD PRECH 2.53539f
C1 VDD BLB 0.95217f
C2 BL VDD 1.05273f
C3 PRECH BLB 0.09739f
C4 BL PRECH 0.33891f
C5 BL BLB 2.04826f
R0 BLB.n0 BLB.t0 106.474
R1 BLB.n0 BLB.t1 105.653
R2 BLB BLB.n0 0.964783
R3 BL.n0 BL.t0 106.594
R4 BL.n0 BL.t1 105.341
R5 BL BL.n0 0.338117
R6 PRECH.n0 PRECH.t0 649.008
R7 PRECH.n1 PRECH.t2 648.38
R8 PRECH.n0 PRECH.t1 648.38
R9 PRECH.n1 PRECH.n0 0.627167
R10 PRECH PRECH.n1 0.43525
R11 VDD.n32 VDD.n26 1972.94
R12 VDD.n29 VDD.n27 1972.94
R13 VDD.n19 VDD.n13 1972.94
R14 VDD.n16 VDD.n14 1972.94
R15 VDD.n8 VDD.n2 1972.94
R16 VDD.n5 VDD.n3 1972.94
R17 VDD.n33 VDD.n25 210.447
R18 VDD.n28 VDD.n25 210.447
R19 VDD.n28 VDD.n24 210.447
R20 VDD.n20 VDD.n12 210.447
R21 VDD.n15 VDD.n12 210.447
R22 VDD.n15 VDD.n11 210.447
R23 VDD.n9 VDD.n1 210.447
R24 VDD.n4 VDD.n1 210.447
R25 VDD.n4 VDD.n0 210.447
R26 VDD.n30 VDD.n29 156.411
R27 VDD.n32 VDD.n31 156.411
R28 VDD.n17 VDD.n16 156.411
R29 VDD.n19 VDD.n18 156.411
R30 VDD.n6 VDD.n5 156.411
R31 VDD.n8 VDD.n7 156.411
R32 VDD.n34 VDD.n33 134.024
R33 VDD.n21 VDD.n20 134.024
R34 VDD.n10 VDD.n9 134.024
R35 VDD.n36 VDD.t1 105.757
R36 VDD.n23 VDD.t3 105.757
R37 VDD.n27 VDD.n25 92.5005
R38 VDD.n26 VDD.n24 92.5005
R39 VDD.n14 VDD.n12 92.5005
R40 VDD.n13 VDD.n11 92.5005
R41 VDD.n3 VDD.n1 92.5005
R42 VDD.n2 VDD.n0 92.5005
R43 VDD.n30 VDD.n26 81.3537
R44 VDD.n31 VDD.n27 81.3537
R45 VDD.n17 VDD.n13 81.3537
R46 VDD.n18 VDD.n14 81.3537
R47 VDD.n6 VDD.n2 81.3537
R48 VDD.n7 VDD.n3 81.3537
R49 VDD.n34 VDD.n24 61.3652
R50 VDD.n21 VDD.n11 61.3652
R51 VDD.n10 VDD.n0 61.3652
R52 VDD.n22 VDD.n10 48.0772
R53 VDD.n35 VDD.n34 47.4505
R54 VDD.n22 VDD.n21 47.4505
R55 VDD.n29 VDD.n28 18.5005
R56 VDD.n33 VDD.n32 18.5005
R57 VDD.n16 VDD.n15 18.5005
R58 VDD.n20 VDD.n19 18.5005
R59 VDD.n5 VDD.n4 18.5005
R60 VDD.n9 VDD.n8 18.5005
R61 VDD.n31 VDD.t0 7.33417
R62 VDD.t0 VDD.n30 7.33417
R63 VDD.n18 VDD.t2 7.33417
R64 VDD.t2 VDD.n17 7.33417
R65 VDD.n7 VDD.t4 7.33417
R66 VDD.t4 VDD.n6 7.33417
R67 VDD VDD.n36 0.532383
R68 VDD.n35 VDD.n23 0.473633
R69 VDD.n23 VDD.n22 0.154033
R70 VDD.n36 VDD.n35 0.154033
C6 BLB VSS 2.13826f
C7 BL VSS 0.98835f
C8 PRECH VSS 1.07728f
C9 VDD VSS 6.80348f
C10 VDD.n0 VSS 0.02607f $ **FLOATING
C11 VDD.n1 VSS 0.04069f $ **FLOATING
C12 VDD.n2 VSS 0.04069f $ **FLOATING
C13 VDD.n3 VSS 0.04069f $ **FLOATING
C14 VDD.n4 VSS 0.03966f $ **FLOATING
C15 VDD.n5 VSS 0.26821f $ **FLOATING
C16 VDD.t4 VSS 0.3584f $ **FLOATING
C17 VDD.n8 VSS 0.26821f $ **FLOATING
C18 VDD.n9 VSS 0.03225f $ **FLOATING
C19 VDD.n10 VSS 0.04986f $ **FLOATING
C20 VDD.n11 VSS 0.02607f $ **FLOATING
C21 VDD.n12 VSS 0.04069f $ **FLOATING
C22 VDD.n13 VSS 0.04069f $ **FLOATING
C23 VDD.n14 VSS 0.04069f $ **FLOATING
C24 VDD.n15 VSS 0.03966f $ **FLOATING
C25 VDD.n16 VSS 0.26821f $ **FLOATING
C26 VDD.t2 VSS 0.3584f $ **FLOATING
C27 VDD.n19 VSS 0.26821f $ **FLOATING
C28 VDD.n20 VSS 0.03225f $ **FLOATING
C29 VDD.n21 VSS 0.04781f $ **FLOATING
C30 VDD.n22 VSS 0.27801f $ **FLOATING
C31 VDD.t3 VSS 0.06761f $ **FLOATING
C32 VDD.n23 VSS 0.22801f $ **FLOATING
C33 VDD.n24 VSS 0.02607f $ **FLOATING
C34 VDD.n25 VSS 0.04069f $ **FLOATING
C35 VDD.n26 VSS 0.04069f $ **FLOATING
C36 VDD.n27 VSS 0.04069f $ **FLOATING
C37 VDD.n28 VSS 0.03966f $ **FLOATING
C38 VDD.n29 VSS 0.26821f $ **FLOATING
C39 VDD.t0 VSS 0.3584f $ **FLOATING
C40 VDD.n32 VSS 0.26821f $ **FLOATING
C41 VDD.n33 VSS 0.03225f $ **FLOATING
C42 VDD.n34 VSS 0.04781f $ **FLOATING
C43 VDD.n35 VSS 0.11061f $ **FLOATING
C44 VDD.t1 VSS 0.06761f $ **FLOATING
C45 VDD.n36 VSS 0.23263f $ **FLOATING
C46 PRECH.t0 VSS 0.17995f $ **FLOATING
C47 PRECH.t1 VSS 0.17912f $ **FLOATING
C48 PRECH.n0 VSS 1.54783f $ **FLOATING
C49 PRECH.t2 VSS 0.17912f $ **FLOATING
C50 PRECH.n1 VSS 0.62261f $ **FLOATING
C51 BL.t0 VSS 0.29548f $ **FLOATING
C52 BL.t1 VSS 0.27792f $ **FLOATING
C53 BL.n0 VSS 2.65426f $ **FLOATING
C54 BLB.t0 VSS 0.25197f $ **FLOATING
C55 BLB.t1 VSS 0.24337f $ **FLOATING
C56 BLB.n0 VSS 2.24139f $ **FLOATING
.ends
