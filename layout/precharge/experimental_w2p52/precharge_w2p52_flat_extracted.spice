* NGSPICE file created from precharge_w2p52_flat.ext - technology: sky130A

.subckt precharge_w2p52_flat VDD BL BLB PRECH VSS
X0 BLB PRECH BL VDD sky130_fd_pr__pfet_01v8 ad=0.7308 pd=5.62 as=0.7308 ps=5.62 w=2.52 l=0.15
X1 VDD PRECH BL VDD sky130_fd_pr__pfet_01v8 ad=0.7308 pd=5.62 as=0.7308 ps=5.62 w=2.52 l=0.15
X2 VDD PRECH BLB VDD sky130_fd_pr__pfet_01v8 ad=0.7308 pd=5.62 as=0.7308 ps=5.62 w=2.52 l=0.15
.ends
