* NGSPICE file created from row_decoder_flat.ext - technology: sky130A

.subckt row_decoder_flat VDD PCLK A0 A1 DEC0 DEC1 DEC3 DEC2 VSS
X0 VSS N2 DEC2 VSS sky130_fd_pr__nfet_01v8 ad=145G pd=2290k as=145G ps=2290k w=1000k l=75k
X1 VSS A1B A1T VSS sky130_fd_pr__nfet_01v8 ad=145G pd=2290k as=145G ps=2290k w=1000k l=75k
X2 VDD N2 DEC2 VDD sky130_fd_pr__pfet_01v8 ad=145G pd=2290k as=145G ps=2290k w=1000k l=75k
X3 VSS A1 A1B VSS sky130_fd_pr__nfet_01v8 ad=30.45G pd=710k as=30.45G ps=710k w=210k l=75k
X4 EVAL_GND A0T net4 VSS sky130_fd_pr__nfet_01v8 ad=72.5G pd=1290k as=72.5G ps=1290k w=500k l=75k
X5 VSS A0B A0T VSS sky130_fd_pr__nfet_01v8 ad=145G pd=2290k as=145G ps=2290k w=1000k l=75k
X6 VDD N3 DEC3 VDD sky130_fd_pr__pfet_01v8 ad=145G pd=2290k as=145G ps=2290k w=1000k l=75k
X7 VSS A0 A0B VSS sky130_fd_pr__nfet_01v8 ad=30.45G pd=710k as=30.45G ps=710k w=210k l=75k
X8 net2 A1B N1 VSS sky130_fd_pr__nfet_01v8 ad=72.5G pd=1290k as=72.5G ps=1290k w=500k l=75k
X9 net1 A1B N0 VSS sky130_fd_pr__nfet_01v8 ad=72.5G pd=1290k as=72.5G ps=1290k w=500k l=75k
X10 EVAL_GND A0B net3 VSS sky130_fd_pr__nfet_01v8 ad=72.5G pd=1290k as=72.5G ps=1290k w=500k l=75k
X11 VDD A1 A1B VDD sky130_fd_pr__pfet_01v8 ad=30.45G pd=710k as=30.45G ps=710k w=210k l=75k
X12 VDD PCLK N0 VDD sky130_fd_pr__pfet_01v8 ad=36.25G pd=790k as=36.25G ps=790k w=250k l=75k
X13 VDD PCLK N1 VDD sky130_fd_pr__pfet_01v8 ad=36.25G pd=790k as=36.25G ps=790k w=250k l=75k
X14 VDD PCLK N2 VDD sky130_fd_pr__pfet_01v8 ad=36.25G pd=790k as=36.25G ps=790k w=250k l=75k
X15 VDD A1B A1T VDD sky130_fd_pr__pfet_01v8 ad=145G pd=2290k as=145G ps=2290k w=1000k l=75k
X16 VSS PCLK EVAL_GND VSS sky130_fd_pr__nfet_01v8 ad=108.75001G pd=1790k as=108.75001G ps=1790k w=750k l=75k
X17 VDD N0 DEC0 VDD sky130_fd_pr__pfet_01v8 ad=145G pd=2290k as=145G ps=2290k w=1000k l=75k
X18 VDD N1 DEC1 VDD sky130_fd_pr__pfet_01v8 ad=145G pd=2290k as=145G ps=2290k w=1000k l=75k
X19 EVAL_GND A0T net2 VSS sky130_fd_pr__nfet_01v8 ad=72.5G pd=1290k as=72.5G ps=1290k w=500k l=75k
X20 VSS N1 DEC1 VSS sky130_fd_pr__nfet_01v8 ad=145G pd=2290k as=145G ps=2290k w=1000k l=75k
X21 net4 A1T N3 VSS sky130_fd_pr__nfet_01v8 ad=72.5G pd=1290k as=72.5G ps=1290k w=500k l=75k
X22 VDD A0 A0B VDD sky130_fd_pr__pfet_01v8 ad=30.45G pd=710k as=30.45G ps=710k w=210k l=75k
X23 VSS N3 DEC3 VSS sky130_fd_pr__nfet_01v8 ad=145G pd=2290k as=145G ps=2290k w=1000k l=75k
X24 EVAL_GND A0B net1 VSS sky130_fd_pr__nfet_01v8 ad=72.5G pd=1290k as=72.5G ps=1290k w=500k l=75k
X25 VDD PCLK N3 VDD sky130_fd_pr__pfet_01v8 ad=36.25G pd=790k as=36.25G ps=790k w=250k l=75k
X26 VDD A0B A0T VDD sky130_fd_pr__pfet_01v8 ad=145G pd=2290k as=145G ps=2290k w=1000k l=75k
X27 net3 A1T N2 VSS sky130_fd_pr__nfet_01v8 ad=72.5G pd=1290k as=72.5G ps=1290k w=500k l=75k
X28 VSS N0 DEC0 VSS sky130_fd_pr__nfet_01v8 ad=145G pd=2290k as=145G ps=2290k w=1000k l=75k
C0 net1 A1 0.11763f
C1 N2 net2 0.12388f
C2 N2 A0T 0.24467f
C3 A0 A1B 0.3807f
C4 N2 DEC3 0.12093f
C5 A0B net3 1.32126f
C6 A1T net3 2.76001f
C7 N1 net3 0.1227f
C8 A0 net1 0.11763f
C9 net1 A1B 2.61001f
C10 EVAL_GND A0B 5.1257f
C11 EVAL_GND A1T 0.30786f
C12 N1 EVAL_GND 0.30801f
C13 DEC2 VDD 1.00124f
C14 DEC2 PCLK 0.12093f
C15 A0B net4 0.11763f
C16 net4 A1T 2.76001f
C17 N1 net4 0.1227f
C18 A0B A1 10.5559f
C19 A1T A1 0.23245f
C20 N1 A1 0.24467f
C21 VDD N3 2.05114f
C22 N2 net3 0.37409f
C23 PCLK N3 0.86022f
C24 N2 EVAL_GND 0.30801f
C25 DEC2 DEC1 10.3242f
C26 A0B A0 2.15339f
C27 A1T A0 0.23245f
C28 A0B A1B 10.5816f
C29 A1T A1B 2.28205f
C30 N1 A0 0.24467f
C31 N1 A1B 1.48573f
C32 net2 VDD 0.12391f
C33 N2 net4 0.1227f
C34 VDD A0T 1.12289f
C35 DEC2 N0 0.12093f
C36 DEC2 DEC0 0.12603f
C37 N2 A1 0.24467f
C38 N3 DEC1 0.12548f
C39 VDD DEC3 1.00124f
C40 A0B net1 1.32126f
C41 net2 PCLK 0.11763f
C42 A1T net1 0.1227f
C43 PCLK A0T 0.23245f
C44 N1 net1 0.12388f
C45 PCLK DEC3 0.12093f
C46 N3 N0 0.24599f
C47 DEC0 N3 0.12596f
C48 N2 A0 0.24467f
C49 N2 A1B 0.24467f
C50 net2 DEC1 0.12548f
C51 A0T DEC1 0.12106f
C52 DEC3 DEC1 0.12603f
C53 N2 net1 0.12388f
C54 net2 N0 0.1227f
C55 net2 DEC0 0.12596f
C56 A0T N0 0.24599f
C57 DEC0 A0T 0.12141f
C58 VDD net3 0.12391f
C59 A0B A1T 0.29233f
C60 N1 A0B 0.24467f
C61 N1 A1T 0.24567f
C62 DEC3 N0 0.12093f
C63 DEC3 DEC0 0.12603f
C64 PCLK net3 0.11763f
C65 EVAL_GND VDD 0.30154f
C66 EVAL_GND PCLK 1.37774f
C67 net4 VDD 0.12391f
C68 VDD A1 1.44803f
C69 PCLK net4 0.11763f
C70 DEC1 net3 0.12548f
C71 PCLK A1 0.12127f
C72 N2 A0B 0.24479f
C73 N2 A1T 1.56073f
C74 N2 N1 10.5665f
C75 EVAL_GND DEC1 0.39232f
C76 N0 net3 0.1227f
C77 DEC0 net3 0.12596f
C78 VDD A0 1.44803f
C79 VDD A1B 2.15341f
C80 EVAL_GND N0 0.30786f
C81 PCLK A0 10.3193f
C82 PCLK A1B 0.35356f
C83 EVAL_GND DEC0 10.4741f
C84 net4 DEC1 0.12548f
C85 A1 DEC1 0.12093f
C86 DEC2 N3 0.13541f
C87 VDD net1 0.12391f
C88 net4 N0 0.1227f
C89 net4 DEC0 0.12596f
C90 N0 A1 0.2856f
C91 PCLK net1 0.11763f
C92 DEC0 A1 0.12141f
C93 A0 DEC1 0.12093f
C94 A1B DEC1 0.12093f
C95 DEC2 net2 0.12548f
C96 DEC2 A0T 0.12093f
C97 A0 N0 0.24467f
C98 A0 DEC0 0.12141f
C99 A1B N0 1.50599f
C100 DEC2 DEC3 10.3242f
C101 DEC0 A1B 0.12141f
C102 net1 DEC1 0.12548f
C103 net2 N3 0.12388f
C104 A0T N3 0.32674f
C105 A0B VDD 2.15392f
C106 A1T VDD 1.12279f
C107 N1 VDD 2.05114f
C108 DEC3 N3 2.70209f
C109 net1 N0 0.37409f
C110 DEC0 net1 0.12596f
C111 A0B PCLK 0.35449f
C112 PCLK A1T 0.23259f
C113 N1 PCLK 0.86034f
C114 net2 A0T 1.40033f
C115 DEC2 net3 0.12548f
C116 net2 DEC3 0.12548f
C117 A0B DEC1 0.12093f
C118 A1T DEC1 0.12093f
C119 DEC3 A0T 0.12106f
C120 N1 DEC1 2.52482f
C121 N2 VDD 2.05114f
C122 DEC2 EVAL_GND 0.39232f
C123 N2 PCLK 0.86034f
C124 A0B N0 0.24493f
C125 A1T N0 10.4441f
C126 N3 net3 0.12388f
C127 A0B DEC0 0.12141f
C128 A1T DEC0 0.12141f
C129 N1 N0 10.5529f
C130 N1 DEC0 0.13589f
C131 DEC2 net4 0.12548f
C132 EVAL_GND N3 0.30801f
C133 DEC2 A1 0.12093f
C134 N2 DEC1 0.13541f
C135 net4 N3 0.39909f
C136 N3 A1 0.24467f
C137 net2 net3 10.322f
C138 A0T net3 0.11862f
C139 DEC2 A0 0.12093f
C140 DEC2 A1B 0.12093f
C141 DEC3 net3 0.12548f
C142 N2 N0 0.24567f
C143 N2 DEC0 0.12596f
C144 EVAL_GND net2 0.66043f
C145 EVAL_GND A0T 5.43238f
C146 EVAL_GND DEC3 0.39232f
C147 A0 N3 0.24467f
C148 A1B N3 0.24467f
C149 DEC2 net1 0.12548f
C150 net2 net4 0.12388f
C151 net4 A0T 1.39626f
C152 net2 A1 0.11763f
C153 A0T A1 0.23245f
C154 net4 DEC3 0.12548f
C155 DEC3 A1 0.12093f
C156 net1 N3 10.322f
C157 PCLK VDD 5.59919f
C158 net2 A0 0.11763f
C159 net2 A1B 2.60902f
C160 A0 A0T 0.23245f
C161 A0T A1B 10.4403f
C162 A0 DEC3 0.12093f
C163 DEC3 A1B 0.12093f
C164 EVAL_GND net3 0.73661f
C165 DEC2 A0B 0.12106f
C166 DEC2 A1T 0.12093f
C167 VDD DEC1 1.00124f
C168 DEC2 N1 0.12093f
C169 net2 net1 10.322f
C170 net1 A0T 0.1227f
C171 DEC3 net1 0.12548f
C172 net4 net3 10.322f
C173 PCLK DEC1 0.12093f
C174 A1 net3 0.11763f
C175 A0B N3 0.24479f
C176 VDD N0 2.05114f
C177 A1T N3 1.56106f
C178 VDD DEC0 1.00124f
C179 N1 N3 0.24599f
C180 EVAL_GND net4 10.9109f
C181 EVAL_GND A1 0.29155f
C182 PCLK N0 0.86046f
C183 PCLK DEC0 0.13492f
C184 A0 net3 0.11763f
C185 A1B net3 0.11862f
C186 DEC2 N2 2.61345f
C187 net4 A1 0.11763f
C188 net2 A0B 0.11763f
C189 EVAL_GND A0 0.29155f
C190 net2 A1T 0.1227f
C191 A0B A0T 2.19315f
C192 EVAL_GND A1B 0.2997f
C193 N1 net2 0.39909f
C194 A1T A0T 10.4604f
C195 N1 A0T 0.24578f
C196 N0 DEC1 0.12093f
C197 DEC0 DEC1 10.3242f
C198 A0B DEC3 0.12093f
C199 A1T DEC3 0.12093f
C200 N2 N3 10.5805f
C201 net1 net3 0.12388f
C202 N1 DEC3 0.12093f
C203 net4 A0 0.11763f
C204 net4 A1B 0.11763f
C205 A0 A1 10.3194f
C206 EVAL_GND net1 0.68425f
C207 DEC0 N0 2.43666f
C208 A1B A1 2.24243f
C209 net4 net1 0.12388f
C210 DEC3 VSS 18.8957f
C211 DEC2 VSS 11.3434f
C212 DEC1 VSS 11.1826f
C213 DEC0 VSS 11.1441f
C214 PCLK VSS 20.8842f
C215 A1 VSS 8.57283f
C216 A0 VSS 8.42946f
C217 VDD VSS 54.6295f
C218 net4 VSS 11.3747f
C219 net3 VSS 11.2388f
C220 net2 VSS 11.1083f
C221 EVAL_GND VSS 23.6466f
C222 net1 VSS 10.9724f
C223 A1T VSS 12.5419f
C224 A0T VSS 12.26f
C225 N3 VSS 15.2429f
C226 N2 VSS 14.8291f
C227 N1 VSS 14.5233f
C228 N0 VSS 14.262f
C229 A1B VSS 16.6099f
C230 A0B VSS 16.2598f
.ends
