* NGSPICE file created from write_driver_flat.ext - technology: sky130A

.subckt write_driver_flat DATA DATA_B WE BL BLB VDD VSS
X0 a_1415_n5084.t0 DATA_B.t0 BL.t0 VSS.t1 sky130_fd_pr__nfet_01v8 ad=0.2436 pd=2.26 as=0.2436 ps=2.26 w=0.84 l=0.15
X1 VDD.t7 WE.t3 a_227_n1084.t0 VDD.t6 sky130_fd_pr__pfet_01v8 ad=0.2436 pd=2.26 as=0.2436 ps=2.26 w=0.84 l=0.15
X2 VSS.t3 WE.t1 a_1415_n5084.t1 VSS.t2 sky130_fd_pr__nfet_01v8 ad=0.2436 pd=2.26 as=0.2436 ps=2.26 w=0.84 l=0.15
X3 VDD.t3 a_227_n1084.t3 a_1027_n1084.t0 VDD.t2 sky130_fd_pr__pfet_01v8 ad=0.2436 pd=2.26 as=0.2436 ps=2.26 w=0.84 l=0.15
X4 a_3015_n5084.t0 DATA.t0 BLB.t0 VSS.t0 sky130_fd_pr__nfet_01v8 ad=0.2436 pd=2.26 as=0.2436 ps=2.26 w=0.84 l=0.15
X5 a_1027_n1084.t1 DATA_B.t1 BL.t1 VDD.t5 sky130_fd_pr__pfet_01v8 ad=0.2436 pd=2.26 as=0.2436 ps=2.26 w=0.84 l=0.15
X6 VSS.t7 WE.t0 a_3015_n5084.t1 VSS.t6 sky130_fd_pr__nfet_01v8 ad=0.2436 pd=2.26 as=0.2436 ps=2.26 w=0.84 l=0.15
X7 VDD.t1 a_227_n1084.t2 a_2627_n1084.t0 VDD.t0 sky130_fd_pr__pfet_01v8 ad=0.2436 pd=2.26 as=0.2436 ps=2.26 w=0.84 l=0.15
X8 a_2627_n1084.t1 DATA.t1 BLB.t1 VDD.t4 sky130_fd_pr__pfet_01v8 ad=0.2436 pd=2.26 as=0.2436 ps=2.26 w=0.84 l=0.15
X9 VSS.t5 WE.t2 a_227_n1084.t1 VSS.t4 sky130_fd_pr__nfet_01v8 ad=0.2436 pd=2.26 as=0.2436 ps=2.26 w=0.84 l=0.15
C0 BL BLB 2.2383f
C1 BLB WE 0.31183f
C2 BL DATA 2.24564f
C3 VDD BLB 0.13332f
C4 DATA WE 0.19577f
C5 DATA VDD 0.26919f
C6 DATA_B BL 1.70428f
C7 DATA_B WE 0.19581f
C8 DATA_B VDD 0.27303f
C9 BL WE 0.33405f
C10 DATA BLB 1.70423f
C11 BL VDD 0.1335f
C12 VDD WE 0.76567f
C13 DATA_B BLB 0.08307f
C14 DATA_B DATA 2.23517f
R0 BLB.n0 BLB.t1 342.642
R1 BLB.n0 BLB.t0 131.251
R2 BLB BLB.n0 2.45312
R3 DATA.n0 DATA.t1 381.173
R4 DATA.n0 DATA.t0 369.265
R5 DATA DATA.n0 2.55025
R6 BL.n0 BL.t1 342.33
R7 BL.n0 BL.t0 131.564
R8 BL BL.n0 1.19978
R9 DATA_B.n0 DATA_B.t1 380.861
R10 DATA_B.n0 DATA_B.t0 369.577
R11 DATA_B DATA_B.n0 1.29692
R12 WE.n2 WE.t3 379.844
R13 WE.n0 WE.t0 371.455
R14 WE.n1 WE.t2 370.202
R15 WE.n0 WE.t1 370.202
R16 WE.n1 WE.n0 1.25383
R17 WE WE.n2 0.43525
R18 WE.n2 WE.n1 0.2355
R19 VDD.n57 VDD.n56 1380
R20 VDD.n54 VDD.n52 1380
R21 VDD.n44 VDD.n43 1380
R22 VDD.n41 VDD.n39 1380
R23 VDD.n32 VDD.n31 1380
R24 VDD.n29 VDD.n27 1380
R25 VDD.n19 VDD.n18 1380
R26 VDD.n16 VDD.n14 1380
R27 VDD.n8 VDD.n7 1380
R28 VDD.n5 VDD.n3 1380
R29 VDD.n61 VDD.t7 340.688
R30 VDD.n48 VDD.t3 340.688
R31 VDD.n23 VDD.t1 340.688
R32 VDD.n52 VDD.n51 223.581
R33 VDD.n56 VDD.n55 223.581
R34 VDD.n39 VDD.n38 223.581
R35 VDD.n43 VDD.n42 223.581
R36 VDD.n27 VDD.n26 223.581
R37 VDD.n31 VDD.n30 223.581
R38 VDD.n14 VDD.n13 223.581
R39 VDD.n18 VDD.n17 223.581
R40 VDD.n3 VDD.n2 223.581
R41 VDD.n7 VDD.n6 223.581
R42 VDD.n53 VDD.n50 147.201
R43 VDD.n53 VDD.n49 147.201
R44 VDD.n40 VDD.n37 147.201
R45 VDD.n40 VDD.n36 147.201
R46 VDD.n28 VDD.n25 147.201
R47 VDD.n28 VDD.n24 147.201
R48 VDD.n15 VDD.n12 147.201
R49 VDD.n15 VDD.n11 147.201
R50 VDD.n4 VDD.n1 147.201
R51 VDD.n4 VDD.n0 147.201
R52 VDD.n58 VDD.n50 146.071
R53 VDD.n45 VDD.n37 146.071
R54 VDD.n33 VDD.n25 146.071
R55 VDD.n20 VDD.n12 146.071
R56 VDD.n9 VDD.n1 146.071
R57 VDD.n54 VDD.n53 92.5005
R58 VDD.n58 VDD.n57 92.5005
R59 VDD.n41 VDD.n40 92.5005
R60 VDD.n45 VDD.n44 92.5005
R61 VDD.n29 VDD.n28 92.5005
R62 VDD.n33 VDD.n32 92.5005
R63 VDD.n16 VDD.n15 92.5005
R64 VDD.n20 VDD.n19 92.5005
R65 VDD.n5 VDD.n4 92.5005
R66 VDD.n9 VDD.n8 92.5005
R67 VDD.n59 VDD.n49 86.5887
R68 VDD.n46 VDD.n36 86.5887
R69 VDD.n34 VDD.n24 86.5887
R70 VDD.n21 VDD.n11 86.5887
R71 VDD.n10 VDD.n0 86.5887
R72 VDD.n57 VDD.n51 72.6454
R73 VDD.n55 VDD.n54 72.6454
R74 VDD.n44 VDD.n38 72.6454
R75 VDD.n42 VDD.n41 72.6454
R76 VDD.n32 VDD.n26 72.6454
R77 VDD.n30 VDD.n29 72.6454
R78 VDD.n19 VDD.n13 72.6454
R79 VDD.n17 VDD.n16 72.6454
R80 VDD.n8 VDD.n2 72.6454
R81 VDD.n6 VDD.n5 72.6454
R82 VDD.n59 VDD.n58 50.5605
R83 VDD.n46 VDD.n45 50.5605
R84 VDD.n34 VDD.n33 50.5605
R85 VDD.n21 VDD.n20 50.5605
R86 VDD.n10 VDD.n9 50.5605
R87 VDD.n56 VDD.n50 37.0005
R88 VDD.n52 VDD.n49 37.0005
R89 VDD.n43 VDD.n37 37.0005
R90 VDD.n39 VDD.n36 37.0005
R91 VDD.n31 VDD.n25 37.0005
R92 VDD.n27 VDD.n24 37.0005
R93 VDD.n18 VDD.n12 37.0005
R94 VDD.n14 VDD.n11 37.0005
R95 VDD.n7 VDD.n1 37.0005
R96 VDD.n3 VDD.n0 37.0005
R97 VDD.n22 VDD.n10 35.5188
R98 VDD.n60 VDD.n59 34.8922
R99 VDD.n47 VDD.n46 34.8922
R100 VDD.n35 VDD.n34 34.8922
R101 VDD.n22 VDD.n21 34.8922
R102 VDD.n55 VDD.t6 14.9873
R103 VDD.t6 VDD.n51 14.9873
R104 VDD.n42 VDD.t2 14.9873
R105 VDD.t2 VDD.n38 14.9873
R106 VDD.n30 VDD.t5 14.9873
R107 VDD.t5 VDD.n26 14.9873
R108 VDD.n17 VDD.t0 14.9873
R109 VDD.t0 VDD.n13 14.9873
R110 VDD.n6 VDD.t4 14.9873
R111 VDD.t4 VDD.n2 14.9873
R112 VDD.n47 VDD.n35 0.627167
R113 VDD VDD.n61 0.532383
R114 VDD.n35 VDD.n23 0.520633
R115 VDD.n60 VDD.n48 0.520633
R116 VDD.n23 VDD.n22 0.107033
R117 VDD.n48 VDD.n47 0.107033
R118 VDD.n61 VDD.n60 0.107033
R119 VSS.n62 VSS.n59 13600.9
R120 VSS.n56 VSS.n55 11009.4
R121 VSS.n57 VSS.n56 8243.56
R122 VSS.n58 VSS.n57 8243.56
R123 VSS.n59 VSS.n58 8243.56
R124 VSS.n63 VSS.n59 7053.97
R125 VSS.n58 VSS.n6 7053.97
R126 VSS.n57 VSS.n7 7053.97
R127 VSS.n56 VSS.n8 7053.97
R128 VSS.n65 VSS.n3 2213.35
R129 VSS.n61 VSS.n3 2213.35
R130 VSS.n65 VSS.n4 2213.35
R131 VSS.n61 VSS.n4 2213.35
R132 VSS.n33 VSS.n25 2213.35
R133 VSS.n29 VSS.n25 2213.35
R134 VSS.n33 VSS.n26 2213.35
R135 VSS.n29 VSS.n26 2213.35
R136 VSS.n40 VSS.n17 2213.35
R137 VSS.n36 VSS.n17 2213.35
R138 VSS.n40 VSS.n18 2213.35
R139 VSS.n36 VSS.n18 2213.35
R140 VSS.n47 VSS.n13 2213.35
R141 VSS.n43 VSS.n13 2213.35
R142 VSS.n47 VSS.n14 2213.35
R143 VSS.n43 VSS.n14 2213.35
R144 VSS.n54 VSS.n9 2213.35
R145 VSS.n50 VSS.n9 2213.35
R146 VSS.n54 VSS.n10 2213.35
R147 VSS.n50 VSS.n10 2213.35
R148 VSS.n49 VSS.n48 481.048
R149 VSS.n42 VSS.n41 481.048
R150 VSS.n35 VSS.n34 481.048
R151 VSS.n64 VSS.n5 481.048
R152 VSS.n45 VSS.n14 292.5
R153 VSS.t0 VSS.n14 292.5
R154 VSS.n16 VSS.n13 292.5
R155 VSS.t0 VSS.n13 292.5
R156 VSS.n38 VSS.n18 292.5
R157 VSS.t2 VSS.n18 292.5
R158 VSS.n24 VSS.n17 292.5
R159 VSS.t2 VSS.n17 292.5
R160 VSS.n31 VSS.n26 292.5
R161 VSS.n26 VSS.t1 292.5
R162 VSS.n28 VSS.n25 292.5
R163 VSS.t1 VSS.n25 292.5
R164 VSS.n4 VSS.n2 292.5
R165 VSS.t4 VSS.n4 292.5
R166 VSS.n3 VSS.n1 292.5
R167 VSS.t4 VSS.n3 292.5
R168 VSS.n52 VSS.n10 292.5
R169 VSS.n10 VSS.t6 292.5
R170 VSS.n12 VSS.n9 292.5
R171 VSS.n9 VSS.t6 292.5
R172 VSS.n55 VSS.t6 157.036
R173 VSS.n49 VSS.t6 157.036
R174 VSS.n42 VSS.t0 157.036
R175 VSS.n35 VSS.t2 157.036
R176 VSS.t1 VSS.n5 157.036
R177 VSS.t4 VSS.n62 157.036
R178 VSS.n66 VSS.n2 143.812
R179 VSS.n60 VSS.n2 143.812
R180 VSS.n32 VSS.n31 143.812
R181 VSS.n31 VSS.n30 143.812
R182 VSS.n39 VSS.n38 143.812
R183 VSS.n38 VSS.n37 143.812
R184 VSS.n46 VSS.n45 143.812
R185 VSS.n45 VSS.n44 143.812
R186 VSS.n52 VSS.n51 143.812
R187 VSS.n53 VSS.n52 143.812
R188 VSS.n60 VSS.n1 142.683
R189 VSS.n30 VSS.n28 142.683
R190 VSS.n37 VSS.n24 142.683
R191 VSS.n44 VSS.n16 142.683
R192 VSS.n51 VSS.n12 142.683
R193 VSS.n69 VSS.t5 127.397
R194 VSS.n21 VSS.t3 127.397
R195 VSS.n19 VSS.t7 127.397
R196 VSS.n44 VSS.n43 117.001
R197 VSS.n43 VSS.n42 117.001
R198 VSS.n47 VSS.n46 117.001
R199 VSS.n48 VSS.n47 117.001
R200 VSS.n37 VSS.n36 117.001
R201 VSS.n36 VSS.n35 117.001
R202 VSS.n40 VSS.n39 117.001
R203 VSS.n41 VSS.n40 117.001
R204 VSS.n30 VSS.n29 117.001
R205 VSS.n29 VSS.n5 117.001
R206 VSS.n33 VSS.n32 117.001
R207 VSS.n34 VSS.n33 117.001
R208 VSS.n61 VSS.n60 117.001
R209 VSS.n62 VSS.n61 117.001
R210 VSS.n66 VSS.n65 117.001
R211 VSS.n65 VSS.n64 117.001
R212 VSS.n51 VSS.n50 117.001
R213 VSS.n50 VSS.n49 117.001
R214 VSS.n54 VSS.n53 117.001
R215 VSS.n55 VSS.n54 117.001
R216 VSS.t0 VSS.n8 99.3906
R217 VSS.t2 VSS.n7 99.3906
R218 VSS.t1 VSS.n6 99.3906
R219 VSS.n63 VSS.t4 99.3906
R220 VSS.n67 VSS.n66 83.2005
R221 VSS.n32 VSS.n27 83.2005
R222 VSS.n39 VSS.n23 83.2005
R223 VSS.n46 VSS.n15 83.2005
R224 VSS.n53 VSS.n11 83.2005
R225 VSS.n48 VSS.n8 57.6468
R226 VSS.n41 VSS.n7 57.6468
R227 VSS.n34 VSS.n6 57.6468
R228 VSS.n64 VSS.n63 57.6468
R229 VSS.n67 VSS.n1 50.5605
R230 VSS.n28 VSS.n27 50.5605
R231 VSS.n24 VSS.n23 50.5605
R232 VSS.n16 VSS.n15 50.5605
R233 VSS.n12 VSS.n11 50.5605
R234 VSS.n19 VSS.n11 36.0216
R235 VSS.n68 VSS.n67 35.9151
R236 VSS.n27 VSS.n0 35.9151
R237 VSS.n23 VSS.n22 35.9151
R238 VSS.n20 VSS.n15 35.9151
R239 VSS VSS.n69 0.767383
R240 VSS.n22 VSS.n20 0.627167
R241 VSS.n68 VSS.n0 0.627167
R242 VSS.n20 VSS.n19 0.520633
R243 VSS.n21 VSS.n0 0.520633
R244 VSS.n22 VSS.n21 0.107033
R245 VSS.n69 VSS.n68 0.107033
R246 a_3015_n5084.t0 a_3015_n5084.t1 260.435
R247 a_1415_n5084.t0 a_1415_n5084.t1 261.685
R248 a_2627_n1084.t0 a_2627_n1084.t1 687.197
R249 a_1027_n1084.t0 a_1027_n1084.t1 685.947
R250 a_227_n1084.t0 a_227_n1084.n1 341.236
R251 a_227_n1084.n1 a_227_n1084.n0 0.4893
R252 a_227_n1084.n0 a_227_n1084.t2 381.409
R253 a_227_n1084.n1 a_227_n1084.t1 132.501
R254 a_227_n1084.n0 a_227_n1084.t3 380.156
C15 BLB VSS 2.37664f
C16 DATA VSS 2.58225f
C17 BL VSS 1.77636f
C18 DATA_B VSS 1.8534f
C19 WE VSS 3.93494f
C20 VDD VSS 8.64966f
C21 a_227_n1084.t0 VSS 0.12182f $ **FLOATING
C22 a_227_n1084.t3 VSS 0.15207f $ **FLOATING
C23 a_227_n1084.n0 VSS 4.27783f $ **FLOATING
C24 a_227_n1084.t1 VSS 0.24099f $ **FLOATING
C25 a_227_n1084.n1 VSS 4.06395f $ **FLOATING
C26 a_227_n1084.t2 VSS 0.16083f $ **FLOATING
C27 a_1027_n1084.t0 VSS 3.70118f $ **FLOATING
C28 a_1027_n1084.t1 VSS 3.70219f $ **FLOATING
C29 a_2627_n1084.t0 VSS 3.86241f $ **FLOATING
C30 a_2627_n1084.t1 VSS 3.86038f $ **FLOATING
C31 a_1415_n5084.t0 VSS 3.44126f $ **FLOATING
C32 a_1415_n5084.t1 VSS 3.44175f $ **FLOATING
C33 a_3015_n5084.t0 VSS 2.20013f $ **FLOATING
C34 a_3015_n5084.t1 VSS 2.19811f $ **FLOATING
C35 VDD.n0 VSS 0.01433f $ **FLOATING
C36 VDD.n1 VSS 0.01821f $ **FLOATING
C37 VDD.t4 VSS 0.15472f $ **FLOATING
C38 VDD.n3 VSS 0.11067f $ **FLOATING
C39 VDD.n4 VSS 0.01856f $ **FLOATING
C40 VDD.n5 VSS 0.01856f $ **FLOATING
C41 VDD.n7 VSS 0.11067f $ **FLOATING
C42 VDD.n8 VSS 0.01856f $ **FLOATING
C43 VDD.n9 VSS 0.0137f $ **FLOATING
C44 VDD.n10 VSS 0.02249f $ **FLOATING
C45 VDD.n11 VSS 0.01433f $ **FLOATING
C46 VDD.n12 VSS 0.01821f $ **FLOATING
C47 VDD.t0 VSS 0.15472f $ **FLOATING
C48 VDD.n14 VSS 0.11067f $ **FLOATING
C49 VDD.n15 VSS 0.01856f $ **FLOATING
C50 VDD.n16 VSS 0.01856f $ **FLOATING
C51 VDD.n18 VSS 0.11067f $ **FLOATING
C52 VDD.n19 VSS 0.01856f $ **FLOATING
C53 VDD.n20 VSS 0.0137f $ **FLOATING
C54 VDD.n21 VSS 0.0201f $ **FLOATING
C55 VDD.n22 VSS 0.21441f $ **FLOATING
C56 VDD.t1 VSS 0.01349f $ **FLOATING
C57 VDD.n23 VSS 0.11627f $ **FLOATING
C58 VDD.n24 VSS 0.01433f $ **FLOATING
C59 VDD.n25 VSS 0.01821f $ **FLOATING
C60 VDD.t5 VSS 0.15472f $ **FLOATING
C61 VDD.n27 VSS 0.11067f $ **FLOATING
C62 VDD.n28 VSS 0.01856f $ **FLOATING
C63 VDD.n29 VSS 0.01856f $ **FLOATING
C64 VDD.n31 VSS 0.11067f $ **FLOATING
C65 VDD.n32 VSS 0.01856f $ **FLOATING
C66 VDD.n33 VSS 0.0137f $ **FLOATING
C67 VDD.n34 VSS 0.0201f $ **FLOATING
C68 VDD.n35 VSS 0.10266f $ **FLOATING
C69 VDD.n36 VSS 0.01433f $ **FLOATING
C70 VDD.n37 VSS 0.01821f $ **FLOATING
C71 VDD.t2 VSS 0.15472f $ **FLOATING
C72 VDD.n39 VSS 0.11067f $ **FLOATING
C73 VDD.n40 VSS 0.01856f $ **FLOATING
C74 VDD.n41 VSS 0.01856f $ **FLOATING
C75 VDD.n43 VSS 0.11067f $ **FLOATING
C76 VDD.n44 VSS 0.01856f $ **FLOATING
C77 VDD.n45 VSS 0.0137f $ **FLOATING
C78 VDD.n46 VSS 0.0201f $ **FLOATING
C79 VDD.n47 VSS 0.08163f $ **FLOATING
C80 VDD.t3 VSS 0.01349f $ **FLOATING
C81 VDD.n48 VSS 0.11627f $ **FLOATING
C82 VDD.n49 VSS 0.01433f $ **FLOATING
C83 VDD.n50 VSS 0.01821f $ **FLOATING
C84 VDD.t6 VSS 0.15472f $ **FLOATING
C85 VDD.n52 VSS 0.11067f $ **FLOATING
C86 VDD.n53 VSS 0.01856f $ **FLOATING
C87 VDD.n54 VSS 0.01856f $ **FLOATING
C88 VDD.n56 VSS 0.11067f $ **FLOATING
C89 VDD.n57 VSS 0.01856f $ **FLOATING
C90 VDD.n58 VSS 0.0137f $ **FLOATING
C91 VDD.n59 VSS 0.0201f $ **FLOATING
C92 VDD.n60 VSS 0.07622f $ **FLOATING
C93 VDD.t7 VSS 0.01349f $ **FLOATING
C94 VDD.n61 VSS 0.11686f $ **FLOATING
C95 WE.t0 VSS 0.15073f $ **FLOATING
C96 WE.t1 VSS 0.14182f $ **FLOATING
C97 WE.n0 VSS 5.32653f $ **FLOATING
C98 WE.t2 VSS 0.14182f $ **FLOATING
C99 WE.n1 VSS 2.33799f $ **FLOATING
C100 WE.t3 VSS 0.11762f $ **FLOATING
C101 WE.n2 VSS 0.80892f $ **FLOATING
C102 DATA_B.t1 VSS 0.19458f $ **FLOATING
C103 DATA_B.t0 VSS 0.21821f $ **FLOATING
C104 DATA_B.n0 VSS 7.22263f $ **FLOATING
C105 BL.t1 VSS 0.14054f $ **FLOATING
C106 BL.t0 VSS 0.23418f $ **FLOATING
C107 BL.n0 VSS 6.47907f $ **FLOATING
C108 DATA.t1 VSS 0.19437f $ **FLOATING
C109 DATA.t0 VSS 0.21367f $ **FLOATING
C110 DATA.n0 VSS 6.4912f $ **FLOATING
C111 BLB.t1 VSS 0.1416f $ **FLOATING
C112 BLB.t0 VSS 0.22618f $ **FLOATING
C113 BLB.n0 VSS 5.881f $ **FLOATING
.ends
