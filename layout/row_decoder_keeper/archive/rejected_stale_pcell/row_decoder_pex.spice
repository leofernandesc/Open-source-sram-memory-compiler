* NGSPICE file created from row_decoder_flat.ext - technology: sky130A

.subckt row_decoder_flat VDD PCLK A0 A1 DEC0 DEC1 DEC3 DEC2 VSS
X0 VSS.t25 PCLK.t0 EVAL_GND.t4 VSS.t24 sky130_fd_pr__nfet_01v8 ad=0.435 pd=3.58 as=0.435 ps=3.58 w=1.5 l=0.15
X1 net4.t0 A1T.t2 N3.t0 VSS.t5 sky130_fd_pr__nfet_01v8 ad=0.58 pd=4.58 as=0.58 ps=4.58 w=2 l=0.15
X2 VDD.t13 DEC2.t2 N2.t1 VDD.t12 sky130_fd_pr__pfet_01v8 ad=0.1218 pd=1.42 as=0.1218 ps=1.42 w=0.42 l=0.15
X3 VDD.t9 N3.t4 DEC3.t1 VDD.t8 sky130_fd_pr__pfet_01v8 ad=0.87 pd=6.58 as=0.87 ps=6.58 w=3 l=0.15
X4 net1.t0 A1B.t3 N0.t0 VSS.t9 sky130_fd_pr__nfet_01v8 ad=0.58 pd=4.58 as=0.58 ps=4.58 w=2 l=0.15
X5 VSS.t23 A0.t0 A0B.t1 VSS.t22 sky130_fd_pr__nfet_01v8 ad=0.2436 pd=2.26 as=0.2436 ps=2.26 w=0.84 l=0.15
X6 VDD.t15 DEC0.t2 N0.t1 VDD.t14 sky130_fd_pr__pfet_01v8 ad=0.1218 pd=1.42 as=0.1218 ps=1.42 w=0.42 l=0.15
X7 VDD.t3 N1.t4 DEC1.t1 VDD.t2 sky130_fd_pr__pfet_01v8 ad=0.87 pd=6.58 as=0.87 ps=6.58 w=3 l=0.15
X8 VSS.t15 N2.t3 DEC2.t0 VSS.t14 sky130_fd_pr__nfet_01v8 ad=0.58 pd=4.58 as=0.58 ps=4.58 w=2 l=0.15
X9 VSS.t11 A1B.t4 A1T.t0 VSS.t10 sky130_fd_pr__nfet_01v8 ad=0.58 pd=4.58 as=0.58 ps=4.58 w=2 l=0.15
X10 VDD.t23 DEC1.t2 N1.t1 VDD.t22 sky130_fd_pr__pfet_01v8 ad=0.1218 pd=1.42 as=0.1218 ps=1.42 w=0.42 l=0.15
X11 EVAL_GND.t2 A0B.t2 net3.t1 VSS.t16 sky130_fd_pr__nfet_01v8 ad=0.58 pd=4.58 as=0.58 ps=4.58 w=2 l=0.15
X12 VDD.t27 PCLK.t2 N2.t2 VDD.t26 sky130_fd_pr__pfet_01v8 ad=0.3625 pd=3.08 as=0.3625 ps=3.08 w=1.25 l=0.15
X13 VDD.t17 A1.t1 A1B.t0 VDD.t16 sky130_fd_pr__pfet_01v8 ad=0.2436 pd=2.26 as=0.2436 ps=2.26 w=0.84 l=0.15
X14 VDD.t7 A1B.t5 A1T.t1 VDD.t6 sky130_fd_pr__pfet_01v8 ad=0.58 pd=4.58 as=0.58 ps=4.58 w=2 l=0.15
X15 VDD.t31 PCLK.t4 N0.t2 VDD.t30 sky130_fd_pr__pfet_01v8 ad=0.3625 pd=3.08 as=0.3625 ps=3.08 w=1.25 l=0.15
X16 net3.t0 A1T.t3 N2.t0 VSS.t6 sky130_fd_pr__nfet_01v8 ad=0.58 pd=4.58 as=0.58 ps=4.58 w=2 l=0.15
X17 VDD.t19 A0.t1 A0B.t0 VDD.t18 sky130_fd_pr__pfet_01v8 ad=0.2436 pd=2.26 as=0.2436 ps=2.26 w=0.84 l=0.15
X18 VSS.t19 A0B.t4 A0T.t1 VSS.t18 sky130_fd_pr__nfet_01v8 ad=0.58 pd=4.58 as=0.58 ps=4.58 w=2 l=0.15
X19 VDD.t1 A0B.t5 A0T.t0 VDD.t0 sky130_fd_pr__pfet_01v8 ad=0.58 pd=4.58 as=0.58 ps=4.58 w=2 l=0.15
X20 VDD.t21 DEC3.t2 N3.t1 VDD.t20 sky130_fd_pr__pfet_01v8 ad=0.1218 pd=1.42 as=0.1218 ps=1.42 w=0.42 l=0.15
X21 VDD.t29 PCLK.t3 N1.t2 VDD.t28 sky130_fd_pr__pfet_01v8 ad=0.3625 pd=3.08 as=0.3625 ps=3.08 w=1.25 l=0.15
X22 VSS.t2 N1.t3 DEC1.t0 VSS.t1 sky130_fd_pr__nfet_01v8 ad=0.58 pd=4.58 as=0.58 ps=4.58 w=2 l=0.15
X23 net2.t0 A1B.t2 N1.t0 VSS.t0 sky130_fd_pr__nfet_01v8 ad=0.58 pd=4.58 as=0.58 ps=4.58 w=2 l=0.15
X24 VDD.t25 PCLK.t1 N3.t2 VDD.t24 sky130_fd_pr__pfet_01v8 ad=0.3625 pd=3.08 as=0.3625 ps=3.08 w=1.25 l=0.15
X25 VSS.t8 N3.t3 DEC3.t0 VSS.t7 sky130_fd_pr__nfet_01v8 ad=0.58 pd=4.58 as=0.58 ps=4.58 w=2 l=0.15
X26 EVAL_GND.t1 A0T.t3 net2.t1 VSS.t13 sky130_fd_pr__nfet_01v8 ad=0.58 pd=4.58 as=0.58 ps=4.58 w=2 l=0.15
X27 VSS.t4 N0.t3 DEC0.t0 VSS.t3 sky130_fd_pr__nfet_01v8 ad=0.58 pd=4.58 as=0.58 ps=4.58 w=2 l=0.15
X28 VDD.t5 N0.t4 DEC0.t1 VDD.t4 sky130_fd_pr__pfet_01v8 ad=0.87 pd=6.58 as=0.87 ps=6.58 w=3 l=0.15
X29 VSS.t21 A1.t0 A1B.t1 VSS.t20 sky130_fd_pr__nfet_01v8 ad=0.2436 pd=2.26 as=0.2436 ps=2.26 w=0.84 l=0.15
X30 EVAL_GND.t0 A0T.t2 net4.t1 VSS.t12 sky130_fd_pr__nfet_01v8 ad=0.58 pd=4.58 as=0.58 ps=4.58 w=2 l=0.15
X31 VDD.t11 N2.t4 DEC2.t1 VDD.t10 sky130_fd_pr__pfet_01v8 ad=0.87 pd=6.58 as=0.87 ps=6.58 w=3 l=0.15
X32 EVAL_GND.t3 A0B.t3 net1.t1 VSS.t17 sky130_fd_pr__nfet_01v8 ad=0.58 pd=4.58 as=0.58 ps=4.58 w=2 l=0.15
R0 DEC3.n1 DEC3.t2 160.869
R1 DEC3.n0 DEC3.t1 88.9801
R2 DEC3.n0 DEC3.t0 50.6916
R3 DEC3.n1 DEC3.n0 6.698
R4 DEC3 DEC3.n1 0.75955
R5 DEC2.n1 DEC2.t2 160.869
R6 DEC2.n0 DEC2.t1 88.9801
R7 DEC2.n0 DEC2.t0 50.6916
R8 DEC2.n1 DEC2.n0 6.698
R9 DEC2 DEC2.n1 0.75955
R10 DEC1.n1 DEC1.t2 160.869
R11 DEC1.n0 DEC1.t1 88.9801
R12 DEC1.n0 DEC1.t0 50.6916
R13 DEC1.n1 DEC1.n0 6.698
R14 DEC1 DEC1.n1 0.75955
R15 DEC0.n1 DEC0.t2 160.869
R16 DEC0.n0 DEC0.t1 88.9801
R17 DEC0.n0 DEC0.t0 50.6916
R18 DEC0.n1 DEC0.n0 6.698
R19 DEC0 DEC0.n1 0.75955
R20 PCLK.n1 PCLK.t0 245.213
R21 PCLK.n0 PCLK.t1 230.785
R22 PCLK.n3 PCLK.t4 228.208
R23 PCLK.n2 PCLK.t3 228.208
R24 PCLK.n0 PCLK.t2 228.208
R25 PCLK PCLK.n3 4.36288
R26 PCLK.n3 PCLK.n2 2.5761
R27 PCLK.n2 PCLK.n1 2.3411
R28 PCLK.n1 PCLK.n0 1.08777
R29 A1.n0 A1.t1 191.999
R30 A1.n0 A1.t0 186.636
R31 A1 A1.n0 2.40455
R32 A0.n0 A0.t1 192.624
R33 A0.n0 A0.t0 186.011
R34 A0 A0.n0 0.681217
R35 VDD.n5 VDD.n3 2142.35
R36 VDD.n8 VDD.n7 2142.35
R37 VDD.n43 VDD.n41 2142.35
R38 VDD.n46 VDD.n45 2142.35
R39 VDD.n82 VDD.n80 2142.35
R40 VDD.n85 VDD.n84 2142.35
R41 VDD.n121 VDD.n119 2142.35
R42 VDD.n124 VDD.n123 2142.35
R43 VDD.n160 VDD.n158 1789.41
R44 VDD.n163 VDD.n162 1789.41
R45 VDD.n186 VDD.n184 1789.41
R46 VDD.n189 VDD.n188 1789.41
R47 VDD.n30 VDD.n28 1524.71
R48 VDD.n33 VDD.n32 1524.71
R49 VDD.n69 VDD.n67 1524.71
R50 VDD.n72 VDD.n71 1524.71
R51 VDD.n108 VDD.n106 1524.71
R52 VDD.n111 VDD.n110 1524.71
R53 VDD.n147 VDD.n145 1524.71
R54 VDD.n150 VDD.n149 1524.71
R55 VDD.n173 VDD.n171 1380
R56 VDD.n176 VDD.n175 1380
R57 VDD.n199 VDD.n197 1380
R58 VDD.n202 VDD.n201 1380
R59 VDD.n17 VDD.n15 1231.76
R60 VDD.n20 VDD.n19 1231.76
R61 VDD.n56 VDD.n54 1231.76
R62 VDD.n59 VDD.n58 1231.76
R63 VDD.n95 VDD.n93 1231.76
R64 VDD.n98 VDD.n97 1231.76
R65 VDD.n134 VDD.n132 1231.76
R66 VDD.n137 VDD.n136 1231.76
R67 VDD.n24 VDD.t21 672.335
R68 VDD.n63 VDD.t13 672.335
R69 VDD.n102 VDD.t23 672.335
R70 VDD.n141 VDD.t15 672.335
R71 VDD.n180 VDD.t17 341.161
R72 VDD.n206 VDD.t19 341.161
R73 VDD.n19 VDD.n18 247.977
R74 VDD.n15 VDD.n14 247.977
R75 VDD.n58 VDD.n57 247.977
R76 VDD.n54 VDD.n53 247.977
R77 VDD.n97 VDD.n96 247.977
R78 VDD.n93 VDD.n92 247.977
R79 VDD.n136 VDD.n135 247.977
R80 VDD.n132 VDD.n131 247.977
R81 VDD.n37 VDD.t25 230.952
R82 VDD.n76 VDD.t27 230.952
R83 VDD.n115 VDD.t29 230.952
R84 VDD.n154 VDD.t31 230.952
R85 VDD.n4 VDD.n0 228.518
R86 VDD.n4 VDD.n1 228.518
R87 VDD.n42 VDD.n38 228.518
R88 VDD.n42 VDD.n39 228.518
R89 VDD.n81 VDD.n77 228.518
R90 VDD.n81 VDD.n78 228.518
R91 VDD.n120 VDD.n116 228.518
R92 VDD.n120 VDD.n117 228.518
R93 VDD.n9 VDD.n1 227.388
R94 VDD.n47 VDD.n39 227.388
R95 VDD.n86 VDD.n78 227.388
R96 VDD.n125 VDD.n117 227.388
R97 VDD.n175 VDD.n174 223.581
R98 VDD.n171 VDD.n170 223.581
R99 VDD.n201 VDD.n200 223.581
R100 VDD.n197 VDD.n196 223.581
R101 VDD.n32 VDD.n31 203.438
R102 VDD.n28 VDD.n27 203.438
R103 VDD.n71 VDD.n70 203.438
R104 VDD.n67 VDD.n66 203.438
R105 VDD.n110 VDD.n109 203.438
R106 VDD.n106 VDD.n105 203.438
R107 VDD.n149 VDD.n148 203.438
R108 VDD.n145 VDD.n144 203.438
R109 VDD.n159 VDD.n155 190.871
R110 VDD.n159 VDD.n156 190.871
R111 VDD.n185 VDD.n181 190.871
R112 VDD.n185 VDD.n182 190.871
R113 VDD.n164 VDD.n156 189.742
R114 VDD.n190 VDD.n182 189.742
R115 VDD.n162 VDD.n161 173.642
R116 VDD.n158 VDD.n157 173.642
R117 VDD.n188 VDD.n187 173.642
R118 VDD.n184 VDD.n183 173.642
R119 VDD.n10 VDD.n0 167.906
R120 VDD.n48 VDD.n38 167.906
R121 VDD.n87 VDD.n77 167.906
R122 VDD.n126 VDD.n116 167.906
R123 VDD.n29 VDD.n25 162.636
R124 VDD.n29 VDD.n26 162.636
R125 VDD.n68 VDD.n64 162.636
R126 VDD.n68 VDD.n65 162.636
R127 VDD.n107 VDD.n103 162.636
R128 VDD.n107 VDD.n104 162.636
R129 VDD.n146 VDD.n142 162.636
R130 VDD.n146 VDD.n143 162.636
R131 VDD.n34 VDD.n26 161.506
R132 VDD.n73 VDD.n65 161.506
R133 VDD.n112 VDD.n104 161.506
R134 VDD.n151 VDD.n143 161.506
R135 VDD.n172 VDD.n168 147.201
R136 VDD.n172 VDD.n169 147.201
R137 VDD.n198 VDD.n194 147.201
R138 VDD.n198 VDD.n195 147.201
R139 VDD.n177 VDD.n169 146.071
R140 VDD.n203 VDD.n195 146.071
R141 VDD.n7 VDD.n6 144.319
R142 VDD.n3 VDD.n2 144.319
R143 VDD.n45 VDD.n44 144.319
R144 VDD.n41 VDD.n40 144.319
R145 VDD.n84 VDD.n83 144.319
R146 VDD.n80 VDD.n79 144.319
R147 VDD.n123 VDD.n122 144.319
R148 VDD.n119 VDD.n118 144.319
R149 VDD.n16 VDD.n12 131.388
R150 VDD.n16 VDD.n13 131.388
R151 VDD.n55 VDD.n51 131.388
R152 VDD.n55 VDD.n52 131.388
R153 VDD.n94 VDD.n90 131.388
R154 VDD.n94 VDD.n91 131.388
R155 VDD.n133 VDD.n129 131.388
R156 VDD.n133 VDD.n130 131.388
R157 VDD.n21 VDD.n13 130.26
R158 VDD.n60 VDD.n52 130.26
R159 VDD.n99 VDD.n91 130.26
R160 VDD.n138 VDD.n130 130.26
R161 VDD.n165 VDD.n155 130.26
R162 VDD.n191 VDD.n181 130.26
R163 VDD.n23 VDD.n22 124.507
R164 VDD.n62 VDD.n61 124.507
R165 VDD.n101 VDD.n100 124.507
R166 VDD.n140 VDD.n139 124.507
R167 VDD.n179 VDD.n178 124.421
R168 VDD.n205 VDD.n204 124.421
R169 VDD.n36 VDD.n35 124.335
R170 VDD.n75 VDD.n74 124.335
R171 VDD.n114 VDD.n113 124.335
R172 VDD.n153 VDD.n152 124.335
R173 VDD.n166 VDD.n165 124.178
R174 VDD.n192 VDD.n191 124.178
R175 VDD.n11 VDD.n10 124.165
R176 VDD.n49 VDD.n48 123.971
R177 VDD.n88 VDD.n87 123.971
R178 VDD.n127 VDD.n126 123.971
R179 VDD.n167 VDD.t7 123.638
R180 VDD.n193 VDD.t1 123.638
R181 VDD.n35 VDD.n25 102.025
R182 VDD.n74 VDD.n64 102.025
R183 VDD.n113 VDD.n103 102.025
R184 VDD.n152 VDD.n142 102.025
R185 VDD.n11 VDD.t9 93.8026
R186 VDD.n50 VDD.t11 93.8026
R187 VDD.n89 VDD.t3 93.8026
R188 VDD.n128 VDD.t5 93.8026
R189 VDD.n9 VDD.n8 92.5005
R190 VDD.n5 VDD.n4 92.5005
R191 VDD.n21 VDD.n20 92.5005
R192 VDD.n17 VDD.n16 92.5005
R193 VDD.n34 VDD.n33 92.5005
R194 VDD.n30 VDD.n29 92.5005
R195 VDD.n47 VDD.n46 92.5005
R196 VDD.n43 VDD.n42 92.5005
R197 VDD.n60 VDD.n59 92.5005
R198 VDD.n56 VDD.n55 92.5005
R199 VDD.n73 VDD.n72 92.5005
R200 VDD.n69 VDD.n68 92.5005
R201 VDD.n86 VDD.n85 92.5005
R202 VDD.n82 VDD.n81 92.5005
R203 VDD.n99 VDD.n98 92.5005
R204 VDD.n95 VDD.n94 92.5005
R205 VDD.n112 VDD.n111 92.5005
R206 VDD.n108 VDD.n107 92.5005
R207 VDD.n125 VDD.n124 92.5005
R208 VDD.n121 VDD.n120 92.5005
R209 VDD.n138 VDD.n137 92.5005
R210 VDD.n134 VDD.n133 92.5005
R211 VDD.n151 VDD.n150 92.5005
R212 VDD.n147 VDD.n146 92.5005
R213 VDD.n164 VDD.n163 92.5005
R214 VDD.n160 VDD.n159 92.5005
R215 VDD.n177 VDD.n176 92.5005
R216 VDD.n173 VDD.n172 92.5005
R217 VDD.n190 VDD.n189 92.5005
R218 VDD.n186 VDD.n185 92.5005
R219 VDD.n203 VDD.n202 92.5005
R220 VDD.n199 VDD.n198 92.5005
R221 VDD.n178 VDD.n168 86.5887
R222 VDD.n204 VDD.n194 86.5887
R223 VDD.n6 VDD.n5 82.6992
R224 VDD.n8 VDD.n2 82.6992
R225 VDD.n44 VDD.n43 82.6992
R226 VDD.n46 VDD.n40 82.6992
R227 VDD.n83 VDD.n82 82.6992
R228 VDD.n85 VDD.n79 82.6992
R229 VDD.n122 VDD.n121 82.6992
R230 VDD.n124 VDD.n118 82.6992
R231 VDD.n161 VDD.n160 79.4196
R232 VDD.n163 VDD.n157 79.4196
R233 VDD.n187 VDD.n186 79.4196
R234 VDD.n189 VDD.n183 79.4196
R235 VDD.n31 VDD.n30 75.5742
R236 VDD.n33 VDD.n27 75.5742
R237 VDD.n70 VDD.n69 75.5742
R238 VDD.n72 VDD.n66 75.5742
R239 VDD.n109 VDD.n108 75.5742
R240 VDD.n111 VDD.n105 75.5742
R241 VDD.n148 VDD.n147 75.5742
R242 VDD.n150 VDD.n144 75.5742
R243 VDD.n174 VDD.n173 72.6454
R244 VDD.n176 VDD.n170 72.6454
R245 VDD.n200 VDD.n199 72.6454
R246 VDD.n202 VDD.n196 72.6454
R247 VDD.n22 VDD.n12 70.777
R248 VDD.n61 VDD.n51 70.777
R249 VDD.n100 VDD.n90 70.777
R250 VDD.n139 VDD.n129 70.777
R251 VDD.n18 VDD.n17 68.7187
R252 VDD.n20 VDD.n14 68.7187
R253 VDD.n57 VDD.n56 68.7187
R254 VDD.n59 VDD.n53 68.7187
R255 VDD.n96 VDD.n95 68.7187
R256 VDD.n98 VDD.n92 68.7187
R257 VDD.n135 VDD.n134 68.7187
R258 VDD.n137 VDD.n131 68.7187
R259 VDD.n10 VDD.n9 50.5605
R260 VDD.n22 VDD.n21 50.5605
R261 VDD.n35 VDD.n34 50.5605
R262 VDD.n48 VDD.n47 50.5605
R263 VDD.n61 VDD.n60 50.5605
R264 VDD.n74 VDD.n73 50.5605
R265 VDD.n87 VDD.n86 50.5605
R266 VDD.n100 VDD.n99 50.5605
R267 VDD.n113 VDD.n112 50.5605
R268 VDD.n126 VDD.n125 50.5605
R269 VDD.n139 VDD.n138 50.5605
R270 VDD.n152 VDD.n151 50.5605
R271 VDD.n165 VDD.n164 50.5605
R272 VDD.n178 VDD.n177 50.5605
R273 VDD.n191 VDD.n190 50.5605
R274 VDD.n204 VDD.n203 50.5605
R275 VDD.n15 VDD.n12 46.2505
R276 VDD.n19 VDD.n13 46.2505
R277 VDD.n54 VDD.n51 46.2505
R278 VDD.n58 VDD.n52 46.2505
R279 VDD.n93 VDD.n90 46.2505
R280 VDD.n97 VDD.n91 46.2505
R281 VDD.n132 VDD.n129 46.2505
R282 VDD.n136 VDD.n130 46.2505
R283 VDD.n171 VDD.n168 37.0005
R284 VDD.n175 VDD.n169 37.0005
R285 VDD.n197 VDD.n194 37.0005
R286 VDD.n201 VDD.n195 37.0005
R287 VDD.n28 VDD.n25 30.8338
R288 VDD.n32 VDD.n26 30.8338
R289 VDD.n67 VDD.n64 30.8338
R290 VDD.n71 VDD.n65 30.8338
R291 VDD.n106 VDD.n103 30.8338
R292 VDD.n110 VDD.n104 30.8338
R293 VDD.n145 VDD.n142 30.8338
R294 VDD.n149 VDD.n143 30.8338
R295 VDD.n158 VDD.n155 23.1255
R296 VDD.n162 VDD.n156 23.1255
R297 VDD.n184 VDD.n181 23.1255
R298 VDD.n188 VDD.n182 23.1255
R299 VDD.t20 VDD.n14 18.6229
R300 VDD.n18 VDD.t20 18.6229
R301 VDD.t12 VDD.n53 18.6229
R302 VDD.n57 VDD.t12 18.6229
R303 VDD.t22 VDD.n92 18.6229
R304 VDD.n96 VDD.t22 18.6229
R305 VDD.t14 VDD.n131 18.6229
R306 VDD.n135 VDD.t14 18.6229
R307 VDD.n3 VDD.n0 16.8187
R308 VDD.n7 VDD.n1 16.8187
R309 VDD.n41 VDD.n38 16.8187
R310 VDD.n45 VDD.n39 16.8187
R311 VDD.n80 VDD.n77 16.8187
R312 VDD.n84 VDD.n78 16.8187
R313 VDD.n119 VDD.n116 16.8187
R314 VDD.n123 VDD.n117 16.8187
R315 VDD.t16 VDD.n170 14.9873
R316 VDD.n174 VDD.t16 14.9873
R317 VDD.t18 VDD.n196 14.9873
R318 VDD.n200 VDD.t18 14.9873
R319 VDD.t24 VDD.n27 12.343
R320 VDD.n31 VDD.t24 12.343
R321 VDD.t26 VDD.n66 12.343
R322 VDD.n70 VDD.t26 12.343
R323 VDD.t28 VDD.n105 12.343
R324 VDD.n109 VDD.t28 12.343
R325 VDD.t30 VDD.n144 12.343
R326 VDD.n148 VDD.t30 12.343
R327 VDD.t6 VDD.n157 8.97701
R328 VDD.n161 VDD.t6 8.97701
R329 VDD.t0 VDD.n183 8.97701
R330 VDD.n187 VDD.t0 8.97701
R331 VDD.t8 VDD.n2 6.23219
R332 VDD.n6 VDD.t8 6.23219
R333 VDD.t10 VDD.n40 6.23219
R334 VDD.n44 VDD.t10 6.23219
R335 VDD.t2 VDD.n79 6.23219
R336 VDD.n83 VDD.t2 6.23219
R337 VDD.t4 VDD.n118 6.23219
R338 VDD.n122 VDD.t4 6.23219
R339 VDD.n88 VDD.n76 1.51077
R340 VDD VDD.n206 1.03372
R341 VDD.n205 VDD.n193 0.6491
R342 VDD.n192 VDD.n180 0.6491
R343 VDD.n179 VDD.n167 0.6491
R344 VDD.n166 VDD.n154 0.6491
R345 VDD.n153 VDD.n141 0.6491
R346 VDD.n140 VDD.n128 0.6491
R347 VDD.n127 VDD.n115 0.6491
R348 VDD.n114 VDD.n102 0.6491
R349 VDD.n101 VDD.n89 0.6491
R350 VDD.n75 VDD.n63 0.6491
R351 VDD.n62 VDD.n50 0.6491
R352 VDD.n49 VDD.n37 0.6491
R353 VDD.n36 VDD.n24 0.6491
R354 VDD.n23 VDD.n11 0.6491
R355 VDD.n206 VDD.n205 0.194767
R356 VDD.n193 VDD.n192 0.194767
R357 VDD.n180 VDD.n179 0.194767
R358 VDD.n167 VDD.n166 0.194767
R359 VDD.n154 VDD.n153 0.194767
R360 VDD.n141 VDD.n140 0.194767
R361 VDD.n128 VDD.n127 0.194767
R362 VDD.n115 VDD.n114 0.194767
R363 VDD.n102 VDD.n101 0.194767
R364 VDD.n89 VDD.n88 0.194767
R365 VDD.n76 VDD.n75 0.194767
R366 VDD.n63 VDD.n62 0.194767
R367 VDD.n50 VDD.n49 0.194767
R368 VDD.n37 VDD.n36 0.194767
R369 VDD.n24 VDD.n23 0.194767
R370 VSS.n209 VSS.n208 68998.2
R371 VSS.n209 VSS.t17 63117.1
R372 VSS.n61 VSS.t16 58507.6
R373 VSS.t13 VSS.n6 44679
R374 VSS.t12 VSS.n62 44679
R375 VSS.n111 VSS.n62 32122
R376 VSS.n161 VSS.n6 32122
R377 VSS.n61 VSS.t24 29359.7
R378 VSS.n213 VSS.n210 28983.9
R379 VSS.n210 VSS.t20 22828.4
R380 VSS.n90 VSS.n62 11244.8
R381 VSS.n61 VSS.n6 4108.66
R382 VSS.n62 VSS.n61 4108.66
R383 VSS.n209 VSS.n6 3485.34
R384 VSS.n95 VSS.n72 2885.47
R385 VSS.n91 VSS.n72 2885.47
R386 VSS.n95 VSS.n71 2885.47
R387 VSS.n91 VSS.n71 2885.47
R388 VSS.n202 VSS.n9 2885.47
R389 VSS.n206 VSS.n9 2885.47
R390 VSS.n202 VSS.n8 2885.47
R391 VSS.n206 VSS.n8 2885.47
R392 VSS.n188 VSS.n17 2885.47
R393 VSS.n192 VSS.n17 2885.47
R394 VSS.n188 VSS.n16 2885.47
R395 VSS.n192 VSS.n16 2885.47
R396 VSS.n174 VSS.n26 2885.47
R397 VSS.n170 VSS.n26 2885.47
R398 VSS.n174 VSS.n25 2885.47
R399 VSS.n170 VSS.n25 2885.47
R400 VSS.n24 VSS.n23 2885.47
R401 VSS.n177 VSS.n24 2885.47
R402 VSS.n23 VSS.n21 2885.47
R403 VSS.n177 VSS.n21 2885.47
R404 VSS.n167 VSS.n30 2885.47
R405 VSS.n163 VSS.n30 2885.47
R406 VSS.n167 VSS.n29 2885.47
R407 VSS.n163 VSS.n29 2885.47
R408 VSS.n152 VSS.n38 2885.47
R409 VSS.n148 VSS.n38 2885.47
R410 VSS.n152 VSS.n37 2885.47
R411 VSS.n148 VSS.n37 2885.47
R412 VSS.n159 VSS.n34 2885.47
R413 VSS.n155 VSS.n34 2885.47
R414 VSS.n159 VSS.n33 2885.47
R415 VSS.n155 VSS.n33 2885.47
R416 VSS.n145 VSS.n42 2885.47
R417 VSS.n141 VSS.n42 2885.47
R418 VSS.n145 VSS.n41 2885.47
R419 VSS.n141 VSS.n41 2885.47
R420 VSS.n124 VSS.n54 2885.47
R421 VSS.n120 VSS.n54 2885.47
R422 VSS.n124 VSS.n53 2885.47
R423 VSS.n120 VSS.n53 2885.47
R424 VSS.n131 VSS.n50 2885.47
R425 VSS.n127 VSS.n50 2885.47
R426 VSS.n131 VSS.n49 2885.47
R427 VSS.n127 VSS.n49 2885.47
R428 VSS.n117 VSS.n58 2885.47
R429 VSS.n113 VSS.n58 2885.47
R430 VSS.n117 VSS.n57 2885.47
R431 VSS.n113 VSS.n57 2885.47
R432 VSS.n102 VSS.n68 2885.47
R433 VSS.n98 VSS.n68 2885.47
R434 VSS.n102 VSS.n67 2885.47
R435 VSS.n98 VSS.n67 2885.47
R436 VSS.n109 VSS.n64 2885.47
R437 VSS.n105 VSS.n64 2885.47
R438 VSS.n109 VSS.n63 2885.47
R439 VSS.n105 VSS.n63 2885.47
R440 VSS.n210 VSS.n209 2865.26
R441 VSS.n138 VSS.n46 2595.76
R442 VSS.n134 VSS.n46 2595.76
R443 VSS.n138 VSS.n45 2595.76
R444 VSS.n134 VSS.n45 2595.76
R445 VSS.n195 VSS.n13 2213.35
R446 VSS.n199 VSS.n13 2213.35
R447 VSS.n195 VSS.n12 2213.35
R448 VSS.n199 VSS.n12 2213.35
R449 VSS.n212 VSS.n4 2213.35
R450 VSS.n215 VSS.n4 2213.35
R451 VSS.n212 VSS.n3 2213.35
R452 VSS.n215 VSS.n3 2213.35
R453 VSS.n214 VSS.n5 1484.98
R454 VSS.n194 VSS.n193 1484.98
R455 VSS.n201 VSS.n200 1484.98
R456 VSS.n97 VSS.n96 1446.19
R457 VSS.n119 VSS.n118 1446.19
R458 VSS.n140 VSS.n139 1446.19
R459 VSS.n147 VSS.n146 1446.19
R460 VSS.n169 VSS.n168 1446.19
R461 VSS.n104 VSS.n103 1438.53
R462 VSS.n133 VSS.n132 1438.53
R463 VSS.n126 VSS.n125 1438.53
R464 VSS.n154 VSS.n153 1438.53
R465 VSS.n176 VSS.n175 1438.53
R466 VSS.n112 VSS.n111 726.923
R467 VSS.n162 VSS.n161 726.923
R468 VSS.n208 VSS.n207 722.407
R469 VSS.n111 VSS.n110 719.266
R470 VSS.n161 VSS.n160 719.266
R471 VSS.n208 VSS.n7 719.266
R472 VSS.n96 VSS.t7 312.731
R473 VSS.n90 VSS.t7 312.731
R474 VSS.n118 VSS.t14 312.731
R475 VSS.n112 VSS.t14 312.731
R476 VSS.n146 VSS.t1 312.731
R477 VSS.n140 VSS.t1 312.731
R478 VSS.n168 VSS.t3 312.731
R479 VSS.n162 VSS.t3 312.731
R480 VSS.t22 VSS.n213 299.269
R481 VSS.n214 VSS.t22 299.269
R482 VSS.t18 VSS.n5 299.269
R483 VSS.n193 VSS.t18 299.269
R484 VSS.n194 VSS.t20 299.269
R485 VSS.n200 VSS.t20 299.269
R486 VSS.n201 VSS.t10 299.269
R487 VSS.n207 VSS.t10 299.269
R488 VSS.n71 VSS.t7 292.5
R489 VSS.n73 VSS.n71 292.5
R490 VSS.n72 VSS.t7 292.5
R491 VSS.n93 VSS.n72 292.5
R492 VSS.n63 VSS.t5 292.5
R493 VSS.n65 VSS.n63 292.5
R494 VSS.n64 VSS.t5 292.5
R495 VSS.n107 VSS.n64 292.5
R496 VSS.n67 VSS.t12 292.5
R497 VSS.n69 VSS.n67 292.5
R498 VSS.n68 VSS.t12 292.5
R499 VSS.n100 VSS.n68 292.5
R500 VSS.n57 VSS.t14 292.5
R501 VSS.n59 VSS.n57 292.5
R502 VSS.n58 VSS.t14 292.5
R503 VSS.n115 VSS.n58 292.5
R504 VSS.n49 VSS.t6 292.5
R505 VSS.n51 VSS.n49 292.5
R506 VSS.n50 VSS.t6 292.5
R507 VSS.n129 VSS.n50 292.5
R508 VSS.n45 VSS.t24 292.5
R509 VSS.n47 VSS.n45 292.5
R510 VSS.n46 VSS.t24 292.5
R511 VSS.n136 VSS.n46 292.5
R512 VSS.n53 VSS.t16 292.5
R513 VSS.n55 VSS.n53 292.5
R514 VSS.n54 VSS.t16 292.5
R515 VSS.n122 VSS.n54 292.5
R516 VSS.n41 VSS.t1 292.5
R517 VSS.n43 VSS.n41 292.5
R518 VSS.n42 VSS.t1 292.5
R519 VSS.n143 VSS.n42 292.5
R520 VSS.n33 VSS.t0 292.5
R521 VSS.n35 VSS.n33 292.5
R522 VSS.n34 VSS.t0 292.5
R523 VSS.n157 VSS.n34 292.5
R524 VSS.n37 VSS.t13 292.5
R525 VSS.n39 VSS.n37 292.5
R526 VSS.n38 VSS.t13 292.5
R527 VSS.n150 VSS.n38 292.5
R528 VSS.n29 VSS.t3 292.5
R529 VSS.n31 VSS.n29 292.5
R530 VSS.n30 VSS.t3 292.5
R531 VSS.n165 VSS.n30 292.5
R532 VSS.t9 VSS.n21 292.5
R533 VSS.n21 VSS.n19 292.5
R534 VSS.t9 VSS.n24 292.5
R535 VSS.n24 VSS.n20 292.5
R536 VSS.n25 VSS.t17 292.5
R537 VSS.n27 VSS.n25 292.5
R538 VSS.n26 VSS.t17 292.5
R539 VSS.n172 VSS.n26 292.5
R540 VSS.n16 VSS.t18 292.5
R541 VSS.n187 VSS.n16 292.5
R542 VSS.n17 VSS.t18 292.5
R543 VSS.n190 VSS.n17 292.5
R544 VSS.t22 VSS.n3 292.5
R545 VSS.n3 VSS.n1 292.5
R546 VSS.t22 VSS.n4 292.5
R547 VSS.n4 VSS.n2 292.5
R548 VSS.n8 VSS.t10 292.5
R549 VSS.n11 VSS.n8 292.5
R550 VSS.n9 VSS.t10 292.5
R551 VSS.n204 VSS.n9 292.5
R552 VSS.n12 VSS.t20 292.5
R553 VSS.n15 VSS.n12 292.5
R554 VSS.n13 VSS.t20 292.5
R555 VSS.n197 VSS.n13 292.5
R556 VSS.n110 VSS.t5 289.909
R557 VSS.n104 VSS.t5 289.909
R558 VSS.n103 VSS.t12 289.909
R559 VSS.n97 VSS.t12 289.909
R560 VSS.n139 VSS.t24 289.909
R561 VSS.n133 VSS.t24 289.909
R562 VSS.n132 VSS.t6 289.909
R563 VSS.n126 VSS.t6 289.909
R564 VSS.n125 VSS.t16 289.909
R565 VSS.n119 VSS.t16 289.909
R566 VSS.n160 VSS.t0 289.909
R567 VSS.n154 VSS.t0 289.909
R568 VSS.n153 VSS.t13 289.909
R569 VSS.n147 VSS.t13 289.909
R570 VSS.t9 VSS.n7 289.909
R571 VSS.n176 VSS.t9 289.909
R572 VSS.n175 VSS.t17 289.909
R573 VSS.n169 VSS.t17 289.909
R574 VSS.n93 VSS.n92 187.482
R575 VSS.n94 VSS.n93 187.482
R576 VSS.n204 VSS.n203 187.482
R577 VSS.n205 VSS.n204 187.482
R578 VSS.n190 VSS.n189 187.482
R579 VSS.n191 VSS.n190 187.482
R580 VSS.n173 VSS.n172 187.482
R581 VSS.n172 VSS.n171 187.482
R582 VSS.n22 VSS.n20 187.482
R583 VSS.n178 VSS.n20 187.482
R584 VSS.n166 VSS.n165 187.482
R585 VSS.n165 VSS.n164 187.482
R586 VSS.n151 VSS.n150 187.482
R587 VSS.n150 VSS.n149 187.482
R588 VSS.n158 VSS.n157 187.482
R589 VSS.n157 VSS.n156 187.482
R590 VSS.n144 VSS.n143 187.482
R591 VSS.n143 VSS.n142 187.482
R592 VSS.n123 VSS.n122 187.482
R593 VSS.n122 VSS.n121 187.482
R594 VSS.n130 VSS.n129 187.482
R595 VSS.n129 VSS.n128 187.482
R596 VSS.n116 VSS.n115 187.482
R597 VSS.n115 VSS.n114 187.482
R598 VSS.n101 VSS.n100 187.482
R599 VSS.n100 VSS.n99 187.482
R600 VSS.n108 VSS.n107 187.482
R601 VSS.n107 VSS.n106 187.482
R602 VSS.n94 VSS.n73 186.353
R603 VSS.n203 VSS.n11 186.353
R604 VSS.n189 VSS.n187 186.353
R605 VSS.n173 VSS.n27 186.353
R606 VSS.n22 VSS.n19 186.353
R607 VSS.n166 VSS.n31 186.353
R608 VSS.n151 VSS.n39 186.353
R609 VSS.n158 VSS.n35 186.353
R610 VSS.n144 VSS.n43 186.353
R611 VSS.n123 VSS.n55 186.353
R612 VSS.n130 VSS.n51 186.353
R613 VSS.n116 VSS.n59 186.353
R614 VSS.n101 VSS.n69 186.353
R615 VSS.n108 VSS.n65 186.353
R616 VSS.n137 VSS.n136 168.66
R617 VSS.n136 VSS.n135 168.66
R618 VSS.n137 VSS.n47 167.53
R619 VSS.n197 VSS.n196 143.812
R620 VSS.n198 VSS.n197 143.812
R621 VSS.n211 VSS.n2 143.812
R622 VSS.n216 VSS.n2 143.812
R623 VSS.n196 VSS.n15 142.683
R624 VSS.n211 VSS.n1 142.683
R625 VSS.n219 VSS.t23 127.987
R626 VSS.n184 VSS.t21 127.871
R627 VSS.n92 VSS.n89 126.871
R628 VSS.n205 VSS.n10 126.871
R629 VSS.n191 VSS.n186 126.871
R630 VSS.n171 VSS.n28 126.871
R631 VSS.n179 VSS.n178 126.871
R632 VSS.n164 VSS.n32 126.871
R633 VSS.n149 VSS.n40 126.871
R634 VSS.n156 VSS.n36 126.871
R635 VSS.n142 VSS.n44 126.871
R636 VSS.n121 VSS.n56 126.871
R637 VSS.n128 VSS.n52 126.871
R638 VSS.n114 VSS.n60 126.871
R639 VSS.n99 VSS.n70 126.871
R640 VSS.n106 VSS.n66 126.871
R641 VSS.n89 VSS.n88 125.879
R642 VSS.n181 VSS.n10 125.684
R643 VSS.n186 VSS.n185 125.684
R644 VSS.n28 VSS.n18 125.684
R645 VSS.n180 VSS.n179 125.684
R646 VSS.n75 VSS.n32 125.684
R647 VSS.n77 VSS.n40 125.684
R648 VSS.n76 VSS.n36 125.684
R649 VSS.n79 VSS.n44 125.684
R650 VSS.n83 VSS.n56 125.684
R651 VSS.n82 VSS.n52 125.684
R652 VSS.n85 VSS.n60 125.684
R653 VSS.n87 VSS.n70 125.684
R654 VSS.n86 VSS.n66 125.684
R655 VSS.n81 VSS.n48 125.581
R656 VSS.n183 VSS.n14 125.444
R657 VSS.n218 VSS.n217 125.444
R658 VSS.n215 VSS.n214 117.001
R659 VSS.n216 VSS.n215 117.001
R660 VSS.n213 VSS.n212 117.001
R661 VSS.n212 VSS.n211 117.001
R662 VSS.n200 VSS.n199 117.001
R663 VSS.n199 VSS.n198 117.001
R664 VSS.n195 VSS.n194 117.001
R665 VSS.n196 VSS.n195 117.001
R666 VSS.n135 VSS.n48 108.047
R667 VSS.n134 VSS.n133 83.5719
R668 VSS.n135 VSS.n134 83.5719
R669 VSS.n139 VSS.n138 83.5719
R670 VSS.n138 VSS.n137 83.5719
R671 VSS.n198 VSS.n14 83.2005
R672 VSS.n217 VSS.n216 83.2005
R673 VSS.n91 VSS.n90 73.1255
R674 VSS.n92 VSS.n91 73.1255
R675 VSS.n96 VSS.n95 73.1255
R676 VSS.n95 VSS.n94 73.1255
R677 VSS.n105 VSS.n104 73.1255
R678 VSS.n106 VSS.n105 73.1255
R679 VSS.n110 VSS.n109 73.1255
R680 VSS.n109 VSS.n108 73.1255
R681 VSS.n98 VSS.n97 73.1255
R682 VSS.n99 VSS.n98 73.1255
R683 VSS.n103 VSS.n102 73.1255
R684 VSS.n102 VSS.n101 73.1255
R685 VSS.n113 VSS.n112 73.1255
R686 VSS.n114 VSS.n113 73.1255
R687 VSS.n118 VSS.n117 73.1255
R688 VSS.n117 VSS.n116 73.1255
R689 VSS.n127 VSS.n126 73.1255
R690 VSS.n128 VSS.n127 73.1255
R691 VSS.n132 VSS.n131 73.1255
R692 VSS.n131 VSS.n130 73.1255
R693 VSS.n120 VSS.n119 73.1255
R694 VSS.n121 VSS.n120 73.1255
R695 VSS.n125 VSS.n124 73.1255
R696 VSS.n124 VSS.n123 73.1255
R697 VSS.n141 VSS.n140 73.1255
R698 VSS.n142 VSS.n141 73.1255
R699 VSS.n146 VSS.n145 73.1255
R700 VSS.n145 VSS.n144 73.1255
R701 VSS.n155 VSS.n154 73.1255
R702 VSS.n156 VSS.n155 73.1255
R703 VSS.n160 VSS.n159 73.1255
R704 VSS.n159 VSS.n158 73.1255
R705 VSS.n148 VSS.n147 73.1255
R706 VSS.n149 VSS.n148 73.1255
R707 VSS.n153 VSS.n152 73.1255
R708 VSS.n152 VSS.n151 73.1255
R709 VSS.n163 VSS.n162 73.1255
R710 VSS.n164 VSS.n163 73.1255
R711 VSS.n168 VSS.n167 73.1255
R712 VSS.n167 VSS.n166 73.1255
R713 VSS.n177 VSS.n176 73.1255
R714 VSS.n178 VSS.n177 73.1255
R715 VSS.n23 VSS.n7 73.1255
R716 VSS.n23 VSS.n22 73.1255
R717 VSS.n170 VSS.n169 73.1255
R718 VSS.n171 VSS.n170 73.1255
R719 VSS.n175 VSS.n174 73.1255
R720 VSS.n174 VSS.n173 73.1255
R721 VSS.n193 VSS.n192 73.1255
R722 VSS.n192 VSS.n191 73.1255
R723 VSS.n188 VSS.n5 73.1255
R724 VSS.n189 VSS.n188 73.1255
R725 VSS.n207 VSS.n206 73.1255
R726 VSS.n206 VSS.n205 73.1255
R727 VSS.n202 VSS.n201 73.1255
R728 VSS.n203 VSS.n202 73.1255
R729 VSS.n80 VSS.t25 70.1732
R730 VSS.n88 VSS.t8 51.3891
R731 VSS.n84 VSS.t15 51.3891
R732 VSS.n78 VSS.t2 51.3891
R733 VSS.n74 VSS.t4 51.3891
R734 VSS.n182 VSS.t11 51.3891
R735 VSS.n0 VSS.t19 51.3891
R736 VSS.n89 VSS.n73 50.5605
R737 VSS.n15 VSS.n14 50.5605
R738 VSS.n11 VSS.n10 50.5605
R739 VSS.n217 VSS.n1 50.5605
R740 VSS.n187 VSS.n186 50.5605
R741 VSS.n28 VSS.n27 50.5605
R742 VSS.n179 VSS.n19 50.5605
R743 VSS.n32 VSS.n31 50.5605
R744 VSS.n40 VSS.n39 50.5605
R745 VSS.n36 VSS.n35 50.5605
R746 VSS.n44 VSS.n43 50.5605
R747 VSS.n56 VSS.n55 50.5605
R748 VSS.n48 VSS.n47 50.5605
R749 VSS.n52 VSS.n51 50.5605
R750 VSS.n60 VSS.n59 50.5605
R751 VSS.n70 VSS.n69 50.5605
R752 VSS.n66 VSS.n65 50.5605
R753 VSS VSS.n219 1.03372
R754 VSS.n181 VSS.n180 0.852767
R755 VSS.n180 VSS.n18 0.852767
R756 VSS.n76 VSS.n75 0.852767
R757 VSS.n77 VSS.n76 0.852767
R758 VSS.n82 VSS.n81 0.852767
R759 VSS.n83 VSS.n82 0.852767
R760 VSS.n86 VSS.n85 0.852767
R761 VSS.n87 VSS.n86 0.852767
R762 VSS.n218 VSS.n0 0.6491
R763 VSS.n185 VSS.n184 0.6491
R764 VSS.n183 VSS.n182 0.6491
R765 VSS.n74 VSS.n18 0.6491
R766 VSS.n78 VSS.n77 0.6491
R767 VSS.n80 VSS.n79 0.6491
R768 VSS.n84 VSS.n83 0.6491
R769 VSS.n88 VSS.n87 0.6491
R770 VSS.n219 VSS.n218 0.194767
R771 VSS.n185 VSS.n0 0.194767
R772 VSS.n184 VSS.n183 0.194767
R773 VSS.n182 VSS.n181 0.194767
R774 VSS.n75 VSS.n74 0.194767
R775 VSS.n79 VSS.n78 0.194767
R776 VSS.n81 VSS.n80 0.194767
R777 VSS.n85 VSS.n84 0.194767
R778 net4.n0 net4.t0 43.6291
R779 net4.n0 net4.t1 42.0666
R780 net4 net4.n0 14.7632
R781 net3.n0 net3.t0 43.6291
R782 net3.n0 net3.t1 42.0666
R783 net3 net3.n0 14.7632
R784 net2.n0 net2.t0 43.6291
R785 net2.n0 net2.t1 42.0666
R786 net2 net2.n0 14.7632
R787 EVAL_GND.n1 EVAL_GND.t4 70.7982
R788 EVAL_GND.n0 EVAL_GND.t0 54.5897
R789 EVAL_GND.n0 EVAL_GND.t2 52.0141
R790 EVAL_GND.n2 EVAL_GND.t1 52.0141
R791 EVAL_GND EVAL_GND.t3 52.0141
R792 EVAL_GND EVAL_GND.n2 2.5761
R793 EVAL_GND.n1 EVAL_GND.n0 2.18443
R794 EVAL_GND.n2 EVAL_GND.n1 1.24443
R795 net1.n0 net1.t0 43.6291
R796 net1.n0 net1.t1 42.0666
R797 net1 net1.n0 14.7632
R798 N3.n1 N3.t1 674.131
R799 N3.n0 N3.t4 366.336
R800 N3.n0 N3.t3 282.827
R801 N3.n2 N3.t2 226.13
R802 N3.n2 N3.t0 50.6916
R803 N3 N3.n2 5.448
R804 N3.n1 N3.n0 1.26402
R805 N3 N3.n1 0.559017
R806 N2.n1 N2.t1 674.131
R807 N2.n0 N2.t4 366.336
R808 N2.n0 N2.t3 282.827
R809 N2.n2 N2.t2 226.13
R810 N2.n2 N2.t0 50.6916
R811 N2 N2.n2 5.448
R812 N2.n1 N2.n0 1.26402
R813 N2 N2.n1 0.559017
R814 N1.n1 N1.t1 674.131
R815 N1.n0 N1.t4 366.336
R816 N1.n0 N1.t3 282.827
R817 N1.n2 N1.t2 226.13
R818 N1.n2 N1.t0 50.6916
R819 N1 N1.n2 5.448
R820 N1.n1 N1.n0 1.26402
R821 N1 N1.n1 0.559017
R822 N0.n1 N0.t1 674.131
R823 N0.n0 N0.t4 366.336
R824 N0.n0 N0.t3 282.827
R825 N0.n2 N0.t2 226.13
R826 N0.n2 N0.t0 50.6916
R827 N0 N0.n2 5.448
R828 N0.n1 N0.n0 1.26402
R829 N0 N0.n1 0.559017
R830 A1T.n0 A1T.t2 292.902
R831 A1T.n0 A1T.t3 290.327
R832 A1T.n1 A1T.t1 118.816
R833 A1T.n1 A1T.t0 50.6916
R834 A1T A1T.n1 12.948
R835 A1T A1T.n0 7.00193
R836 A1B.n3 A1B.t0 336.339
R837 A1B.n1 A1B.t5 290.88
R838 A1B.n0 A1B.t2 290.402
R839 A1B.n0 A1B.t3 287.827
R840 A1B.n2 A1B.t4 287.827
R841 A1B.n3 A1B.t1 127.172
R842 A1B A1B.n3 10.448
R843 A1B A1B.n2 0.970267
R844 A1B.n1 A1B.n0 0.617767
R845 A1B.n2 A1B.n1 0.2261
R846 A0T.n0 A0T.t2 295.099
R847 A0T.n0 A0T.t3 289.077
R848 A0T.n1 A0T.t0 118.816
R849 A0T.n1 A0T.t1 50.6916
R850 A0T A0T.n1 11.698
R851 A0T A0T.n0 6.14027
R852 A0B.n3 A0B.t0 336.339
R853 A0B.n0 A0B.t2 292.599
R854 A0B.n1 A0B.t5 289.63
R855 A0B.n0 A0B.t3 286.577
R856 A0B.n2 A0B.t4 286.577
R857 A0B.n3 A0B.t1 127.172
R858 A0B A0B.n3 9.198
R859 A0B.n1 A0B.n0 3.20277
R860 A0B A0B.n2 0.970267
R861 A0B.n2 A0B.n1 0.2261
C0 N2 EVAL_GND 0.1466f
C1 m1_160_n1740# DEC1 0
C2 A0B A0T 1.32151f
C3 PCLK N1 0.20559f
C4 A0T m1_160_n1740# 4.21801f
C5 A0B PCLK 0.38071f
C6 m1_160_n1740# PCLK 1.93989f
C7 N2 DEC2 1.1142f
C8 net4 A0T 0.76077f
C9 N2 VDD 2.18951f
C10 A0B net3 0.76081f
C11 net1 PCLK 0.02866f
C12 PCLK N0 0.17033f
C13 net4 PCLK 0.02047f
C14 A0B A1T 0.13727f
C15 m1_160_n1740# net3 0
C16 A1B N1 0.8394f
C17 A1B A0B 0.44394f
C18 m1_160_n1740# A1T 2.19149f
C19 A1B m1_160_n1740# 1.94209f
C20 A1 A0 0.21908f
C21 N0 A1T 0
C22 net4 A1T 0.09048f
C23 EVAL_GND DEC2 0.11466f
C24 A1B net1 0.09048f
C25 m1_160_n1740# DEC3 0.06915f
C26 A1B N0 0.90234f
C27 EVAL_GND VDD 0.15173f
C28 N2 PCLK 0.24333f
C29 EVAL_GND DEC0 0.11185f
C30 net2 EVAL_GND 0.24542f
C31 net4 DEC3 0.00278f
C32 A1 A0B 0.15515f
C33 N2 net3 0.34553f
C34 EVAL_GND DEC1 0.11468f
C35 A1 m1_160_n1740# 0.00456f
C36 N2 A1T 0.84496f
C37 DEC2 VDD 1.37756f
C38 A0T EVAL_GND 0.36987f
C39 DEC0 VDD 1.37756f
C40 net2 VDD 0.12561f
C41 EVAL_GND PCLK 0.43002f
C42 N3 m1_160_n1740# 0.01916f
C43 DEC1 VDD 1.37836f
C44 A0T DEC2 0
C45 DEC1 DEC0 0.00138f
C46 EVAL_GND net3 0.24542f
C47 net4 N3 0.34553f
C48 net2 DEC1 0.00278f
C49 A0T VDD 0.76659f
C50 A0T DEC0 0
C51 EVAL_GND A1T 0.13715f
C52 PCLK DEC2 0.10739f
C53 net2 A0T 0.76077f
C54 PCLK VDD 3.24504f
C55 A1B EVAL_GND 0.06861f
C56 PCLK DEC0 0.10739f
C57 A0T DEC1 0.18819f
C58 net2 PCLK 0.02866f
C59 net3 DEC2 0.00278f
C60 EVAL_GND DEC3 0.04702f
C61 net3 VDD 0.12553f
C62 N3 N2 0.0626f
C63 PCLK DEC1 0.12538f
C64 DEC2 A1T 0.01853f
C65 A1T VDD 0.80047f
C66 A0B A0 0.51553f
C67 A0T PCLK 0.18465f
C68 A1B VDD 1.6531f
C69 A0 m1_160_n1740# 0.00794f
C70 DEC3 DEC2 0.00138f
C71 A1B DEC0 0.01853f
C72 A1B net2 0.09048f
C73 DEC3 VDD 1.37595f
C74 DEC1 A1T 0
C75 A1B DEC1 0
C76 A0T A1T 0.23554f
C77 m1_160_n1740# N1 0
C78 net3 PCLK 0.0287f
C79 N3 EVAL_GND 0.07171f
C80 A0B m1_160_n1740# 3.54674f
C81 A1B A0T 0.04768f
C82 N0 N1 0.0626f
C83 PCLK A1T 0.66526f
C84 A1 VDD 0.78278f
C85 A0B net1 0.76081f
C86 A0B N0 0.12066f
C87 A0T DEC3 0.18819f
C88 A1B PCLK 0.76415f
C89 net1 m1_160_n1740# 0
C90 m1_160_n1740# N0 0
C91 net3 A1T 0.09048f
C92 net4 m1_160_n1740# 0.00615f
C93 N3 DEC2 0.0012f
C94 DEC3 PCLK 0
C95 net1 N0 0.34553f
C96 N3 VDD 2.25806f
C97 A1 A0T 0.0717f
C98 A1B A1T 1.37238f
C99 N2 A0B 0.12066f
C100 DEC3 A1T 0
C101 N2 m1_160_n1740# 0
C102 N3 A0T 0.12094f
C103 N3 PCLK 0.14554f
C104 A1 A1T 0.05911f
C105 A1 A1B 0.55817f
C106 EVAL_GND N1 0.16377f
C107 A0B EVAL_GND 0.30343f
C108 A0 VDD 0.5738f
C109 N3 A1T 0.8394f
C110 net1 EVAL_GND 0.17565f
C111 EVAL_GND N0 0.0757f
C112 net4 EVAL_GND 0.24542f
C113 N3 DEC3 1.1142f
C114 N1 VDD 2.25806f
C115 A0B DEC2 0.18819f
C116 A0B VDD 1.54473f
C117 N1 DEC0 0.0012f
C118 net2 N1 0.34553f
C119 m1_160_n1740# DEC2 0
C120 A0B DEC0 0.18831f
C121 A0 A0T 0.06275f
C122 A0B net2 0
C123 m1_160_n1740# VDD 0.06508f
C124 DEC1 N1 1.1142f
C125 m1_160_n1740# DEC0 0
C126 net2 m1_160_n1740# 0
C127 net1 VDD 0.1256f
C128 N0 VDD 2.26434f
C129 A0B DEC1 0
C130 net4 VDD 0.12561f
C131 net1 DEC0 0.00278f
C132 A0T N1 0.12066f
C133 N0 DEC0 1.1142f
C134 DEC3 VSS 2.15591f
C135 DEC2 VSS 2.0666f
C136 DEC1 VSS 2.0675f
C137 DEC0 VSS 2.06646f
C138 PCLK VSS 7.01349f
C139 A1 VSS 2.27951f
C140 A0 VSS 1.55459f
C141 VDD VSS 31.95997f
C142 m1_160_n1740# VSS 13.3158f ; **FLOATING
C143 net4 VSS 1.88343f
C144 net3 VSS 1.88023f
C145 net2 VSS 1.88023f
C146 EVAL_GND VSS 7.50715f
C147 net1 VSS 1.85704f
C148 N3 VSS 3.25895f
C149 N2 VSS 3.17607f
C150 N1 VSS 3.11884f
C151 N0 VSS 3.09379f
C152 A1T VSS 10.71553f
C153 A1B VSS 7.67094f
C154 A0T VSS 8.27891f
C155 A0B VSS 7.72587f
C156 A0B.n0 VSS 5.23799f
C157 A0B.n1 VSS 1.49807f
C158 A0B.n2 VSS 1.61438f
C159 A0B.t1 VSS 0.08069f
C160 A0B.t0 VSS 0.06537f
C161 A0B.n3 VSS 1.22619f
C162 A0T.n0 VSS 6.10841f
C163 A0T.t1 VSS 0.18728f
C164 A0T.t0 VSS 0.1314f
C165 A0T.n1 VSS 1.47206f
C166 A1B.n0 VSS 3.81638f
C167 A1B.n1 VSS 1.16091f
C168 A1B.n2 VSS 1.65667f
C169 A1B.t1 VSS 0.07793f
C170 A1B.t0 VSS 0.06069f
C171 A1B.n3 VSS 1.23516f
C172 A1T.n0 VSS 4.5294f
C173 A1T.t0 VSS 0.1643f
C174 A1T.t1 VSS 0.1158f
C175 A1T.n1 VSS 1.28107f
C176 N0.n0 VSS 2.25518f
C177 N0.t1 VSS 0.06068f
C178 N0.n1 VSS 0.89166f
C179 N0.t0 VSS 0.22395f
C180 N0.t2 VSS 0.1051f
C181 N0.n2 VSS 1.25681f
C182 N1.n0 VSS 2.27981f
C183 N1.t1 VSS 0.06102f
C184 N1.n1 VSS 0.9014f
C185 N1.t0 VSS 0.23418f
C186 N1.t2 VSS 0.10589f
C187 N1.n2 VSS 1.27053f
C188 N2.n0 VSS 2.26035f
C189 N2.t1 VSS 0.06078f
C190 N2.n1 VSS 0.8937f
C191 N2.t0 VSS 0.22441f
C192 N2.t2 VSS 0.10526f
C193 N2.n2 VSS 1.25969f
C194 N3.n0 VSS 2.22056f
C195 N3.t1 VSS 0.05888f
C196 N3.n1 VSS 0.87797f
C197 N3.t0 VSS 0.22937f
C198 N3.t2 VSS 0.11065f
C199 N3.n2 VSS 1.23752f
C200 net1.t1 VSS 0.1338f
C201 net1.t0 VSS 0.14275f
C202 net1.n0 VSS 0.84228f
C203 EVAL_GND.t0 VSS 0.19099f
C204 EVAL_GND.t2 VSS 0.1588f
C205 EVAL_GND.n0 VSS 1.15053f
C206 EVAL_GND.t4 VSS 0.10567f
C207 EVAL_GND.n1 VSS 0.55296f
C208 EVAL_GND.t1 VSS 0.14118f
C209 EVAL_GND.n2 VSS 0.59687f
C210 EVAL_GND.t3 VSS 0.13415f
C211 net2.t1 VSS 0.14473f
C212 net2.t0 VSS 0.15533f
C213 net2.n0 VSS 0.8807f
C214 net3.t1 VSS 0.16235f
C215 net3.t0 VSS 0.14706f
C216 net3.n0 VSS 0.88068f
C217 net4.t1 VSS 0.17126f
C218 net4.t0 VSS 0.15498f
C219 net4.n0 VSS 0.87952f
C220 VSS.t19 VSS 0.04832f
C221 VSS.t4 VSS 0.04635f
C222 VSS.t2 VSS 0.04685f
C223 VSS.t25 VSS 0.04468f
C224 VSS.t15 VSS 0.04645f
C225 VSS.t8 VSS 0.04564f
C226 VSS.t11 VSS 0.04944f
C227 VSS.t21 VSS 0.02764f
C228 VSS.t23 VSS 0.02739f
C229 VDD.n0 VSS 0.04032f
C230 VDD.n1 VSS 0.04666f
C231 VDD.t8 VSS 0.43011f
C232 VDD.n3 VSS 0.32094f
C233 VDD.n4 VSS 0.04801f
C234 VDD.n5 VSS 0.04801f
C235 VDD.n7 VSS 0.32094f
C236 VDD.n8 VSS 0.04801f
C237 VDD.n9 VSS 0.03144f
C238 VDD.n10 VSS 0.0457f
C239 VDD.t9 VSS 0.13384f
C240 VDD.n11 VSS 0.44763f
C241 VDD.n12 VSS 0.02098f
C242 VDD.n13 VSS 0.02757f
C243 VDD.t20 VSS 0.22688f
C244 VDD.n15 VSS 0.16026f
C245 VDD.n16 VSS 0.02792f
C246 VDD.n17 VSS 0.02792f
C247 VDD.n19 VSS 0.16026f
C248 VDD.n20 VSS 0.02792f
C249 VDD.n21 VSS 0.02139f
C250 VDD.n22 VSS 0.03708f
C251 VDD.n23 VSS 0.20496f
C252 VDD.t21 VSS 0.04245f
C253 VDD.n24 VSS 0.23504f
C254 VDD.n25 VSS 0.02717f
C255 VDD.n26 VSS 0.03364f
C256 VDD.t24 VSS 0.29305f
C257 VDD.n28 VSS 0.21149f
C258 VDD.n29 VSS 0.03445f
C259 VDD.n30 VSS 0.03445f
C260 VDD.n32 VSS 0.21149f
C261 VDD.n33 VSS 0.03445f
C262 VDD.n34 VSS 0.02466f
C263 VDD.n35 VSS 0.03977f
C264 VDD.n36 VSS 0.19429f
C265 VDD.t25 VSS 0.07465f
C266 VDD.n37 VSS 0.26222f
C267 VDD.n38 VSS 0.04032f
C268 VDD.n39 VSS 0.04666f
C269 VDD.t10 VSS 0.43011f
C270 VDD.n41 VSS 0.32094f
C271 VDD.n42 VSS 0.04801f
C272 VDD.n43 VSS 0.04801f
C273 VDD.n45 VSS 0.32094f
C274 VDD.n46 VSS 0.04801f
C275 VDD.n47 VSS 0.03144f
C276 VDD.n48 VSS 0.04549f
C277 VDD.n49 VSS 0.17176f
C278 VDD.t11 VSS 0.13459f
C279 VDD.n50 VSS 0.31361f
C280 VDD.n51 VSS 0.02098f
C281 VDD.n52 VSS 0.02757f
C282 VDD.t12 VSS 0.22688f
C283 VDD.n54 VSS 0.16026f
C284 VDD.n55 VSS 0.02792f
C285 VDD.n56 VSS 0.02792f
C286 VDD.n58 VSS 0.16026f
C287 VDD.n59 VSS 0.02792f
C288 VDD.n60 VSS 0.02139f
C289 VDD.n61 VSS 0.03708f
C290 VDD.n62 VSS 0.20496f
C291 VDD.t13 VSS 0.04385f
C292 VDD.n63 VSS 0.23504f
C293 VDD.n64 VSS 0.02717f
C294 VDD.n65 VSS 0.03364f
C295 VDD.t26 VSS 0.29305f
C296 VDD.n67 VSS 0.21149f
C297 VDD.n68 VSS 0.03445f
C298 VDD.n69 VSS 0.03445f
C299 VDD.n71 VSS 0.21149f
C300 VDD.n72 VSS 0.03445f
C301 VDD.n73 VSS 0.02466f
C302 VDD.n74 VSS 0.03977f
C303 VDD.n75 VSS 0.19429f
C304 VDD.t27 VSS 0.06798f
C305 VDD.n76 VSS 0.33593f
C306 VDD.n77 VSS 0.04032f
C307 VDD.n78 VSS 0.04666f
C308 VDD.t2 VSS 0.43011f
C309 VDD.n80 VSS 0.32094f
C310 VDD.n81 VSS 0.04801f
C311 VDD.n82 VSS 0.04801f
C312 VDD.n84 VSS 0.32094f
C313 VDD.n85 VSS 0.04801f
C314 VDD.n86 VSS 0.03144f
C315 VDD.n87 VSS 0.04549f
C316 VDD.n88 VSS 0.24548f
C317 VDD.t3 VSS 0.13496f
C318 VDD.n89 VSS 0.31361f
C319 VDD.n90 VSS 0.02098f
C320 VDD.n91 VSS 0.02757f
C321 VDD.t22 VSS 0.22688f
C322 VDD.n93 VSS 0.16026f
C323 VDD.n94 VSS 0.02792f
C324 VDD.n95 VSS 0.02792f
C325 VDD.n97 VSS 0.16026f
C326 VDD.n98 VSS 0.02792f
C327 VDD.n99 VSS 0.02139f
C328 VDD.n100 VSS 0.03708f
C329 VDD.n101 VSS 0.20496f
C330 VDD.t23 VSS 0.04385f
C331 VDD.n102 VSS 0.23504f
C332 VDD.n103 VSS 0.02717f
C333 VDD.n104 VSS 0.03364f
C334 VDD.t28 VSS 0.29305f
C335 VDD.n106 VSS 0.21149f
C336 VDD.n107 VSS 0.03445f
C337 VDD.n108 VSS 0.03445f
C338 VDD.n110 VSS 0.21149f
C339 VDD.n111 VSS 0.03445f
C340 VDD.n112 VSS 0.02466f
C341 VDD.n113 VSS 0.03977f
C342 VDD.n114 VSS 0.19429f
C343 VDD.t29 VSS 0.06798f
C344 VDD.n115 VSS 0.26222f
C345 VDD.n116 VSS 0.04032f
C346 VDD.n117 VSS 0.04666f
C347 VDD.t4 VSS 0.43011f
C348 VDD.n119 VSS 0.32094f
C349 VDD.n120 VSS 0.04801f
C350 VDD.n121 VSS 0.04801f
C351 VDD.n123 VSS 0.32094f
C352 VDD.n124 VSS 0.04801f
C353 VDD.n125 VSS 0.03144f
C354 VDD.n126 VSS 0.04549f
C355 VDD.n127 VSS 0.17176f
C356 VDD.t5 VSS 0.13449f
C357 VDD.n128 VSS 0.31361f
C358 VDD.n129 VSS 0.02098f
C359 VDD.n130 VSS 0.02757f
C360 VDD.t14 VSS 0.22688f
C361 VDD.n132 VSS 0.16026f
C362 VDD.n133 VSS 0.02792f
C363 VDD.n134 VSS 0.02792f
C364 VDD.n136 VSS 0.16026f
C365 VDD.n137 VSS 0.02792f
C366 VDD.n138 VSS 0.02139f
C367 VDD.n139 VSS 0.03708f
C368 VDD.n140 VSS 0.20496f
C369 VDD.t15 VSS 0.04382f
C370 VDD.n141 VSS 0.23504f
C371 VDD.n142 VSS 0.02717f
C372 VDD.n143 VSS 0.03364f
C373 VDD.t30 VSS 0.29305f
C374 VDD.n145 VSS 0.21149f
C375 VDD.n146 VSS 0.03445f
C376 VDD.n147 VSS 0.03445f
C377 VDD.n149 VSS 0.21149f
C378 VDD.n150 VSS 0.03445f
C379 VDD.n151 VSS 0.02466f
C380 VDD.n152 VSS 0.03977f
C381 VDD.n153 VSS 0.19429f
C382 VDD.t31 VSS 0.06798f
C383 VDD.n154 VSS 0.26222f
C384 VDD.n155 VSS 0.03279f
C385 VDD.n156 VSS 0.0392f
C386 VDD.t6 VSS 0.35226f
C387 VDD.n158 VSS 0.25814f
C388 VDD.n159 VSS 0.04028f
C389 VDD.n160 VSS 0.04028f
C390 VDD.n162 VSS 0.25814f
C391 VDD.n163 VSS 0.04028f
C392 VDD.n164 VSS 0.02758f
C393 VDD.n165 VSS 0.04222f
C394 VDD.n166 VSS 0.18464f
C395 VDD.t7 VSS 0.09764f
C396 VDD.n167 VSS 0.28417f
C397 VDD.n168 VSS 0.0241f
C398 VDD.n169 VSS 0.03063f
C399 VDD.t16 VSS 0.26032f
C400 VDD.n171 VSS 0.1862f
C401 VDD.n172 VSS 0.03123f
C402 VDD.n173 VSS 0.03123f
C403 VDD.n175 VSS 0.1862f
C404 VDD.n176 VSS 0.03123f
C405 VDD.n177 VSS 0.02305f
C406 VDD.n178 VSS 0.03844f
C407 VDD.n179 VSS 0.19956f
C408 VDD.t17 VSS 0.04693f
C409 VDD.n180 VSS 0.249f
C410 VDD.n181 VSS 0.03279f
C411 VDD.n182 VSS 0.0392f
C412 VDD.t0 VSS 0.35226f
C413 VDD.n184 VSS 0.25814f
C414 VDD.n185 VSS 0.04028f
C415 VDD.n186 VSS 0.04028f
C416 VDD.n188 VSS 0.25814f
C417 VDD.n189 VSS 0.04028f
C418 VDD.n190 VSS 0.02758f
C419 VDD.n191 VSS 0.04222f
C420 VDD.n192 VSS 0.18464f
C421 VDD.t1 VSS 0.09688f
C422 VDD.n193 VSS 0.28417f
C423 VDD.n194 VSS 0.0241f
C424 VDD.n195 VSS 0.03063f
C425 VDD.t18 VSS 0.26032f
C426 VDD.n197 VSS 0.1862f
C427 VDD.n198 VSS 0.03123f
C428 VDD.n199 VSS 0.03123f
C429 VDD.n201 VSS 0.1862f
C430 VDD.n202 VSS 0.03123f
C431 VDD.n203 VSS 0.02305f
C432 VDD.n204 VSS 0.03844f
C433 VDD.n205 VSS 0.19956f
C434 VDD.t19 VSS 0.04938f
C435 VDD.n206 VSS 0.28189f
C436 A0.n0 VSS 1.15263f
C437 A1.n0 VSS 1.36641f
C438 PCLK.n0 VSS 2.5353f
C439 PCLK.n1 VSS 1.79715f
C440 PCLK.n2 VSS 1.55267f
C441 PCLK.n3 VSS 1.8734f
C442 DEC0.t0 VSS 0.19936f
C443 DEC0.t1 VSS 0.20226f
C444 DEC0.n0 VSS 1.3244f
C445 DEC0.n1 VSS 1.06931f
C446 DEC1.t0 VSS 0.19997f
C447 DEC1.t1 VSS 0.20283f
C448 DEC1.n0 VSS 1.3253f
C449 DEC1.n1 VSS 1.07004f
C450 DEC2.t0 VSS 0.19961f
C451 DEC2.t1 VSS 0.2025f
C452 DEC2.n0 VSS 1.32562f
C453 DEC2.n1 VSS 1.07029f
C454 DEC3.t0 VSS 0.19215f
C455 DEC3.t1 VSS 0.19482f
C456 DEC3.n0 VSS 1.26812f
C457 DEC3.n1 VSS 1.02387f
.ends
