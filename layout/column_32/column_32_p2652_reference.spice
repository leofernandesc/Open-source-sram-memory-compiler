* NGSPICE file created from bitcell_6t_flat.ext - technology: sky130A

.subckt bitcell_6t_flat VDD BL BLB VSS WL
X0 a_167_n2114# a_215_n2026# VDD VDD sky130_fd_pr__pfet_01v8 ad=0.1218 pd=1.42 as=0.1218 ps=1.42 w=0.42 l=0.15
X1 a_215_n2026# WL BL VSS sky130_fd_pr__nfet_01v8 ad=0.174 pd=1.78 as=0.174 ps=1.78 w=0.6 l=0.15
X2 a_167_n2114# a_215_n2026# VSS VSS sky130_fd_pr__nfet_01v8 ad=0.3654 pd=3.1 as=0.3654 ps=3.1 w=1.26 l=0.15
X3 a_215_n2026# a_167_n2114# VDD VDD sky130_fd_pr__pfet_01v8 ad=0.1218 pd=1.42 as=0.1218 ps=1.42 w=0.42 l=0.15
X4 a_167_n2114# WL BLB VSS sky130_fd_pr__nfet_01v8 ad=0.174 pd=1.78 as=0.174 ps=1.78 w=0.6 l=0.15
X5 a_215_n2026# a_167_n2114# VSS VSS sky130_fd_pr__nfet_01v8 ad=0.3654 pd=3.1 as=0.3654 ps=3.1 w=1.26 l=0.15
.ends

.subckt column_32_p2652_reference BL BLB VSS VDD WLOFF
XBC00 VDD BL BLB VSS WLOFF bitcell_6t_flat
XBC01 VDD BL BLB VSS WLOFF bitcell_6t_flat
XBC02 VDD BL BLB VSS WLOFF bitcell_6t_flat
XBC03 VDD BL BLB VSS WLOFF bitcell_6t_flat
XBC04 VDD BL BLB VSS WLOFF bitcell_6t_flat
XBC05 VDD BL BLB VSS WLOFF bitcell_6t_flat
XBC06 VDD BL BLB VSS WLOFF bitcell_6t_flat
XBC07 VDD BL BLB VSS WLOFF bitcell_6t_flat
XBC08 VDD BL BLB VSS WLOFF bitcell_6t_flat
XBC09 VDD BL BLB VSS WLOFF bitcell_6t_flat
XBC10 VDD BL BLB VSS WLOFF bitcell_6t_flat
XBC11 VDD BL BLB VSS WLOFF bitcell_6t_flat
XBC12 VDD BL BLB VSS WLOFF bitcell_6t_flat
XBC13 VDD BL BLB VSS WLOFF bitcell_6t_flat
XBC14 VDD BL BLB VSS WLOFF bitcell_6t_flat
XBC15 VDD BL BLB VSS WLOFF bitcell_6t_flat
XBC16 VDD BL BLB VSS WLOFF bitcell_6t_flat
XBC17 VDD BL BLB VSS WLOFF bitcell_6t_flat
XBC18 VDD BL BLB VSS WLOFF bitcell_6t_flat
XBC19 VDD BL BLB VSS WLOFF bitcell_6t_flat
XBC20 VDD BL BLB VSS WLOFF bitcell_6t_flat
XBC21 VDD BL BLB VSS WLOFF bitcell_6t_flat
XBC22 VDD BL BLB VSS WLOFF bitcell_6t_flat
XBC23 VDD BL BLB VSS WLOFF bitcell_6t_flat
XBC24 VDD BL BLB VSS WLOFF bitcell_6t_flat
XBC25 VDD BL BLB VSS WLOFF bitcell_6t_flat
XBC26 VDD BL BLB VSS WLOFF bitcell_6t_flat
XBC27 VDD BL BLB VSS WLOFF bitcell_6t_flat
XBC28 VDD BL BLB VSS WLOFF bitcell_6t_flat
XBC29 VDD BL BLB VSS WLOFF bitcell_6t_flat
XBC30 VDD BL BLB VSS WLOFF bitcell_6t_flat
XBC31 VDD BL BLB VSS WLOFF bitcell_6t_flat
.ends column_32_p2652_reference
