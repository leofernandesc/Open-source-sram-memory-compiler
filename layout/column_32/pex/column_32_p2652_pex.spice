* NGSPICE file created from column_32_p2652_flat.ext - technology: sky130A

.subckt column_32_p2652_flat BL BLB VSS VDD WLOFF
X0 a_665_56608.t2 WLOFF.t43 BL.t23 VSS.t148 sky130_fd_pr__nfet_01v8 ad=0.174 pd=1.78 as=0.174 ps=1.78 w=0.6 l=0.15
X1 a_617_45912.t2 WLOFF.t34 BLB.t13 VSS.t157 sky130_fd_pr__nfet_01v8 ad=0.174 pd=1.78 as=0.174 ps=1.78 w=0.6 l=0.15
X2 a_665_72520.t0 a_617_72432.t4 VDD.t7 VDD.t6 sky130_fd_pr__pfet_01v8 ad=0.1218 pd=1.42 as=0.1218 ps=1.42 w=0.42 l=0.15
X3 a_617_45912.t1 a_665_46000.t3 VSS.t95 VSS.t94 sky130_fd_pr__nfet_01v8 ad=0.3654 pd=3.1 as=0.3654 ps=3.1 w=1.26 l=0.15
X4 a_665_916.t1 a_617_828.t4 VDD.t119 VDD.t118 sky130_fd_pr__pfet_01v8 ad=0.1218 pd=1.42 as=0.1218 ps=1.42 w=0.42 l=0.15
X5 a_665_30088.t2 WLOFF.t23 BL.t29 VSS.t168 sky130_fd_pr__nfet_01v8 ad=0.174 pd=1.78 as=0.174 ps=1.78 w=0.6 l=0.15
X6 a_617_53868.t1 a_665_53956.t3 VSS.t31 VSS.t30 sky130_fd_pr__nfet_01v8 ad=0.3654 pd=3.1 as=0.3654 ps=3.1 w=1.26 l=0.15
X7 a_617_61824.t0 a_665_61912.t4 VDD.t57 VDD.t56 sky130_fd_pr__pfet_01v8 ad=0.1218 pd=1.42 as=0.1218 ps=1.42 w=0.42 l=0.15
X8 a_665_59260.t2 WLOFF.t45 BL.t24 VSS.t146 sky130_fd_pr__nfet_01v8 ad=0.174 pd=1.78 as=0.174 ps=1.78 w=0.6 l=0.15
X9 a_665_30088.t0 a_617_30000.t3 VSS.t27 VSS.t26 sky130_fd_pr__nfet_01v8 ad=0.3654 pd=3.1 as=0.3654 ps=3.1 w=1.26 l=0.15
X10 a_617_56520.t1 a_665_56608.t3 VSS.t39 VSS.t38 sky130_fd_pr__nfet_01v8 ad=0.3654 pd=3.1 as=0.3654 ps=3.1 w=1.26 l=0.15
X11 a_665_16828.t2 WLOFF.t13 BL.t1 VSS.t178 sky130_fd_pr__nfet_01v8 ad=0.174 pd=1.78 as=0.174 ps=1.78 w=0.6 l=0.15
X12 a_617_16740.t0 a_665_16828.t4 VDD.t37 VDD.t36 sky130_fd_pr__pfet_01v8 ad=0.1218 pd=1.42 as=0.1218 ps=1.42 w=0.42 l=0.15
X13 a_617_64476.t0 a_665_64564.t4 VDD.t9 VDD.t8 sky130_fd_pr__pfet_01v8 ad=0.1218 pd=1.42 as=0.1218 ps=1.42 w=0.42 l=0.15
X14 a_665_32740.t1 a_617_32652.t4 VDD.t17 VDD.t16 sky130_fd_pr__pfet_01v8 ad=0.1218 pd=1.42 as=0.1218 ps=1.42 w=0.42 l=0.15
X15 a_617_77736.t2 WLOFF.t58 BLB.t4 VSS.t133 sky130_fd_pr__nfet_01v8 ad=0.174 pd=1.78 as=0.174 ps=1.78 w=0.6 l=0.15
X16 a_665_56608.t1 a_617_56520.t4 VDD.t51 VDD.t50 sky130_fd_pr__pfet_01v8 ad=0.1218 pd=1.42 as=0.1218 ps=1.42 w=0.42 l=0.15
X17 a_617_6132.t1 a_665_6220.t3 VSS.t45 VSS.t44 sky130_fd_pr__nfet_01v8 ad=0.3654 pd=3.1 as=0.3654 ps=3.1 w=1.26 l=0.15
X18 a_617_14088.t0 a_665_14176.t4 VDD.t117 VDD.t116 sky130_fd_pr__pfet_01v8 ad=0.1218 pd=1.42 as=0.1218 ps=1.42 w=0.42 l=0.15
X19 a_665_30088.t1 a_617_30000.t4 VDD.t75 VDD.t74 sky130_fd_pr__pfet_01v8 ad=0.1218 pd=1.42 as=0.1218 ps=1.42 w=0.42 l=0.15
X20 a_617_51216.t2 WLOFF.t38 BLB.t8 VSS.t153 sky130_fd_pr__nfet_01v8 ad=0.174 pd=1.78 as=0.174 ps=1.78 w=0.6 l=0.15
X21 a_665_19480.t2 WLOFF.t15 BL.t6 VSS.t176 sky130_fd_pr__nfet_01v8 ad=0.174 pd=1.78 as=0.174 ps=1.78 w=0.6 l=0.15
X22 a_617_16740.t1 a_665_16828.t3 VSS.t33 VSS.t32 sky130_fd_pr__nfet_01v8 ad=0.3654 pd=3.1 as=0.3654 ps=3.1 w=1.26 l=0.15
X23 a_665_64564.t2 WLOFF.t49 BL.t7 VSS.t142 sky130_fd_pr__nfet_01v8 ad=0.174 pd=1.78 as=0.174 ps=1.78 w=0.6 l=0.15
X24 a_617_53868.t2 WLOFF.t40 BLB.t29 VSS.t151 sky130_fd_pr__nfet_01v8 ad=0.174 pd=1.78 as=0.174 ps=1.78 w=0.6 l=0.15
X25 a_617_24696.t0 a_665_24784.t4 VDD.t61 VDD.t60 sky130_fd_pr__pfet_01v8 ad=0.1218 pd=1.42 as=0.1218 ps=1.42 w=0.42 l=0.15
X26 a_617_828.t2 WLOFF.t0 BLB.t7 VSS.t191 sky130_fd_pr__nfet_01v8 ad=0.174 pd=1.78 as=0.174 ps=1.78 w=0.6 l=0.15
X27 a_617_14088.t1 a_665_14176.t3 VSS.t15 VSS.t14 sky130_fd_pr__nfet_01v8 ad=0.3654 pd=3.1 as=0.3654 ps=3.1 w=1.26 l=0.15
X28 a_617_61824.t2 WLOFF.t46 BLB.t25 VSS.t145 sky130_fd_pr__nfet_01v8 ad=0.174 pd=1.78 as=0.174 ps=1.78 w=0.6 l=0.15
X29 a_617_61824.t1 a_665_61912.t3 VSS.t63 VSS.t62 sky130_fd_pr__nfet_01v8 ad=0.3654 pd=3.1 as=0.3654 ps=3.1 w=1.26 l=0.15
X30 a_617_11436.t2 WLOFF.t8 BLB.t16 VSS.t183 sky130_fd_pr__nfet_01v8 ad=0.174 pd=1.78 as=0.174 ps=1.78 w=0.6 l=0.15
X31 a_617_69780.t0 a_665_69868.t4 VDD.t25 VDD.t24 sky130_fd_pr__pfet_01v8 ad=0.1218 pd=1.42 as=0.1218 ps=1.42 w=0.42 l=0.15
X32 a_665_64564.t0 a_617_64476.t3 VSS.t19 VSS.t18 sky130_fd_pr__nfet_01v8 ad=0.3654 pd=3.1 as=0.3654 ps=3.1 w=1.26 l=0.15
X33 a_665_916.t2 WLOFF.t1 BL.t5 VSS.t190 sky130_fd_pr__nfet_01v8 ad=0.174 pd=1.78 as=0.174 ps=1.78 w=0.6 l=0.15
X34 a_617_14088.t2 WLOFF.t10 BLB.t14 VSS.t181 sky130_fd_pr__nfet_01v8 ad=0.174 pd=1.78 as=0.174 ps=1.78 w=0.6 l=0.15
X35 a_665_24784.t2 WLOFF.t19 BL.t0 VSS.t172 sky130_fd_pr__nfet_01v8 ad=0.174 pd=1.78 as=0.174 ps=1.78 w=0.6 l=0.15
X36 a_617_72432.t0 a_665_72520.t4 VDD.t105 VDD.t104 sky130_fd_pr__pfet_01v8 ad=0.1218 pd=1.42 as=0.1218 ps=1.42 w=0.42 l=0.15
X37 a_665_72520.t2 WLOFF.t55 BL.t22 VSS.t136 sky130_fd_pr__nfet_01v8 ad=0.174 pd=1.78 as=0.174 ps=1.78 w=0.6 l=0.15
X38 a_665_67216.t1 a_617_67128.t3 VSS.t53 VSS.t52 sky130_fd_pr__nfet_01v8 ad=0.3654 pd=3.1 as=0.3654 ps=3.1 w=1.26 l=0.15
X39 a_665_916.t0 a_617_828.t3 VSS.t23 VSS.t22 sky130_fd_pr__nfet_01v8 ad=0.3654 pd=3.1 as=0.3654 ps=3.1 w=1.26 l=0.15
X40 a_665_24784.t1 a_617_24696.t3 VSS.t101 VSS.t100 sky130_fd_pr__nfet_01v8 ad=0.3654 pd=3.1 as=0.3654 ps=3.1 w=1.26 l=0.15
X41 a_665_27436.t2 WLOFF.t21 BL.t17 VSS.t170 sky130_fd_pr__nfet_01v8 ad=0.174 pd=1.78 as=0.174 ps=1.78 w=0.6 l=0.15
X42 a_665_75172.t2 WLOFF.t57 BL.t30 VSS.t134 sky130_fd_pr__nfet_01v8 ad=0.174 pd=1.78 as=0.174 ps=1.78 w=0.6 l=0.15
X43 a_665_67216.t0 a_617_67128.t4 VDD.t23 VDD.t22 sky130_fd_pr__pfet_01v8 ad=0.1218 pd=1.42 as=0.1218 ps=1.42 w=0.42 l=0.15
X44 a_617_48564.t1 a_665_48652.t3 VSS.t117 VSS.t116 sky130_fd_pr__nfet_01v8 ad=0.3654 pd=3.1 as=0.3654 ps=3.1 w=1.26 l=0.15
X45 a_665_3568.t1 a_617_3480.t3 VSS.t125 VSS.t124 sky130_fd_pr__nfet_01v8 ad=0.3654 pd=3.1 as=0.3654 ps=3.1 w=1.26 l=0.15
X46 a_617_22044.t2 WLOFF.t16 BLB.t27 VSS.t175 sky130_fd_pr__nfet_01v8 ad=0.174 pd=1.78 as=0.174 ps=1.78 w=0.6 l=0.15
X47 a_665_27436.t1 a_617_27348.t3 VSS.t67 VSS.t66 sky130_fd_pr__nfet_01v8 ad=0.3654 pd=3.1 as=0.3654 ps=3.1 w=1.26 l=0.15
X48 a_617_32652.t0 a_665_32740.t4 VDD.t77 VDD.t76 sky130_fd_pr__pfet_01v8 ad=0.1218 pd=1.42 as=0.1218 ps=1.42 w=0.42 l=0.15
X49 a_617_56520.t0 a_665_56608.t4 VDD.t49 VDD.t48 sky130_fd_pr__pfet_01v8 ad=0.1218 pd=1.42 as=0.1218 ps=1.42 w=0.42 l=0.15
X50 a_617_22044.t1 a_665_22132.t3 VSS.t65 VSS.t64 sky130_fd_pr__nfet_01v8 ad=0.3654 pd=3.1 as=0.3654 ps=3.1 w=1.26 l=0.15
X51 a_665_77824.t0 a_617_77736.t4 VDD.t69 VDD.t68 sky130_fd_pr__pfet_01v8 ad=0.1218 pd=1.42 as=0.1218 ps=1.42 w=0.42 l=0.15
X52 a_617_30000.t0 a_665_30088.t4 VDD.t11 VDD.t10 sky130_fd_pr__pfet_01v8 ad=0.1218 pd=1.42 as=0.1218 ps=1.42 w=0.42 l=0.15
X53 a_665_72520.t1 a_617_72432.t3 VSS.t57 VSS.t56 sky130_fd_pr__nfet_01v8 ad=0.3654 pd=3.1 as=0.3654 ps=3.1 w=1.26 l=0.15
X54 a_665_35392.t2 WLOFF.t27 BL.t18 VSS.t164 sky130_fd_pr__nfet_01v8 ad=0.174 pd=1.78 as=0.174 ps=1.78 w=0.6 l=0.15
X55 a_617_828.t0 a_665_916.t4 VDD.t59 VDD.t58 sky130_fd_pr__pfet_01v8 ad=0.1218 pd=1.42 as=0.1218 ps=1.42 w=0.42 l=0.15
X56 a_665_3568.t0 a_617_3480.t4 VDD.t35 VDD.t34 sky130_fd_pr__pfet_01v8 ad=0.1218 pd=1.42 as=0.1218 ps=1.42 w=0.42 l=0.15
X57 a_665_27436.t0 a_617_27348.t4 VDD.t47 VDD.t46 sky130_fd_pr__pfet_01v8 ad=0.1218 pd=1.42 as=0.1218 ps=1.42 w=0.42 l=0.15
X58 a_665_75172.t0 a_617_75084.t4 VDD.t13 VDD.t12 sky130_fd_pr__pfet_01v8 ad=0.1218 pd=1.42 as=0.1218 ps=1.42 w=0.42 l=0.15
X59 a_665_80476.t2 WLOFF.t61 BL.t28 VSS.t130 sky130_fd_pr__nfet_01v8 ad=0.174 pd=1.78 as=0.174 ps=1.78 w=0.6 l=0.15
X60 a_617_8784.t1 a_665_8872.t3 VSS.t83 VSS.t82 sky130_fd_pr__nfet_01v8 ad=0.3654 pd=3.1 as=0.3654 ps=3.1 w=1.26 l=0.15
X61 a_617_30000.t1 a_665_30088.t3 VSS.t59 VSS.t58 sky130_fd_pr__nfet_01v8 ad=0.3654 pd=3.1 as=0.3654 ps=3.1 w=1.26 l=0.15
X62 a_665_6220.t1 a_617_6132.t4 VDD.t115 VDD.t114 sky130_fd_pr__pfet_01v8 ad=0.1218 pd=1.42 as=0.1218 ps=1.42 w=0.42 l=0.15
X63 a_665_32740.t0 a_617_32652.t3 VSS.t7 VSS.t6 sky130_fd_pr__nfet_01v8 ad=0.3654 pd=3.1 as=0.3654 ps=3.1 w=1.26 l=0.15
X64 a_665_80476.t1 a_617_80388.t3 VSS.t115 VSS.t114 sky130_fd_pr__nfet_01v8 ad=0.3654 pd=3.1 as=0.3654 ps=3.1 w=1.26 l=0.15
X65 a_665_11524.t1 a_617_11436.t4 VDD.t125 VDD.t124 sky130_fd_pr__pfet_01v8 ad=0.1218 pd=1.42 as=0.1218 ps=1.42 w=0.42 l=0.15
X66 a_617_32652.t2 WLOFF.t24 BLB.t5 VSS.t167 sky130_fd_pr__nfet_01v8 ad=0.174 pd=1.78 as=0.174 ps=1.78 w=0.6 l=0.15
X67 a_665_35392.t0 a_617_35304.t4 VDD.t55 VDD.t54 sky130_fd_pr__pfet_01v8 ad=0.1218 pd=1.42 as=0.1218 ps=1.42 w=0.42 l=0.15
X68 a_617_56520.t2 WLOFF.t42 BLB.t26 VSS.t149 sky130_fd_pr__nfet_01v8 ad=0.174 pd=1.78 as=0.174 ps=1.78 w=0.6 l=0.15
X69 a_617_30000.t2 WLOFF.t22 BLB.t31 VSS.t169 sky130_fd_pr__nfet_01v8 ad=0.174 pd=1.78 as=0.174 ps=1.78 w=0.6 l=0.15
X70 a_665_40696.t2 WLOFF.t31 BL.t13 VSS.t160 sky130_fd_pr__nfet_01v8 ad=0.174 pd=1.78 as=0.174 ps=1.78 w=0.6 l=0.15
X71 a_665_83128.t1 a_617_83040.t3 VSS.t113 VSS.t112 sky130_fd_pr__nfet_01v8 ad=0.3654 pd=3.1 as=0.3654 ps=3.1 w=1.26 l=0.15
X72 a_665_59260.t1 a_617_59172.t3 VSS.t61 VSS.t60 sky130_fd_pr__nfet_01v8 ad=0.3654 pd=3.1 as=0.3654 ps=3.1 w=1.26 l=0.15
X73 a_665_80476.t0 a_617_80388.t4 VDD.t15 VDD.t14 sky130_fd_pr__pfet_01v8 ad=0.1218 pd=1.42 as=0.1218 ps=1.42 w=0.42 l=0.15
X74 a_665_38044.t0 a_617_37956.t4 VDD.t21 VDD.t20 sky130_fd_pr__pfet_01v8 ad=0.1218 pd=1.42 as=0.1218 ps=1.42 w=0.42 l=0.15
X75 a_665_69868.t2 WLOFF.t53 BL.t31 VSS.t138 sky130_fd_pr__nfet_01v8 ad=0.174 pd=1.78 as=0.174 ps=1.78 w=0.6 l=0.15
X76 a_617_59172.t2 WLOFF.t44 BLB.t2 VSS.t147 sky130_fd_pr__nfet_01v8 ad=0.174 pd=1.78 as=0.174 ps=1.78 w=0.6 l=0.15
X77 a_665_40696.t1 a_617_40608.t3 VSS.t103 VSS.t102 sky130_fd_pr__nfet_01v8 ad=0.3654 pd=3.1 as=0.3654 ps=3.1 w=1.26 l=0.15
X78 a_617_67128.t0 a_665_67216.t4 VDD.t43 VDD.t42 sky130_fd_pr__pfet_01v8 ad=0.1218 pd=1.42 as=0.1218 ps=1.42 w=0.42 l=0.15
X79 a_665_67216.t2 WLOFF.t51 BL.t4 VSS.t140 sky130_fd_pr__nfet_01v8 ad=0.174 pd=1.78 as=0.174 ps=1.78 w=0.6 l=0.15
X80 a_665_43348.t2 WLOFF.t33 BL.t10 VSS.t158 sky130_fd_pr__nfet_01v8 ad=0.174 pd=1.78 as=0.174 ps=1.78 w=0.6 l=0.15
X81 a_665_83128.t0 a_617_83040.t4 VDD.t81 VDD.t80 sky130_fd_pr__pfet_01v8 ad=0.1218 pd=1.42 as=0.1218 ps=1.42 w=0.42 l=0.15
X82 a_665_69868.t0 a_617_69780.t3 VSS.t5 VSS.t4 sky130_fd_pr__nfet_01v8 ad=0.3654 pd=3.1 as=0.3654 ps=3.1 w=1.26 l=0.15
X83 a_617_16740.t2 WLOFF.t12 BLB.t18 VSS.t179 sky130_fd_pr__nfet_01v8 ad=0.174 pd=1.78 as=0.174 ps=1.78 w=0.6 l=0.15
X84 a_617_64476.t1 a_665_64564.t3 VSS.t21 VSS.t20 sky130_fd_pr__nfet_01v8 ad=0.3654 pd=3.1 as=0.3654 ps=3.1 w=1.26 l=0.15
X85 a_665_43348.t1 a_617_43260.t3 VSS.t105 VSS.t104 sky130_fd_pr__nfet_01v8 ad=0.3654 pd=3.1 as=0.3654 ps=3.1 w=1.26 l=0.15
X86 a_665_19480.t1 a_617_19392.t3 VSS.t85 VSS.t84 sky130_fd_pr__nfet_01v8 ad=0.3654 pd=3.1 as=0.3654 ps=3.1 w=1.26 l=0.15
X87 a_665_40696.t0 a_617_40608.t4 VDD.t97 VDD.t96 sky130_fd_pr__pfet_01v8 ad=0.1218 pd=1.42 as=0.1218 ps=1.42 w=0.42 l=0.15
X88 a_617_3480.t2 WLOFF.t2 BLB.t0 VSS.t189 sky130_fd_pr__nfet_01v8 ad=0.174 pd=1.78 as=0.174 ps=1.78 w=0.6 l=0.15
X89 a_617_19392.t2 WLOFF.t14 BLB.t23 VSS.t177 sky130_fd_pr__nfet_01v8 ad=0.174 pd=1.78 as=0.174 ps=1.78 w=0.6 l=0.15
X90 a_617_77736.t0 a_665_77824.t4 VDD.t67 VDD.t66 sky130_fd_pr__pfet_01v8 ad=0.1218 pd=1.42 as=0.1218 ps=1.42 w=0.42 l=0.15
X91 a_617_67128.t1 a_665_67216.t3 VSS.t127 VSS.t126 sky130_fd_pr__nfet_01v8 ad=0.3654 pd=3.1 as=0.3654 ps=3.1 w=1.26 l=0.15
X92 a_617_27348.t0 a_665_27436.t4 VDD.t53 VDD.t52 sky130_fd_pr__pfet_01v8 ad=0.1218 pd=1.42 as=0.1218 ps=1.42 w=0.42 l=0.15
X93 a_617_75084.t0 a_665_75172.t4 VDD.t107 VDD.t106 sky130_fd_pr__pfet_01v8 ad=0.1218 pd=1.42 as=0.1218 ps=1.42 w=0.42 l=0.15
X94 a_665_43348.t0 a_617_43260.t4 VDD.t101 VDD.t100 sky130_fd_pr__pfet_01v8 ad=0.1218 pd=1.42 as=0.1218 ps=1.42 w=0.42 l=0.15
X95 a_617_64476.t2 WLOFF.t48 BLB.t19 VSS.t143 sky130_fd_pr__nfet_01v8 ad=0.174 pd=1.78 as=0.174 ps=1.78 w=0.6 l=0.15
X96 a_617_24696.t1 a_665_24784.t3 VSS.t9 VSS.t8 sky130_fd_pr__nfet_01v8 ad=0.3654 pd=3.1 as=0.3654 ps=3.1 w=1.26 l=0.15
X97 a_617_828.t1 a_665_916.t3 VSS.t43 VSS.t42 sky130_fd_pr__nfet_01v8 ad=0.3654 pd=3.1 as=0.3654 ps=3.1 w=1.26 l=0.15
X98 a_617_27348.t1 a_665_27436.t3 VSS.t25 VSS.t24 sky130_fd_pr__nfet_01v8 ad=0.3654 pd=3.1 as=0.3654 ps=3.1 w=1.26 l=0.15
X99 a_617_11436.t0 a_665_11524.t4 VDD.t1 VDD.t0 sky130_fd_pr__pfet_01v8 ad=0.1218 pd=1.42 as=0.1218 ps=1.42 w=0.42 l=0.15
X100 a_617_35304.t0 a_665_35392.t4 VDD.t29 VDD.t28 sky130_fd_pr__pfet_01v8 ad=0.1218 pd=1.42 as=0.1218 ps=1.42 w=0.42 l=0.15
X101 a_665_77824.t1 a_617_77736.t3 VSS.t77 VSS.t76 sky130_fd_pr__nfet_01v8 ad=0.3654 pd=3.1 as=0.3654 ps=3.1 w=1.26 l=0.15
X102 a_665_51304.t1 a_617_51216.t4 VDD.t127 VDD.t126 sky130_fd_pr__pfet_01v8 ad=0.1218 pd=1.42 as=0.1218 ps=1.42 w=0.42 l=0.15
X103 a_617_24696.t2 WLOFF.t18 BLB.t24 VSS.t173 sky130_fd_pr__nfet_01v8 ad=0.174 pd=1.78 as=0.174 ps=1.78 w=0.6 l=0.15
X104 a_617_72432.t2 WLOFF.t54 BLB.t22 VSS.t137 sky130_fd_pr__nfet_01v8 ad=0.174 pd=1.78 as=0.174 ps=1.78 w=0.6 l=0.15
X105 a_617_72432.t1 a_665_72520.t3 VSS.t41 VSS.t40 sky130_fd_pr__nfet_01v8 ad=0.3654 pd=3.1 as=0.3654 ps=3.1 w=1.26 l=0.15
X106 a_665_51304.t0 a_617_51216.t3 VSS.t123 VSS.t122 sky130_fd_pr__nfet_01v8 ad=0.3654 pd=3.1 as=0.3654 ps=3.1 w=1.26 l=0.15
X107 a_665_8872.t1 a_617_8784.t4 VDD.t121 VDD.t120 sky130_fd_pr__pfet_01v8 ad=0.1218 pd=1.42 as=0.1218 ps=1.42 w=0.42 l=0.15
X108 a_617_80388.t0 a_665_80476.t4 VDD.t103 VDD.t102 sky130_fd_pr__pfet_01v8 ad=0.1218 pd=1.42 as=0.1218 ps=1.42 w=0.42 l=0.15
X109 a_665_75172.t1 a_617_75084.t3 VSS.t111 VSS.t110 sky130_fd_pr__nfet_01v8 ad=0.3654 pd=3.1 as=0.3654 ps=3.1 w=1.26 l=0.15
X110 a_617_37956.t0 a_665_38044.t4 VDD.t19 VDD.t18 sky130_fd_pr__pfet_01v8 ad=0.1218 pd=1.42 as=0.1218 ps=1.42 w=0.42 l=0.15
X111 a_665_3568.t2 WLOFF.t3 BL.t25 VSS.t188 sky130_fd_pr__nfet_01v8 ad=0.174 pd=1.78 as=0.174 ps=1.78 w=0.6 l=0.15
X112 a_617_3480.t0 a_665_3568.t4 VDD.t33 VDD.t32 sky130_fd_pr__pfet_01v8 ad=0.1218 pd=1.42 as=0.1218 ps=1.42 w=0.42 l=0.15
X113 a_617_27348.t2 WLOFF.t20 BLB.t12 VSS.t171 sky130_fd_pr__nfet_01v8 ad=0.174 pd=1.78 as=0.174 ps=1.78 w=0.6 l=0.15
X114 a_617_75084.t2 WLOFF.t56 BLB.t1 VSS.t135 sky130_fd_pr__nfet_01v8 ad=0.174 pd=1.78 as=0.174 ps=1.78 w=0.6 l=0.15
X115 a_617_83040.t0 a_665_83128.t4 VDD.t79 VDD.t78 sky130_fd_pr__pfet_01v8 ad=0.1218 pd=1.42 as=0.1218 ps=1.42 w=0.42 l=0.15
X116 a_665_83128.t2 WLOFF.t63 BL.t11 VSS.t128 sky130_fd_pr__nfet_01v8 ad=0.174 pd=1.78 as=0.174 ps=1.78 w=0.6 l=0.15
X117 a_665_6220.t0 a_617_6132.t3 VSS.t11 VSS.t10 sky130_fd_pr__nfet_01v8 ad=0.3654 pd=3.1 as=0.3654 ps=3.1 w=1.26 l=0.15
X118 a_617_6132.t0 a_665_6220.t4 VDD.t63 VDD.t62 sky130_fd_pr__pfet_01v8 ad=0.1218 pd=1.42 as=0.1218 ps=1.42 w=0.42 l=0.15
X119 a_665_11524.t0 a_617_11436.t3 VSS.t13 VSS.t12 sky130_fd_pr__nfet_01v8 ad=0.3654 pd=3.1 as=0.3654 ps=3.1 w=1.26 l=0.15
X120 a_617_32652.t1 a_665_32740.t3 VSS.t17 VSS.t16 sky130_fd_pr__nfet_01v8 ad=0.3654 pd=3.1 as=0.3654 ps=3.1 w=1.26 l=0.15
X121 a_617_80388.t1 a_665_80476.t3 VSS.t81 VSS.t80 sky130_fd_pr__nfet_01v8 ad=0.3654 pd=3.1 as=0.3654 ps=3.1 w=1.26 l=0.15
X122 a_665_35392.t1 a_617_35304.t3 VSS.t73 VSS.t72 sky130_fd_pr__nfet_01v8 ad=0.3654 pd=3.1 as=0.3654 ps=3.1 w=1.26 l=0.15
X123 a_617_40608.t0 a_665_40696.t4 VDD.t95 VDD.t94 sky130_fd_pr__pfet_01v8 ad=0.1218 pd=1.42 as=0.1218 ps=1.42 w=0.42 l=0.15
X124 a_665_38044.t2 WLOFF.t29 BL.t12 VSS.t162 sky130_fd_pr__nfet_01v8 ad=0.174 pd=1.78 as=0.174 ps=1.78 w=0.6 l=0.15
X125 a_617_35304.t2 WLOFF.t26 BLB.t28 VSS.t165 sky130_fd_pr__nfet_01v8 ad=0.174 pd=1.78 as=0.174 ps=1.78 w=0.6 l=0.15
X126 a_617_83040.t1 a_665_83128.t3 VSS.t87 VSS.t86 sky130_fd_pr__nfet_01v8 ad=0.3654 pd=3.1 as=0.3654 ps=3.1 w=1.26 l=0.15
X127 a_617_59172.t1 a_665_59260.t3 VSS.t93 VSS.t92 sky130_fd_pr__nfet_01v8 ad=0.3654 pd=3.1 as=0.3654 ps=3.1 w=1.26 l=0.15
X128 a_617_43260.t0 a_665_43348.t4 VDD.t89 VDD.t88 sky130_fd_pr__pfet_01v8 ad=0.1218 pd=1.42 as=0.1218 ps=1.42 w=0.42 l=0.15
X129 a_665_38044.t1 a_617_37956.t3 VSS.t51 VSS.t50 sky130_fd_pr__nfet_01v8 ad=0.3654 pd=3.1 as=0.3654 ps=3.1 w=1.26 l=0.15
X130 a_665_59260.t0 a_617_59172.t4 VDD.t41 VDD.t40 sky130_fd_pr__pfet_01v8 ad=0.1218 pd=1.42 as=0.1218 ps=1.42 w=0.42 l=0.15
X131 a_617_80388.t2 WLOFF.t60 BLB.t6 VSS.t131 sky130_fd_pr__nfet_01v8 ad=0.174 pd=1.78 as=0.174 ps=1.78 w=0.6 l=0.15
X132 a_665_48652.t2 WLOFF.t37 BL.t14 VSS.t154 sky130_fd_pr__nfet_01v8 ad=0.174 pd=1.78 as=0.174 ps=1.78 w=0.6 l=0.15
X133 a_617_40608.t1 a_665_40696.t3 VSS.t89 VSS.t88 sky130_fd_pr__nfet_01v8 ad=0.3654 pd=3.1 as=0.3654 ps=3.1 w=1.26 l=0.15
X134 a_665_46000.t2 WLOFF.t35 BL.t27 VSS.t156 sky130_fd_pr__nfet_01v8 ad=0.174 pd=1.78 as=0.174 ps=1.78 w=0.6 l=0.15
X135 a_617_69780.t1 a_665_69868.t3 VSS.t107 VSS.t106 sky130_fd_pr__nfet_01v8 ad=0.3654 pd=3.1 as=0.3654 ps=3.1 w=1.26 l=0.15
X136 a_665_46000.t0 a_617_45912.t4 VDD.t87 VDD.t86 sky130_fd_pr__pfet_01v8 ad=0.1218 pd=1.42 as=0.1218 ps=1.42 w=0.42 l=0.15
X137 a_617_43260.t1 a_665_43348.t3 VSS.t97 VSS.t96 sky130_fd_pr__nfet_01v8 ad=0.3654 pd=3.1 as=0.3654 ps=3.1 w=1.26 l=0.15
X138 a_617_8784.t2 WLOFF.t6 BLB.t30 VSS.t185 sky130_fd_pr__nfet_01v8 ad=0.174 pd=1.78 as=0.174 ps=1.78 w=0.6 l=0.15
X139 a_617_19392.t1 a_665_19480.t3 VSS.t47 VSS.t46 sky130_fd_pr__nfet_01v8 ad=0.3654 pd=3.1 as=0.3654 ps=3.1 w=1.26 l=0.15
X140 a_617_51216.t0 a_665_51304.t4 VDD.t113 VDD.t112 sky130_fd_pr__pfet_01v8 ad=0.1218 pd=1.42 as=0.1218 ps=1.42 w=0.42 l=0.15
X141 a_665_19480.t0 a_617_19392.t4 VDD.t45 VDD.t44 sky130_fd_pr__pfet_01v8 ad=0.1218 pd=1.42 as=0.1218 ps=1.42 w=0.42 l=0.15
X142 a_617_40608.t2 WLOFF.t30 BLB.t17 VSS.t161 sky130_fd_pr__nfet_01v8 ad=0.174 pd=1.78 as=0.174 ps=1.78 w=0.6 l=0.15
X143 a_617_6132.t2 WLOFF.t4 BLB.t9 VSS.t187 sky130_fd_pr__nfet_01v8 ad=0.174 pd=1.78 as=0.174 ps=1.78 w=0.6 l=0.15
X144 a_665_48652.t1 a_617_48564.t4 VDD.t111 VDD.t110 sky130_fd_pr__pfet_01v8 ad=0.1218 pd=1.42 as=0.1218 ps=1.42 w=0.42 l=0.15
X145 a_617_69780.t2 WLOFF.t52 BLB.t11 VSS.t139 sky130_fd_pr__nfet_01v8 ad=0.174 pd=1.78 as=0.174 ps=1.78 w=0.6 l=0.15
X146 a_665_22132.t1 a_617_22044.t4 VDD.t123 VDD.t122 sky130_fd_pr__pfet_01v8 ad=0.1218 pd=1.42 as=0.1218 ps=1.42 w=0.42 l=0.15
X147 a_617_43260.t2 WLOFF.t32 BLB.t15 VSS.t159 sky130_fd_pr__nfet_01v8 ad=0.174 pd=1.78 as=0.174 ps=1.78 w=0.6 l=0.15
X148 a_665_77824.t2 WLOFF.t59 BL.t2 VSS.t132 sky130_fd_pr__nfet_01v8 ad=0.174 pd=1.78 as=0.174 ps=1.78 w=0.6 l=0.15
X149 a_617_67128.t2 WLOFF.t50 BLB.t10 VSS.t141 sky130_fd_pr__nfet_01v8 ad=0.174 pd=1.78 as=0.174 ps=1.78 w=0.6 l=0.15
X150 a_665_51304.t2 WLOFF.t39 BL.t19 VSS.t152 sky130_fd_pr__nfet_01v8 ad=0.174 pd=1.78 as=0.174 ps=1.78 w=0.6 l=0.15
X151 a_665_46000.t1 a_617_45912.t3 VSS.t109 VSS.t108 sky130_fd_pr__nfet_01v8 ad=0.3654 pd=3.1 as=0.3654 ps=3.1 w=1.26 l=0.15
X152 a_617_3480.t1 a_665_3568.t3 VSS.t3 VSS.t2 sky130_fd_pr__nfet_01v8 ad=0.3654 pd=3.1 as=0.3654 ps=3.1 w=1.26 l=0.15
X153 a_665_53956.t0 a_617_53868.t3 VSS.t91 VSS.t90 sky130_fd_pr__nfet_01v8 ad=0.3654 pd=3.1 as=0.3654 ps=3.1 w=1.26 l=0.15
X154 a_617_77736.t1 a_665_77824.t3 VSS.t75 VSS.t74 sky130_fd_pr__nfet_01v8 ad=0.3654 pd=3.1 as=0.3654 ps=3.1 w=1.26 l=0.15
X155 a_665_53956.t2 WLOFF.t41 BL.t9 VSS.t150 sky130_fd_pr__nfet_01v8 ad=0.174 pd=1.78 as=0.174 ps=1.78 w=0.6 l=0.15
X156 a_665_61912.t2 WLOFF.t47 BL.t8 VSS.t144 sky130_fd_pr__nfet_01v8 ad=0.174 pd=1.78 as=0.174 ps=1.78 w=0.6 l=0.15
X157 a_665_56608.t0 a_617_56520.t3 VSS.t55 VSS.t54 sky130_fd_pr__nfet_01v8 ad=0.3654 pd=3.1 as=0.3654 ps=3.1 w=1.26 l=0.15
X158 a_665_8872.t0 a_617_8784.t3 VSS.t79 VSS.t78 sky130_fd_pr__nfet_01v8 ad=0.3654 pd=3.1 as=0.3654 ps=3.1 w=1.26 l=0.15
X159 a_665_53956.t1 a_617_53868.t4 VDD.t99 VDD.t98 sky130_fd_pr__pfet_01v8 ad=0.1218 pd=1.42 as=0.1218 ps=1.42 w=0.42 l=0.15
X160 a_617_51216.t1 a_665_51304.t3 VSS.t121 VSS.t120 sky130_fd_pr__nfet_01v8 ad=0.3654 pd=3.1 as=0.3654 ps=3.1 w=1.26 l=0.15
X161 a_617_75084.t1 a_665_75172.t3 VSS.t71 VSS.t70 sky130_fd_pr__nfet_01v8 ad=0.3654 pd=3.1 as=0.3654 ps=3.1 w=1.26 l=0.15
X162 a_617_59172.t0 a_665_59260.t4 VDD.t83 VDD.t82 sky130_fd_pr__pfet_01v8 ad=0.1218 pd=1.42 as=0.1218 ps=1.42 w=0.42 l=0.15
X163 a_665_8872.t2 WLOFF.t7 BL.t16 VSS.t184 sky130_fd_pr__nfet_01v8 ad=0.174 pd=1.78 as=0.174 ps=1.78 w=0.6 l=0.15
X164 a_617_8784.t0 a_665_8872.t4 VDD.t3 VDD.t2 sky130_fd_pr__pfet_01v8 ad=0.1218 pd=1.42 as=0.1218 ps=1.42 w=0.42 l=0.15
X165 a_665_11524.t2 WLOFF.t9 BL.t20 VSS.t182 sky130_fd_pr__nfet_01v8 ad=0.174 pd=1.78 as=0.174 ps=1.78 w=0.6 l=0.15
X166 a_665_6220.t2 WLOFF.t5 BL.t3 VSS.t186 sky130_fd_pr__nfet_01v8 ad=0.174 pd=1.78 as=0.174 ps=1.78 w=0.6 l=0.15
X167 a_665_14176.t2 WLOFF.t11 BL.t21 VSS.t180 sky130_fd_pr__nfet_01v8 ad=0.174 pd=1.78 as=0.174 ps=1.78 w=0.6 l=0.15
X168 a_665_16828.t0 a_617_16740.t3 VSS.t35 VSS.t34 sky130_fd_pr__nfet_01v8 ad=0.3654 pd=3.1 as=0.3654 ps=3.1 w=1.26 l=0.15
X169 a_617_45912.t0 a_665_46000.t4 VDD.t93 VDD.t92 sky130_fd_pr__pfet_01v8 ad=0.1218 pd=1.42 as=0.1218 ps=1.42 w=0.42 l=0.15
X170 a_617_11436.t1 a_665_11524.t3 VSS.t1 VSS.t0 sky130_fd_pr__nfet_01v8 ad=0.3654 pd=3.1 as=0.3654 ps=3.1 w=1.26 l=0.15
X171 a_665_61912.t1 a_617_61824.t4 VDD.t85 VDD.t84 sky130_fd_pr__pfet_01v8 ad=0.1218 pd=1.42 as=0.1218 ps=1.42 w=0.42 l=0.15
X172 a_665_14176.t1 a_617_14088.t3 VSS.t99 VSS.t98 sky130_fd_pr__nfet_01v8 ad=0.3654 pd=3.1 as=0.3654 ps=3.1 w=1.26 l=0.15
X173 a_617_35304.t1 a_665_35392.t3 VSS.t69 VSS.t68 sky130_fd_pr__nfet_01v8 ad=0.3654 pd=3.1 as=0.3654 ps=3.1 w=1.26 l=0.15
X174 a_617_19392.t0 a_665_19480.t4 VDD.t39 VDD.t38 sky130_fd_pr__pfet_01v8 ad=0.1218 pd=1.42 as=0.1218 ps=1.42 w=0.42 l=0.15
X175 a_665_61912.t0 a_617_61824.t3 VSS.t29 VSS.t28 sky130_fd_pr__nfet_01v8 ad=0.3654 pd=3.1 as=0.3654 ps=3.1 w=1.26 l=0.15
X176 a_617_48564.t0 a_665_48652.t4 VDD.t109 VDD.t108 sky130_fd_pr__pfet_01v8 ad=0.1218 pd=1.42 as=0.1218 ps=1.42 w=0.42 l=0.15
X177 a_665_16828.t1 a_617_16740.t4 VDD.t65 VDD.t64 sky130_fd_pr__pfet_01v8 ad=0.1218 pd=1.42 as=0.1218 ps=1.42 w=0.42 l=0.15
X178 a_665_64564.t1 a_617_64476.t4 VDD.t27 VDD.t26 sky130_fd_pr__pfet_01v8 ad=0.1218 pd=1.42 as=0.1218 ps=1.42 w=0.42 l=0.15
X179 a_617_37956.t1 a_665_38044.t3 VSS.t37 VSS.t36 sky130_fd_pr__nfet_01v8 ad=0.3654 pd=3.1 as=0.3654 ps=3.1 w=1.26 l=0.15
X180 a_665_14176.t0 a_617_14088.t4 VDD.t71 VDD.t70 sky130_fd_pr__pfet_01v8 ad=0.1218 pd=1.42 as=0.1218 ps=1.42 w=0.42 l=0.15
X181 a_665_22132.t2 WLOFF.t17 BL.t26 VSS.t174 sky130_fd_pr__nfet_01v8 ad=0.174 pd=1.78 as=0.174 ps=1.78 w=0.6 l=0.15
X182 a_617_22044.t0 a_665_22132.t4 VDD.t5 VDD.t4 sky130_fd_pr__pfet_01v8 ad=0.1218 pd=1.42 as=0.1218 ps=1.42 w=0.42 l=0.15
X183 a_617_83040.t2 WLOFF.t62 BLB.t21 VSS.t129 sky130_fd_pr__nfet_01v8 ad=0.174 pd=1.78 as=0.174 ps=1.78 w=0.6 l=0.15
X184 a_617_37956.t2 WLOFF.t28 BLB.t3 VSS.t163 sky130_fd_pr__nfet_01v8 ad=0.174 pd=1.78 as=0.174 ps=1.78 w=0.6 l=0.15
X185 a_665_24784.t0 a_617_24696.t4 VDD.t73 VDD.t72 sky130_fd_pr__pfet_01v8 ad=0.1218 pd=1.42 as=0.1218 ps=1.42 w=0.42 l=0.15
X186 a_617_53868.t0 a_665_53956.t4 VDD.t91 VDD.t90 sky130_fd_pr__pfet_01v8 ad=0.1218 pd=1.42 as=0.1218 ps=1.42 w=0.42 l=0.15
X187 a_665_48652.t0 a_617_48564.t3 VSS.t119 VSS.t118 sky130_fd_pr__nfet_01v8 ad=0.3654 pd=3.1 as=0.3654 ps=3.1 w=1.26 l=0.15
X188 a_665_69868.t1 a_617_69780.t4 VDD.t31 VDD.t30 sky130_fd_pr__pfet_01v8 ad=0.1218 pd=1.42 as=0.1218 ps=1.42 w=0.42 l=0.15
X189 a_665_22132.t0 a_617_22044.t3 VSS.t49 VSS.t48 sky130_fd_pr__nfet_01v8 ad=0.3654 pd=3.1 as=0.3654 ps=3.1 w=1.26 l=0.15
X190 a_617_48564.t2 WLOFF.t36 BLB.t20 VSS.t155 sky130_fd_pr__nfet_01v8 ad=0.174 pd=1.78 as=0.174 ps=1.78 w=0.6 l=0.15
X191 a_665_32740.t2 WLOFF.t25 BL.t15 VSS.t166 sky130_fd_pr__nfet_01v8 ad=0.174 pd=1.78 as=0.174 ps=1.78 w=0.6 l=0.15
C0 WLOFF BL 65.4669f
C1 WLOFF BLB 10.5645f
C2 BL VDD 4.89896f
C3 BLB VDD 60.4397f
C4 BL BLB 87.35921f
C5 WLOFF VDD 29.4307f
R0 BLB.n0 BLB.t21 233.731
R1 BLB.n2 BLB.t6 233.731
R2 BLB.n4 BLB.t4 233.731
R3 BLB.n6 BLB.t1 233.731
R4 BLB.n8 BLB.t22 233.731
R5 BLB.n10 BLB.t11 233.731
R6 BLB.n12 BLB.t10 233.731
R7 BLB.n14 BLB.t19 233.731
R8 BLB.n16 BLB.t25 233.731
R9 BLB.n18 BLB.t2 233.731
R10 BLB.n20 BLB.t26 233.731
R11 BLB.n22 BLB.t29 233.731
R12 BLB.n24 BLB.t8 233.731
R13 BLB.n26 BLB.t20 233.731
R14 BLB.n28 BLB.t13 233.731
R15 BLB.n30 BLB.t15 233.731
R16 BLB.n32 BLB.t17 233.731
R17 BLB.n34 BLB.t3 233.731
R18 BLB.n36 BLB.t28 233.731
R19 BLB.n38 BLB.t5 233.731
R20 BLB.n40 BLB.t31 233.731
R21 BLB.n42 BLB.t12 233.731
R22 BLB.n44 BLB.t24 233.731
R23 BLB.n46 BLB.t27 233.731
R24 BLB.n48 BLB.t23 233.731
R25 BLB.n50 BLB.t18 233.731
R26 BLB.n52 BLB.t14 233.731
R27 BLB.n54 BLB.t16 233.731
R28 BLB.n56 BLB.t30 233.731
R29 BLB.n58 BLB.t9 233.731
R30 BLB.n60 BLB.t0 233.731
R31 BLB.n62 BLB.t7 233.731
R32 BLB.n62 BLB.n61 4.95915
R33 BLB.n61 BLB.n60 3.4105
R34 BLB.n59 BLB.n58 3.4105
R35 BLB.n57 BLB.n56 3.4105
R36 BLB.n55 BLB.n54 3.4105
R37 BLB.n53 BLB.n52 3.4105
R38 BLB.n51 BLB.n50 3.4105
R39 BLB.n49 BLB.n48 3.4105
R40 BLB.n47 BLB.n46 3.4105
R41 BLB.n45 BLB.n44 3.4105
R42 BLB.n43 BLB.n42 3.4105
R43 BLB.n41 BLB.n40 3.4105
R44 BLB.n39 BLB.n38 3.4105
R45 BLB.n37 BLB.n36 3.4105
R46 BLB.n35 BLB.n34 3.4105
R47 BLB.n33 BLB.n32 3.4105
R48 BLB.n31 BLB.n30 3.4105
R49 BLB.n29 BLB.n28 3.4105
R50 BLB.n27 BLB.n26 3.4105
R51 BLB.n25 BLB.n24 3.4105
R52 BLB.n23 BLB.n22 3.4105
R53 BLB.n21 BLB.n20 3.4105
R54 BLB.n19 BLB.n18 3.4105
R55 BLB.n17 BLB.n16 3.4105
R56 BLB.n15 BLB.n14 3.4105
R57 BLB.n13 BLB.n12 3.4105
R58 BLB.n11 BLB.n10 3.4105
R59 BLB.n9 BLB.n8 3.4105
R60 BLB.n7 BLB.n6 3.4105
R61 BLB.n5 BLB.n4 3.4105
R62 BLB.n3 BLB.n2 3.4105
R63 BLB.n1 BLB.n0 3.4105
R64 BLB.n61 BLB.n59 1.54915
R65 BLB.n59 BLB.n57 1.54915
R66 BLB.n57 BLB.n55 1.54915
R67 BLB.n55 BLB.n53 1.54915
R68 BLB.n53 BLB.n51 1.54915
R69 BLB.n51 BLB.n49 1.54915
R70 BLB.n49 BLB.n47 1.54915
R71 BLB.n47 BLB.n45 1.54915
R72 BLB.n45 BLB.n43 1.54915
R73 BLB.n43 BLB.n41 1.54915
R74 BLB.n41 BLB.n39 1.54915
R75 BLB.n39 BLB.n37 1.54915
R76 BLB.n37 BLB.n35 1.54915
R77 BLB.n35 BLB.n33 1.54915
R78 BLB.n33 BLB.n31 1.54915
R79 BLB.n31 BLB.n29 1.54915
R80 BLB.n29 BLB.n27 1.54915
R81 BLB.n27 BLB.n25 1.54915
R82 BLB.n25 BLB.n23 1.54915
R83 BLB.n23 BLB.n21 1.54915
R84 BLB.n21 BLB.n19 1.54915
R85 BLB.n19 BLB.n17 1.54915
R86 BLB.n17 BLB.n15 1.54915
R87 BLB.n15 BLB.n13 1.54915
R88 BLB.n13 BLB.n11 1.54915
R89 BLB.n11 BLB.n9 1.54915
R90 BLB.n9 BLB.n7 1.54915
R91 BLB.n7 BLB.n5 1.54915
R92 BLB.n5 BLB.n3 1.54915
R93 BLB.n3 BLB.n1 1.54915
R94 BLB.n1 BLB 1.53505
R95 BLB.n0 BLB 0.178988
R96 BLB.n2 BLB 0.178988
R97 BLB.n4 BLB 0.178988
R98 BLB.n6 BLB 0.178988
R99 BLB.n8 BLB 0.178988
R100 BLB.n10 BLB 0.178988
R101 BLB.n12 BLB 0.178988
R102 BLB.n14 BLB 0.178988
R103 BLB.n16 BLB 0.178988
R104 BLB.n18 BLB 0.178988
R105 BLB.n20 BLB 0.178988
R106 BLB.n22 BLB 0.178988
R107 BLB.n24 BLB 0.178988
R108 BLB.n26 BLB 0.178988
R109 BLB.n28 BLB 0.178988
R110 BLB.n30 BLB 0.178988
R111 BLB.n32 BLB 0.178988
R112 BLB.n34 BLB 0.178988
R113 BLB.n36 BLB 0.178988
R114 BLB.n38 BLB 0.178988
R115 BLB.n40 BLB 0.178988
R116 BLB.n42 BLB 0.178988
R117 BLB.n44 BLB 0.178988
R118 BLB.n46 BLB 0.178988
R119 BLB.n48 BLB 0.178988
R120 BLB.n50 BLB 0.178988
R121 BLB.n52 BLB 0.178988
R122 BLB.n54 BLB 0.178988
R123 BLB.n56 BLB 0.178988
R124 BLB.n58 BLB 0.178988
R125 BLB.n60 BLB 0.178988
R126 BLB BLB.n62 0.178988
R127 BL.n0 BL.t11 233.578
R128 BL.n2 BL.t28 233.578
R129 BL.n4 BL.t2 233.578
R130 BL.n6 BL.t30 233.578
R131 BL.n8 BL.t22 233.578
R132 BL.n10 BL.t31 233.578
R133 BL.n12 BL.t4 233.578
R134 BL.n14 BL.t7 233.578
R135 BL.n16 BL.t8 233.578
R136 BL.n18 BL.t24 233.578
R137 BL.n20 BL.t23 233.578
R138 BL.n22 BL.t9 233.578
R139 BL.n24 BL.t19 233.578
R140 BL.n26 BL.t14 233.578
R141 BL.n28 BL.t27 233.578
R142 BL.n30 BL.t10 233.578
R143 BL.n32 BL.t13 233.578
R144 BL.n34 BL.t12 233.578
R145 BL.n36 BL.t18 233.578
R146 BL.n38 BL.t15 233.578
R147 BL.n40 BL.t29 233.578
R148 BL.n42 BL.t17 233.578
R149 BL.n44 BL.t0 233.578
R150 BL.n46 BL.t26 233.578
R151 BL.n48 BL.t6 233.578
R152 BL.n50 BL.t1 233.578
R153 BL.n52 BL.t21 233.578
R154 BL.n54 BL.t20 233.578
R155 BL.n56 BL.t16 233.578
R156 BL.n58 BL.t3 233.578
R157 BL.n60 BL.t25 233.578
R158 BL.n62 BL.t5 233.578
R159 BL.n62 BL.n61 4.95915
R160 BL.n61 BL.n60 3.4105
R161 BL.n59 BL.n58 3.4105
R162 BL.n57 BL.n56 3.4105
R163 BL.n55 BL.n54 3.4105
R164 BL.n53 BL.n52 3.4105
R165 BL.n51 BL.n50 3.4105
R166 BL.n49 BL.n48 3.4105
R167 BL.n47 BL.n46 3.4105
R168 BL.n45 BL.n44 3.4105
R169 BL.n43 BL.n42 3.4105
R170 BL.n41 BL.n40 3.4105
R171 BL.n39 BL.n38 3.4105
R172 BL.n37 BL.n36 3.4105
R173 BL.n35 BL.n34 3.4105
R174 BL.n33 BL.n32 3.4105
R175 BL.n31 BL.n30 3.4105
R176 BL.n29 BL.n28 3.4105
R177 BL.n27 BL.n26 3.4105
R178 BL.n25 BL.n24 3.4105
R179 BL.n23 BL.n22 3.4105
R180 BL.n21 BL.n20 3.4105
R181 BL.n19 BL.n18 3.4105
R182 BL.n17 BL.n16 3.4105
R183 BL.n15 BL.n14 3.4105
R184 BL.n13 BL.n12 3.4105
R185 BL.n11 BL.n10 3.4105
R186 BL.n9 BL.n8 3.4105
R187 BL.n7 BL.n6 3.4105
R188 BL.n5 BL.n4 3.4105
R189 BL.n3 BL.n2 3.4105
R190 BL.n1 BL.n0 3.4105
R191 BL.n61 BL.n59 1.54915
R192 BL.n59 BL.n57 1.54915
R193 BL.n57 BL.n55 1.54915
R194 BL.n55 BL.n53 1.54915
R195 BL.n53 BL.n51 1.54915
R196 BL.n51 BL.n49 1.54915
R197 BL.n49 BL.n47 1.54915
R198 BL.n47 BL.n45 1.54915
R199 BL.n45 BL.n43 1.54915
R200 BL.n43 BL.n41 1.54915
R201 BL.n41 BL.n39 1.54915
R202 BL.n39 BL.n37 1.54915
R203 BL.n37 BL.n35 1.54915
R204 BL.n35 BL.n33 1.54915
R205 BL.n33 BL.n31 1.54915
R206 BL.n31 BL.n29 1.54915
R207 BL.n29 BL.n27 1.54915
R208 BL.n27 BL.n25 1.54915
R209 BL.n25 BL.n23 1.54915
R210 BL.n23 BL.n21 1.54915
R211 BL.n21 BL.n19 1.54915
R212 BL.n19 BL.n17 1.54915
R213 BL.n17 BL.n15 1.54915
R214 BL.n15 BL.n13 1.54915
R215 BL.n13 BL.n11 1.54915
R216 BL.n11 BL.n9 1.54915
R217 BL.n9 BL.n7 1.54915
R218 BL.n7 BL.n5 1.54915
R219 BL.n5 BL.n3 1.54915
R220 BL.n3 BL.n1 1.54915
R221 BL.n1 BL 1.44693
R222 BL.n0 BL 0.0127396
R223 BL.n2 BL 0.0127396
R224 BL.n4 BL 0.0127396
R225 BL.n6 BL 0.0127396
R226 BL.n8 BL 0.0127396
R227 BL.n10 BL 0.0127396
R228 BL.n12 BL 0.0127396
R229 BL.n14 BL 0.0127396
R230 BL.n16 BL 0.0127396
R231 BL.n18 BL 0.0127396
R232 BL.n20 BL 0.0127396
R233 BL.n22 BL 0.0127396
R234 BL.n24 BL 0.0127396
R235 BL.n26 BL 0.0127396
R236 BL.n28 BL 0.0127396
R237 BL.n30 BL 0.0127396
R238 BL.n32 BL 0.0127396
R239 BL.n34 BL 0.0127396
R240 BL.n36 BL 0.0127396
R241 BL.n38 BL 0.0127396
R242 BL.n40 BL 0.0127396
R243 BL.n42 BL 0.0127396
R244 BL.n44 BL 0.0127396
R245 BL.n46 BL 0.0127396
R246 BL.n48 BL 0.0127396
R247 BL.n50 BL 0.0127396
R248 BL.n52 BL 0.0127396
R249 BL.n54 BL 0.0127396
R250 BL.n56 BL 0.0127396
R251 BL.n58 BL 0.0127396
R252 BL.n60 BL 0.0127396
R253 BL BL.n62 0.0127396
R254 WLOFF.n1 WLOFF.t63 319.156
R255 WLOFF.n4 WLOFF.t61 319.156
R256 WLOFF.n7 WLOFF.t59 319.156
R257 WLOFF.n10 WLOFF.t57 319.156
R258 WLOFF.n13 WLOFF.t55 319.156
R259 WLOFF.n16 WLOFF.t53 319.156
R260 WLOFF.n19 WLOFF.t51 319.156
R261 WLOFF.n22 WLOFF.t49 319.156
R262 WLOFF.n25 WLOFF.t47 319.156
R263 WLOFF.n28 WLOFF.t45 319.156
R264 WLOFF.n31 WLOFF.t43 319.156
R265 WLOFF.n34 WLOFF.t41 319.156
R266 WLOFF.n37 WLOFF.t39 319.156
R267 WLOFF.n40 WLOFF.t37 319.156
R268 WLOFF.n43 WLOFF.t35 319.156
R269 WLOFF.n46 WLOFF.t33 319.156
R270 WLOFF.n49 WLOFF.t31 319.156
R271 WLOFF.n52 WLOFF.t29 319.156
R272 WLOFF.n55 WLOFF.t27 319.156
R273 WLOFF.n58 WLOFF.t25 319.156
R274 WLOFF.n61 WLOFF.t23 319.156
R275 WLOFF.n64 WLOFF.t21 319.156
R276 WLOFF.n67 WLOFF.t19 319.156
R277 WLOFF.n70 WLOFF.t17 319.156
R278 WLOFF.n73 WLOFF.t15 319.156
R279 WLOFF.n76 WLOFF.t13 319.156
R280 WLOFF.n79 WLOFF.t11 319.156
R281 WLOFF.n82 WLOFF.t9 319.156
R282 WLOFF.n85 WLOFF.t7 319.156
R283 WLOFF.n88 WLOFF.t5 319.156
R284 WLOFF.n91 WLOFF.t3 319.156
R285 WLOFF.n0 WLOFF.t1 319.156
R286 WLOFF.n1 WLOFF.t62 317.147
R287 WLOFF.n4 WLOFF.t60 317.147
R288 WLOFF.n7 WLOFF.t58 317.147
R289 WLOFF.n10 WLOFF.t56 317.147
R290 WLOFF.n13 WLOFF.t54 317.147
R291 WLOFF.n16 WLOFF.t52 317.147
R292 WLOFF.n19 WLOFF.t50 317.147
R293 WLOFF.n22 WLOFF.t48 317.147
R294 WLOFF.n25 WLOFF.t46 317.147
R295 WLOFF.n28 WLOFF.t44 317.147
R296 WLOFF.n31 WLOFF.t42 317.147
R297 WLOFF.n34 WLOFF.t40 317.147
R298 WLOFF.n37 WLOFF.t38 317.147
R299 WLOFF.n40 WLOFF.t36 317.147
R300 WLOFF.n43 WLOFF.t34 317.147
R301 WLOFF.n46 WLOFF.t32 317.147
R302 WLOFF.n49 WLOFF.t30 317.147
R303 WLOFF.n52 WLOFF.t28 317.147
R304 WLOFF.n55 WLOFF.t26 317.147
R305 WLOFF.n58 WLOFF.t24 317.147
R306 WLOFF.n61 WLOFF.t22 317.147
R307 WLOFF.n64 WLOFF.t20 317.147
R308 WLOFF.n67 WLOFF.t18 317.147
R309 WLOFF.n70 WLOFF.t16 317.147
R310 WLOFF.n73 WLOFF.t14 317.147
R311 WLOFF.n76 WLOFF.t12 317.147
R312 WLOFF.n79 WLOFF.t10 317.147
R313 WLOFF.n82 WLOFF.t8 317.147
R314 WLOFF.n85 WLOFF.t6 317.147
R315 WLOFF.n88 WLOFF.t4 317.147
R316 WLOFF.n91 WLOFF.t2 317.147
R317 WLOFF.n0 WLOFF.t0 317.147
R318 WLOFF.n2 WLOFF.n1 12.8214
R319 WLOFF.n5 WLOFF.n4 12.8214
R320 WLOFF.n8 WLOFF.n7 12.8214
R321 WLOFF.n11 WLOFF.n10 12.8214
R322 WLOFF.n14 WLOFF.n13 12.8214
R323 WLOFF.n17 WLOFF.n16 12.8214
R324 WLOFF.n20 WLOFF.n19 12.8214
R325 WLOFF.n23 WLOFF.n22 12.8214
R326 WLOFF.n26 WLOFF.n25 12.8214
R327 WLOFF.n29 WLOFF.n28 12.8214
R328 WLOFF.n32 WLOFF.n31 12.8214
R329 WLOFF.n35 WLOFF.n34 12.8214
R330 WLOFF.n38 WLOFF.n37 12.8214
R331 WLOFF.n41 WLOFF.n40 12.8214
R332 WLOFF.n44 WLOFF.n43 12.8214
R333 WLOFF.n47 WLOFF.n46 12.8214
R334 WLOFF.n50 WLOFF.n49 12.8214
R335 WLOFF.n53 WLOFF.n52 12.8214
R336 WLOFF.n56 WLOFF.n55 12.8214
R337 WLOFF.n59 WLOFF.n58 12.8214
R338 WLOFF.n62 WLOFF.n61 12.8214
R339 WLOFF.n65 WLOFF.n64 12.8214
R340 WLOFF.n68 WLOFF.n67 12.8214
R341 WLOFF.n71 WLOFF.n70 12.8214
R342 WLOFF.n74 WLOFF.n73 12.8214
R343 WLOFF.n77 WLOFF.n76 12.8214
R344 WLOFF.n80 WLOFF.n79 12.8214
R345 WLOFF.n83 WLOFF.n82 12.8214
R346 WLOFF.n86 WLOFF.n85 12.8214
R347 WLOFF.n89 WLOFF.n88 12.8214
R348 WLOFF.n92 WLOFF.n91 12.8214
R349 WLOFF.n94 WLOFF.n0 12.8214
R350 WLOFF.n94 WLOFF.n93 4.95915
R351 WLOFF.n93 WLOFF.n92 3.4105
R352 WLOFF.n90 WLOFF.n89 3.4105
R353 WLOFF.n87 WLOFF.n86 3.4105
R354 WLOFF.n84 WLOFF.n83 3.4105
R355 WLOFF.n81 WLOFF.n80 3.4105
R356 WLOFF.n78 WLOFF.n77 3.4105
R357 WLOFF.n75 WLOFF.n74 3.4105
R358 WLOFF.n72 WLOFF.n71 3.4105
R359 WLOFF.n69 WLOFF.n68 3.4105
R360 WLOFF.n66 WLOFF.n65 3.4105
R361 WLOFF.n63 WLOFF.n62 3.4105
R362 WLOFF.n60 WLOFF.n59 3.4105
R363 WLOFF.n57 WLOFF.n56 3.4105
R364 WLOFF.n54 WLOFF.n53 3.4105
R365 WLOFF.n51 WLOFF.n50 3.4105
R366 WLOFF.n48 WLOFF.n47 3.4105
R367 WLOFF.n45 WLOFF.n44 3.4105
R368 WLOFF.n42 WLOFF.n41 3.4105
R369 WLOFF.n39 WLOFF.n38 3.4105
R370 WLOFF.n36 WLOFF.n35 3.4105
R371 WLOFF.n33 WLOFF.n32 3.4105
R372 WLOFF.n30 WLOFF.n29 3.4105
R373 WLOFF.n27 WLOFF.n26 3.4105
R374 WLOFF.n24 WLOFF.n23 3.4105
R375 WLOFF.n21 WLOFF.n20 3.4105
R376 WLOFF.n18 WLOFF.n17 3.4105
R377 WLOFF.n15 WLOFF.n14 3.4105
R378 WLOFF.n12 WLOFF.n11 3.4105
R379 WLOFF.n9 WLOFF.n8 3.4105
R380 WLOFF.n6 WLOFF.n5 3.4105
R381 WLOFF.n3 WLOFF.n2 3.4105
R382 WLOFF.n93 WLOFF.n90 1.54915
R383 WLOFF.n90 WLOFF.n87 1.54915
R384 WLOFF.n87 WLOFF.n84 1.54915
R385 WLOFF.n84 WLOFF.n81 1.54915
R386 WLOFF.n81 WLOFF.n78 1.54915
R387 WLOFF.n78 WLOFF.n75 1.54915
R388 WLOFF.n75 WLOFF.n72 1.54915
R389 WLOFF.n72 WLOFF.n69 1.54915
R390 WLOFF.n69 WLOFF.n66 1.54915
R391 WLOFF.n66 WLOFF.n63 1.54915
R392 WLOFF.n63 WLOFF.n60 1.54915
R393 WLOFF.n60 WLOFF.n57 1.54915
R394 WLOFF.n57 WLOFF.n54 1.54915
R395 WLOFF.n54 WLOFF.n51 1.54915
R396 WLOFF.n51 WLOFF.n48 1.54915
R397 WLOFF.n48 WLOFF.n45 1.54915
R398 WLOFF.n45 WLOFF.n42 1.54915
R399 WLOFF.n42 WLOFF.n39 1.54915
R400 WLOFF.n39 WLOFF.n36 1.54915
R401 WLOFF.n36 WLOFF.n33 1.54915
R402 WLOFF.n33 WLOFF.n30 1.54915
R403 WLOFF.n30 WLOFF.n27 1.54915
R404 WLOFF.n27 WLOFF.n24 1.54915
R405 WLOFF.n24 WLOFF.n21 1.54915
R406 WLOFF.n21 WLOFF.n18 1.54915
R407 WLOFF.n18 WLOFF.n15 1.54915
R408 WLOFF.n15 WLOFF.n12 1.54915
R409 WLOFF.n12 WLOFF.n9 1.54915
R410 WLOFF.n9 WLOFF.n6 1.54915
R411 WLOFF.n6 WLOFF.n3 1.54915
R412 WLOFF.n3 WLOFF 1.3588
R413 WLOFF.n2 WLOFF 0.68256
R414 WLOFF.n5 WLOFF 0.68256
R415 WLOFF.n8 WLOFF 0.68256
R416 WLOFF.n11 WLOFF 0.68256
R417 WLOFF.n14 WLOFF 0.68256
R418 WLOFF.n17 WLOFF 0.68256
R419 WLOFF.n20 WLOFF 0.68256
R420 WLOFF.n23 WLOFF 0.68256
R421 WLOFF.n26 WLOFF 0.68256
R422 WLOFF.n29 WLOFF 0.68256
R423 WLOFF.n32 WLOFF 0.68256
R424 WLOFF.n35 WLOFF 0.68256
R425 WLOFF.n38 WLOFF 0.68256
R426 WLOFF.n41 WLOFF 0.68256
R427 WLOFF.n44 WLOFF 0.68256
R428 WLOFF.n47 WLOFF 0.68256
R429 WLOFF.n50 WLOFF 0.68256
R430 WLOFF.n53 WLOFF 0.68256
R431 WLOFF.n56 WLOFF 0.68256
R432 WLOFF.n59 WLOFF 0.68256
R433 WLOFF.n62 WLOFF 0.68256
R434 WLOFF.n65 WLOFF 0.68256
R435 WLOFF.n68 WLOFF 0.68256
R436 WLOFF.n71 WLOFF 0.68256
R437 WLOFF.n74 WLOFF 0.68256
R438 WLOFF.n77 WLOFF 0.68256
R439 WLOFF.n80 WLOFF 0.68256
R440 WLOFF.n83 WLOFF 0.68256
R441 WLOFF.n86 WLOFF 0.68256
R442 WLOFF.n89 WLOFF 0.68256
R443 WLOFF.n92 WLOFF 0.68256
R444 WLOFF WLOFF.n94 0.68256
R445 VDD.n2 VDD.t79 671.755
R446 VDD.n7 VDD.t103 671.755
R447 VDD.n12 VDD.t67 671.755
R448 VDD.n17 VDD.t107 671.755
R449 VDD.n22 VDD.t105 671.755
R450 VDD.n27 VDD.t25 671.755
R451 VDD.n32 VDD.t43 671.755
R452 VDD.n37 VDD.t9 671.755
R453 VDD.n42 VDD.t57 671.755
R454 VDD.n47 VDD.t83 671.755
R455 VDD.n52 VDD.t49 671.755
R456 VDD.n57 VDD.t91 671.755
R457 VDD.n62 VDD.t113 671.755
R458 VDD.n67 VDD.t109 671.755
R459 VDD.n72 VDD.t93 671.755
R460 VDD.n77 VDD.t89 671.755
R461 VDD.n82 VDD.t95 671.755
R462 VDD.n87 VDD.t19 671.755
R463 VDD.n92 VDD.t29 671.755
R464 VDD.n97 VDD.t77 671.755
R465 VDD.n102 VDD.t11 671.755
R466 VDD.n107 VDD.t53 671.755
R467 VDD.n112 VDD.t61 671.755
R468 VDD.n117 VDD.t5 671.755
R469 VDD.n122 VDD.t39 671.755
R470 VDD.n127 VDD.t37 671.755
R471 VDD.n132 VDD.t117 671.755
R472 VDD.n137 VDD.t1 671.755
R473 VDD.n142 VDD.t3 671.755
R474 VDD.n147 VDD.t63 671.755
R475 VDD.n152 VDD.t33 671.755
R476 VDD.n156 VDD.t59 671.755
R477 VDD.n0 VDD.t81 671.547
R478 VDD.n5 VDD.t15 671.547
R479 VDD.n10 VDD.t69 671.547
R480 VDD.n15 VDD.t13 671.547
R481 VDD.n20 VDD.t7 671.547
R482 VDD.n25 VDD.t31 671.547
R483 VDD.n30 VDD.t23 671.547
R484 VDD.n35 VDD.t27 671.547
R485 VDD.n40 VDD.t85 671.547
R486 VDD.n45 VDD.t41 671.547
R487 VDD.n50 VDD.t51 671.547
R488 VDD.n55 VDD.t99 671.547
R489 VDD.n60 VDD.t127 671.547
R490 VDD.n65 VDD.t111 671.547
R491 VDD.n70 VDD.t87 671.547
R492 VDD.n75 VDD.t101 671.547
R493 VDD.n80 VDD.t97 671.547
R494 VDD.n85 VDD.t21 671.547
R495 VDD.n90 VDD.t55 671.547
R496 VDD.n95 VDD.t17 671.547
R497 VDD.n100 VDD.t75 671.547
R498 VDD.n105 VDD.t47 671.547
R499 VDD.n110 VDD.t73 671.547
R500 VDD.n115 VDD.t123 671.547
R501 VDD.n120 VDD.t45 671.547
R502 VDD.n125 VDD.t65 671.547
R503 VDD.n130 VDD.t71 671.547
R504 VDD.n135 VDD.t125 671.547
R505 VDD.n140 VDD.t121 671.547
R506 VDD.n145 VDD.t115 671.547
R507 VDD.n150 VDD.t35 671.547
R508 VDD.n158 VDD.t119 671.547
R509 VDD.n3 VDD.t78 185.983
R510 VDD.n8 VDD.t102 185.983
R511 VDD.n13 VDD.t66 185.983
R512 VDD.n18 VDD.t106 185.983
R513 VDD.n23 VDD.t104 185.983
R514 VDD.n28 VDD.t24 185.983
R515 VDD.n33 VDD.t42 185.983
R516 VDD.n38 VDD.t8 185.983
R517 VDD.n43 VDD.t56 185.983
R518 VDD.n48 VDD.t82 185.983
R519 VDD.n53 VDD.t48 185.983
R520 VDD.n58 VDD.t90 185.983
R521 VDD.n63 VDD.t112 185.983
R522 VDD.n68 VDD.t108 185.983
R523 VDD.n73 VDD.t92 185.983
R524 VDD.n78 VDD.t88 185.983
R525 VDD.n83 VDD.t94 185.983
R526 VDD.n88 VDD.t18 185.983
R527 VDD.n93 VDD.t28 185.983
R528 VDD.n98 VDD.t76 185.983
R529 VDD.n103 VDD.t10 185.983
R530 VDD.n108 VDD.t52 185.983
R531 VDD.n113 VDD.t60 185.983
R532 VDD.n118 VDD.t4 185.983
R533 VDD.n123 VDD.t38 185.983
R534 VDD.n128 VDD.t36 185.983
R535 VDD.n133 VDD.t116 185.983
R536 VDD.n138 VDD.t0 185.983
R537 VDD.n143 VDD.t2 185.983
R538 VDD.n148 VDD.t62 185.983
R539 VDD.n153 VDD.t32 185.983
R540 VDD.n155 VDD.t58 185.983
R541 VDD.n1 VDD.t80 185.75
R542 VDD.n6 VDD.t14 185.75
R543 VDD.n11 VDD.t68 185.75
R544 VDD.n16 VDD.t12 185.75
R545 VDD.n21 VDD.t6 185.75
R546 VDD.n26 VDD.t30 185.75
R547 VDD.n31 VDD.t22 185.75
R548 VDD.n36 VDD.t26 185.75
R549 VDD.n41 VDD.t84 185.75
R550 VDD.n46 VDD.t40 185.75
R551 VDD.n51 VDD.t50 185.75
R552 VDD.n56 VDD.t98 185.75
R553 VDD.n61 VDD.t126 185.75
R554 VDD.n66 VDD.t110 185.75
R555 VDD.n71 VDD.t86 185.75
R556 VDD.n76 VDD.t100 185.75
R557 VDD.n81 VDD.t96 185.75
R558 VDD.n86 VDD.t20 185.75
R559 VDD.n91 VDD.t54 185.75
R560 VDD.n96 VDD.t16 185.75
R561 VDD.n101 VDD.t74 185.75
R562 VDD.n106 VDD.t46 185.75
R563 VDD.n111 VDD.t72 185.75
R564 VDD.n116 VDD.t122 185.75
R565 VDD.n121 VDD.t44 185.75
R566 VDD.n126 VDD.t64 185.75
R567 VDD.n131 VDD.t70 185.75
R568 VDD.n136 VDD.t124 185.75
R569 VDD.n141 VDD.t120 185.75
R570 VDD.n146 VDD.t114 185.75
R571 VDD.n151 VDD.t34 185.75
R572 VDD.n157 VDD.t118 185.75
R573 VDD.n155 VDD.n154 4.95915
R574 VDD.n154 VDD.n153 3.4105
R575 VDD.n149 VDD.n148 3.4105
R576 VDD.n144 VDD.n143 3.4105
R577 VDD.n139 VDD.n138 3.4105
R578 VDD.n134 VDD.n133 3.4105
R579 VDD.n129 VDD.n128 3.4105
R580 VDD.n124 VDD.n123 3.4105
R581 VDD.n119 VDD.n118 3.4105
R582 VDD.n114 VDD.n113 3.4105
R583 VDD.n109 VDD.n108 3.4105
R584 VDD.n104 VDD.n103 3.4105
R585 VDD.n99 VDD.n98 3.4105
R586 VDD.n94 VDD.n93 3.4105
R587 VDD.n89 VDD.n88 3.4105
R588 VDD.n84 VDD.n83 3.4105
R589 VDD.n79 VDD.n78 3.4105
R590 VDD.n74 VDD.n73 3.4105
R591 VDD.n69 VDD.n68 3.4105
R592 VDD.n64 VDD.n63 3.4105
R593 VDD.n59 VDD.n58 3.4105
R594 VDD.n54 VDD.n53 3.4105
R595 VDD.n49 VDD.n48 3.4105
R596 VDD.n44 VDD.n43 3.4105
R597 VDD.n39 VDD.n38 3.4105
R598 VDD.n34 VDD.n33 3.4105
R599 VDD.n29 VDD.n28 3.4105
R600 VDD.n24 VDD.n23 3.4105
R601 VDD.n19 VDD.n18 3.4105
R602 VDD.n14 VDD.n13 3.4105
R603 VDD.n9 VDD.n8 3.4105
R604 VDD.n4 VDD.n3 3.4105
R605 VDD.n154 VDD.n149 1.54915
R606 VDD.n149 VDD.n144 1.54915
R607 VDD.n144 VDD.n139 1.54915
R608 VDD.n139 VDD.n134 1.54915
R609 VDD.n134 VDD.n129 1.54915
R610 VDD.n129 VDD.n124 1.54915
R611 VDD.n124 VDD.n119 1.54915
R612 VDD.n119 VDD.n114 1.54915
R613 VDD.n114 VDD.n109 1.54915
R614 VDD.n109 VDD.n104 1.54915
R615 VDD.n104 VDD.n99 1.54915
R616 VDD.n99 VDD.n94 1.54915
R617 VDD.n94 VDD.n89 1.54915
R618 VDD.n89 VDD.n84 1.54915
R619 VDD.n84 VDD.n79 1.54915
R620 VDD.n79 VDD.n74 1.54915
R621 VDD.n74 VDD.n69 1.54915
R622 VDD.n69 VDD.n64 1.54915
R623 VDD.n64 VDD.n59 1.54915
R624 VDD.n59 VDD.n54 1.54915
R625 VDD.n54 VDD.n49 1.54915
R626 VDD.n49 VDD.n44 1.54915
R627 VDD.n44 VDD.n39 1.54915
R628 VDD.n39 VDD.n34 1.54915
R629 VDD.n34 VDD.n29 1.54915
R630 VDD.n29 VDD.n24 1.54915
R631 VDD.n24 VDD.n19 1.54915
R632 VDD.n19 VDD.n14 1.54915
R633 VDD.n14 VDD.n9 1.54915
R634 VDD.n9 VDD.n4 1.54915
R635 VDD.n2 VDD.n1 0.267812
R636 VDD.n7 VDD.n6 0.267812
R637 VDD.n12 VDD.n11 0.267812
R638 VDD.n17 VDD.n16 0.267812
R639 VDD.n22 VDD.n21 0.267812
R640 VDD.n27 VDD.n26 0.267812
R641 VDD.n32 VDD.n31 0.267812
R642 VDD.n37 VDD.n36 0.267812
R643 VDD.n42 VDD.n41 0.267812
R644 VDD.n47 VDD.n46 0.267812
R645 VDD.n52 VDD.n51 0.267812
R646 VDD.n57 VDD.n56 0.267812
R647 VDD.n62 VDD.n61 0.267812
R648 VDD.n67 VDD.n66 0.267812
R649 VDD.n72 VDD.n71 0.267812
R650 VDD.n77 VDD.n76 0.267812
R651 VDD.n82 VDD.n81 0.267812
R652 VDD.n87 VDD.n86 0.267812
R653 VDD.n92 VDD.n91 0.267812
R654 VDD.n97 VDD.n96 0.267812
R655 VDD.n102 VDD.n101 0.267812
R656 VDD.n107 VDD.n106 0.267812
R657 VDD.n112 VDD.n111 0.267812
R658 VDD.n117 VDD.n116 0.267812
R659 VDD.n122 VDD.n121 0.267812
R660 VDD.n127 VDD.n126 0.267812
R661 VDD.n132 VDD.n131 0.267812
R662 VDD.n137 VDD.n136 0.267812
R663 VDD.n142 VDD.n141 0.267812
R664 VDD.n147 VDD.n146 0.267812
R665 VDD.n152 VDD.n151 0.267812
R666 VDD.n157 VDD.n156 0.267812
R667 VDD.n0 VDD 0.143179
R668 VDD.n5 VDD 0.143179
R669 VDD.n10 VDD 0.143179
R670 VDD.n15 VDD 0.143179
R671 VDD.n20 VDD 0.143179
R672 VDD.n25 VDD 0.143179
R673 VDD.n30 VDD 0.143179
R674 VDD.n35 VDD 0.143179
R675 VDD.n40 VDD 0.143179
R676 VDD.n45 VDD 0.143179
R677 VDD.n50 VDD 0.143179
R678 VDD.n55 VDD 0.143179
R679 VDD.n60 VDD 0.143179
R680 VDD.n65 VDD 0.143179
R681 VDD.n70 VDD 0.143179
R682 VDD.n75 VDD 0.143179
R683 VDD.n80 VDD 0.143179
R684 VDD.n85 VDD 0.143179
R685 VDD.n90 VDD 0.143179
R686 VDD.n95 VDD 0.143179
R687 VDD.n100 VDD 0.143179
R688 VDD.n105 VDD 0.143179
R689 VDD.n110 VDD 0.143179
R690 VDD.n115 VDD 0.143179
R691 VDD.n120 VDD 0.143179
R692 VDD.n125 VDD 0.143179
R693 VDD.n130 VDD 0.143179
R694 VDD.n135 VDD 0.143179
R695 VDD.n140 VDD 0.143179
R696 VDD.n145 VDD 0.143179
R697 VDD.n150 VDD 0.143179
R698 VDD VDD.n158 0.143179
R699 VDD.n1 VDD.n0 0.0900238
R700 VDD.n6 VDD.n5 0.0900238
R701 VDD.n11 VDD.n10 0.0900238
R702 VDD.n16 VDD.n15 0.0900238
R703 VDD.n21 VDD.n20 0.0900238
R704 VDD.n26 VDD.n25 0.0900238
R705 VDD.n31 VDD.n30 0.0900238
R706 VDD.n36 VDD.n35 0.0900238
R707 VDD.n41 VDD.n40 0.0900238
R708 VDD.n46 VDD.n45 0.0900238
R709 VDD.n51 VDD.n50 0.0900238
R710 VDD.n56 VDD.n55 0.0900238
R711 VDD.n61 VDD.n60 0.0900238
R712 VDD.n66 VDD.n65 0.0900238
R713 VDD.n71 VDD.n70 0.0900238
R714 VDD.n76 VDD.n75 0.0900238
R715 VDD.n81 VDD.n80 0.0900238
R716 VDD.n86 VDD.n85 0.0900238
R717 VDD.n91 VDD.n90 0.0900238
R718 VDD.n96 VDD.n95 0.0900238
R719 VDD.n101 VDD.n100 0.0900238
R720 VDD.n106 VDD.n105 0.0900238
R721 VDD.n111 VDD.n110 0.0900238
R722 VDD.n116 VDD.n115 0.0900238
R723 VDD.n121 VDD.n120 0.0900238
R724 VDD.n126 VDD.n125 0.0900238
R725 VDD.n131 VDD.n130 0.0900238
R726 VDD.n136 VDD.n135 0.0900238
R727 VDD.n141 VDD.n140 0.0900238
R728 VDD.n146 VDD.n145 0.0900238
R729 VDD.n151 VDD.n150 0.0900238
R730 VDD.n158 VDD.n157 0.0900238
R731 VDD.n4 VDD 0.0663
R732 VDD.n3 VDD.n2 0.0151875
R733 VDD.n8 VDD.n7 0.0151875
R734 VDD.n13 VDD.n12 0.0151875
R735 VDD.n18 VDD.n17 0.0151875
R736 VDD.n23 VDD.n22 0.0151875
R737 VDD.n28 VDD.n27 0.0151875
R738 VDD.n33 VDD.n32 0.0151875
R739 VDD.n38 VDD.n37 0.0151875
R740 VDD.n43 VDD.n42 0.0151875
R741 VDD.n48 VDD.n47 0.0151875
R742 VDD.n53 VDD.n52 0.0151875
R743 VDD.n58 VDD.n57 0.0151875
R744 VDD.n63 VDD.n62 0.0151875
R745 VDD.n68 VDD.n67 0.0151875
R746 VDD.n73 VDD.n72 0.0151875
R747 VDD.n78 VDD.n77 0.0151875
R748 VDD.n83 VDD.n82 0.0151875
R749 VDD.n88 VDD.n87 0.0151875
R750 VDD.n93 VDD.n92 0.0151875
R751 VDD.n98 VDD.n97 0.0151875
R752 VDD.n103 VDD.n102 0.0151875
R753 VDD.n108 VDD.n107 0.0151875
R754 VDD.n113 VDD.n112 0.0151875
R755 VDD.n118 VDD.n117 0.0151875
R756 VDD.n123 VDD.n122 0.0151875
R757 VDD.n128 VDD.n127 0.0151875
R758 VDD.n133 VDD.n132 0.0151875
R759 VDD.n138 VDD.n137 0.0151875
R760 VDD.n143 VDD.n142 0.0151875
R761 VDD.n148 VDD.n147 0.0151875
R762 VDD.n153 VDD.n152 0.0151875
R763 VDD.n156 VDD.n155 0.0151875
R764 VSS.n1048 VSS.n4 11727.9
R765 VSS.n139 VSS.n4 8618.21
R766 VSS.n858 VSS.n113 8261.87
R767 VSS.n128 VSS.n4 8261.87
R768 VSS.n128 VSS.n8 8261.87
R769 VSS.n1040 VSS.n8 8261.87
R770 VSS.n1040 VSS.n1039 8261.87
R771 VSS.n1039 VSS.n10 8261.87
R772 VSS.n23 VSS.n10 8261.87
R773 VSS.n1014 VSS.n23 8261.87
R774 VSS.n1014 VSS.n1013 8261.87
R775 VSS.n1013 VSS.n25 8261.87
R776 VSS.n38 VSS.n25 8261.87
R777 VSS.n988 VSS.n38 8261.87
R778 VSS.n988 VSS.n987 8261.87
R779 VSS.n987 VSS.n40 8261.87
R780 VSS.n53 VSS.n40 8261.87
R781 VSS.n962 VSS.n53 8261.87
R782 VSS.n962 VSS.n961 8261.87
R783 VSS.n961 VSS.n55 8261.87
R784 VSS.n68 VSS.n55 8261.87
R785 VSS.n936 VSS.n68 8261.87
R786 VSS.n936 VSS.n935 8261.87
R787 VSS.n935 VSS.n70 8261.87
R788 VSS.n83 VSS.n70 8261.87
R789 VSS.n910 VSS.n83 8261.87
R790 VSS.n910 VSS.n909 8261.87
R791 VSS.n909 VSS.n85 8261.87
R792 VSS.n98 VSS.n85 8261.87
R793 VSS.n884 VSS.n98 8261.87
R794 VSS.n884 VSS.n883 8261.87
R795 VSS.n883 VSS.n100 8261.87
R796 VSS.n114 VSS.n100 8261.87
R797 VSS.n858 VSS.n114 8261.87
R798 VSS.n864 VSS.n111 5914
R799 VSS.n1048 VSS.n1047 5231.89
R800 VSS.n1047 VSS.n1046 5231.89
R801 VSS.n1046 VSS.n6 5231.89
R802 VSS.n1022 VSS.n6 5231.89
R803 VSS.n1022 VSS.n1021 5231.89
R804 VSS.n1021 VSS.n1020 5231.89
R805 VSS.n1020 VSS.n21 5231.89
R806 VSS.n996 VSS.n21 5231.89
R807 VSS.n996 VSS.n995 5231.89
R808 VSS.n995 VSS.n994 5231.89
R809 VSS.n994 VSS.n36 5231.89
R810 VSS.n970 VSS.n36 5231.89
R811 VSS.n970 VSS.n969 5231.89
R812 VSS.n969 VSS.n968 5231.89
R813 VSS.n968 VSS.n51 5231.89
R814 VSS.n944 VSS.n51 5231.89
R815 VSS.n944 VSS.n943 5231.89
R816 VSS.n943 VSS.n942 5231.89
R817 VSS.n942 VSS.n66 5231.89
R818 VSS.n918 VSS.n66 5231.89
R819 VSS.n918 VSS.n917 5231.89
R820 VSS.n917 VSS.n916 5231.89
R821 VSS.n916 VSS.n81 5231.89
R822 VSS.n892 VSS.n81 5231.89
R823 VSS.n892 VSS.n891 5231.89
R824 VSS.n891 VSS.n890 5231.89
R825 VSS.n890 VSS.n96 5231.89
R826 VSS.n866 VSS.n96 5231.89
R827 VSS.n866 VSS.n865 5231.89
R828 VSS.n865 VSS.n864 5231.89
R829 VSS.n860 VSS.n112 2456.71
R830 VSS.n862 VSS.n112 2456.71
R831 VSS.n861 VSS.n860 2456.71
R832 VSS.n862 VSS.n861 2456.71
R833 VSS.n854 VSS.n115 2456.71
R834 VSS.n856 VSS.n115 2456.71
R835 VSS.n855 VSS.n854 2456.71
R836 VSS.n856 VSS.n855 2456.71
R837 VSS.n817 VSS.n813 2456.71
R838 VSS.n817 VSS.n814 2456.71
R839 VSS.n816 VSS.n813 2456.71
R840 VSS.n816 VSS.n814 2456.71
R841 VSS.n836 VSS.n832 2456.71
R842 VSS.n834 VSS.n832 2456.71
R843 VSS.n836 VSS.n835 2456.71
R844 VSS.n835 VSS.n834 2456.71
R845 VSS.n788 VSS.n784 2456.71
R846 VSS.n788 VSS.n785 2456.71
R847 VSS.n787 VSS.n784 2456.71
R848 VSS.n787 VSS.n785 2456.71
R849 VSS.n800 VSS.n796 2456.71
R850 VSS.n798 VSS.n796 2456.71
R851 VSS.n800 VSS.n799 2456.71
R852 VSS.n799 VSS.n798 2456.71
R853 VSS.n869 VSS.n107 2456.71
R854 VSS.n869 VSS.n108 2456.71
R855 VSS.n868 VSS.n107 2456.71
R856 VSS.n868 VSS.n108 2456.71
R857 VSS.n771 VSS.n767 2456.71
R858 VSS.n769 VSS.n767 2456.71
R859 VSS.n771 VSS.n770 2456.71
R860 VSS.n770 VSS.n769 2456.71
R861 VSS.n881 VSS.n877 2456.71
R862 VSS.n879 VSS.n877 2456.71
R863 VSS.n881 VSS.n880 2456.71
R864 VSS.n880 VSS.n879 2456.71
R865 VSS.n751 VSS.n748 2456.71
R866 VSS.n749 VSS.n748 2456.71
R867 VSS.n751 VSS.n750 2456.71
R868 VSS.n750 VSS.n749 2456.71
R869 VSS.n886 VSS.n97 2456.71
R870 VSS.n888 VSS.n97 2456.71
R871 VSS.n887 VSS.n886 2456.71
R872 VSS.n888 VSS.n887 2456.71
R873 VSS.n732 VSS.n729 2456.71
R874 VSS.n730 VSS.n729 2456.71
R875 VSS.n732 VSS.n731 2456.71
R876 VSS.n731 VSS.n730 2456.71
R877 VSS.n697 VSS.n693 2456.71
R878 VSS.n697 VSS.n694 2456.71
R879 VSS.n696 VSS.n693 2456.71
R880 VSS.n696 VSS.n694 2456.71
R881 VSS.n709 VSS.n705 2456.71
R882 VSS.n707 VSS.n705 2456.71
R883 VSS.n709 VSS.n708 2456.71
R884 VSS.n708 VSS.n707 2456.71
R885 VSS.n895 VSS.n92 2456.71
R886 VSS.n895 VSS.n93 2456.71
R887 VSS.n894 VSS.n92 2456.71
R888 VSS.n894 VSS.n93 2456.71
R889 VSS.n680 VSS.n676 2456.71
R890 VSS.n678 VSS.n676 2456.71
R891 VSS.n680 VSS.n679 2456.71
R892 VSS.n679 VSS.n678 2456.71
R893 VSS.n907 VSS.n903 2456.71
R894 VSS.n905 VSS.n903 2456.71
R895 VSS.n907 VSS.n906 2456.71
R896 VSS.n906 VSS.n905 2456.71
R897 VSS.n660 VSS.n657 2456.71
R898 VSS.n658 VSS.n657 2456.71
R899 VSS.n660 VSS.n659 2456.71
R900 VSS.n659 VSS.n658 2456.71
R901 VSS.n912 VSS.n82 2456.71
R902 VSS.n914 VSS.n82 2456.71
R903 VSS.n913 VSS.n912 2456.71
R904 VSS.n914 VSS.n913 2456.71
R905 VSS.n641 VSS.n638 2456.71
R906 VSS.n639 VSS.n638 2456.71
R907 VSS.n641 VSS.n640 2456.71
R908 VSS.n640 VSS.n639 2456.71
R909 VSS.n606 VSS.n602 2456.71
R910 VSS.n606 VSS.n603 2456.71
R911 VSS.n605 VSS.n602 2456.71
R912 VSS.n605 VSS.n603 2456.71
R913 VSS.n618 VSS.n614 2456.71
R914 VSS.n616 VSS.n614 2456.71
R915 VSS.n618 VSS.n617 2456.71
R916 VSS.n617 VSS.n616 2456.71
R917 VSS.n921 VSS.n77 2456.71
R918 VSS.n921 VSS.n78 2456.71
R919 VSS.n920 VSS.n77 2456.71
R920 VSS.n920 VSS.n78 2456.71
R921 VSS.n589 VSS.n585 2456.71
R922 VSS.n587 VSS.n585 2456.71
R923 VSS.n589 VSS.n588 2456.71
R924 VSS.n588 VSS.n587 2456.71
R925 VSS.n933 VSS.n929 2456.71
R926 VSS.n931 VSS.n929 2456.71
R927 VSS.n933 VSS.n932 2456.71
R928 VSS.n932 VSS.n931 2456.71
R929 VSS.n569 VSS.n566 2456.71
R930 VSS.n567 VSS.n566 2456.71
R931 VSS.n569 VSS.n568 2456.71
R932 VSS.n568 VSS.n567 2456.71
R933 VSS.n938 VSS.n67 2456.71
R934 VSS.n940 VSS.n67 2456.71
R935 VSS.n939 VSS.n938 2456.71
R936 VSS.n940 VSS.n939 2456.71
R937 VSS.n550 VSS.n547 2456.71
R938 VSS.n548 VSS.n547 2456.71
R939 VSS.n550 VSS.n549 2456.71
R940 VSS.n549 VSS.n548 2456.71
R941 VSS.n515 VSS.n511 2456.71
R942 VSS.n515 VSS.n512 2456.71
R943 VSS.n514 VSS.n511 2456.71
R944 VSS.n514 VSS.n512 2456.71
R945 VSS.n527 VSS.n523 2456.71
R946 VSS.n525 VSS.n523 2456.71
R947 VSS.n527 VSS.n526 2456.71
R948 VSS.n526 VSS.n525 2456.71
R949 VSS.n947 VSS.n62 2456.71
R950 VSS.n947 VSS.n63 2456.71
R951 VSS.n946 VSS.n62 2456.71
R952 VSS.n946 VSS.n63 2456.71
R953 VSS.n498 VSS.n494 2456.71
R954 VSS.n496 VSS.n494 2456.71
R955 VSS.n498 VSS.n497 2456.71
R956 VSS.n497 VSS.n496 2456.71
R957 VSS.n959 VSS.n955 2456.71
R958 VSS.n957 VSS.n955 2456.71
R959 VSS.n959 VSS.n958 2456.71
R960 VSS.n958 VSS.n957 2456.71
R961 VSS.n478 VSS.n475 2456.71
R962 VSS.n476 VSS.n475 2456.71
R963 VSS.n478 VSS.n477 2456.71
R964 VSS.n477 VSS.n476 2456.71
R965 VSS.n964 VSS.n52 2456.71
R966 VSS.n966 VSS.n52 2456.71
R967 VSS.n965 VSS.n964 2456.71
R968 VSS.n966 VSS.n965 2456.71
R969 VSS.n459 VSS.n456 2456.71
R970 VSS.n457 VSS.n456 2456.71
R971 VSS.n459 VSS.n458 2456.71
R972 VSS.n458 VSS.n457 2456.71
R973 VSS.n424 VSS.n420 2456.71
R974 VSS.n424 VSS.n421 2456.71
R975 VSS.n423 VSS.n420 2456.71
R976 VSS.n423 VSS.n421 2456.71
R977 VSS.n436 VSS.n432 2456.71
R978 VSS.n434 VSS.n432 2456.71
R979 VSS.n436 VSS.n435 2456.71
R980 VSS.n435 VSS.n434 2456.71
R981 VSS.n973 VSS.n47 2456.71
R982 VSS.n973 VSS.n48 2456.71
R983 VSS.n972 VSS.n47 2456.71
R984 VSS.n972 VSS.n48 2456.71
R985 VSS.n407 VSS.n403 2456.71
R986 VSS.n405 VSS.n403 2456.71
R987 VSS.n407 VSS.n406 2456.71
R988 VSS.n406 VSS.n405 2456.71
R989 VSS.n985 VSS.n981 2456.71
R990 VSS.n983 VSS.n981 2456.71
R991 VSS.n985 VSS.n984 2456.71
R992 VSS.n984 VSS.n983 2456.71
R993 VSS.n387 VSS.n384 2456.71
R994 VSS.n385 VSS.n384 2456.71
R995 VSS.n387 VSS.n386 2456.71
R996 VSS.n386 VSS.n385 2456.71
R997 VSS.n990 VSS.n37 2456.71
R998 VSS.n992 VSS.n37 2456.71
R999 VSS.n991 VSS.n990 2456.71
R1000 VSS.n992 VSS.n991 2456.71
R1001 VSS.n368 VSS.n365 2456.71
R1002 VSS.n366 VSS.n365 2456.71
R1003 VSS.n368 VSS.n367 2456.71
R1004 VSS.n367 VSS.n366 2456.71
R1005 VSS.n333 VSS.n329 2456.71
R1006 VSS.n333 VSS.n330 2456.71
R1007 VSS.n332 VSS.n329 2456.71
R1008 VSS.n332 VSS.n330 2456.71
R1009 VSS.n345 VSS.n341 2456.71
R1010 VSS.n343 VSS.n341 2456.71
R1011 VSS.n345 VSS.n344 2456.71
R1012 VSS.n344 VSS.n343 2456.71
R1013 VSS.n999 VSS.n32 2456.71
R1014 VSS.n999 VSS.n33 2456.71
R1015 VSS.n998 VSS.n32 2456.71
R1016 VSS.n998 VSS.n33 2456.71
R1017 VSS.n316 VSS.n312 2456.71
R1018 VSS.n314 VSS.n312 2456.71
R1019 VSS.n316 VSS.n315 2456.71
R1020 VSS.n315 VSS.n314 2456.71
R1021 VSS.n1011 VSS.n1007 2456.71
R1022 VSS.n1009 VSS.n1007 2456.71
R1023 VSS.n1011 VSS.n1010 2456.71
R1024 VSS.n1010 VSS.n1009 2456.71
R1025 VSS.n296 VSS.n293 2456.71
R1026 VSS.n294 VSS.n293 2456.71
R1027 VSS.n296 VSS.n295 2456.71
R1028 VSS.n295 VSS.n294 2456.71
R1029 VSS.n1016 VSS.n22 2456.71
R1030 VSS.n1018 VSS.n22 2456.71
R1031 VSS.n1017 VSS.n1016 2456.71
R1032 VSS.n1018 VSS.n1017 2456.71
R1033 VSS.n277 VSS.n274 2456.71
R1034 VSS.n275 VSS.n274 2456.71
R1035 VSS.n277 VSS.n276 2456.71
R1036 VSS.n276 VSS.n275 2456.71
R1037 VSS.n242 VSS.n238 2456.71
R1038 VSS.n242 VSS.n239 2456.71
R1039 VSS.n241 VSS.n238 2456.71
R1040 VSS.n241 VSS.n239 2456.71
R1041 VSS.n254 VSS.n250 2456.71
R1042 VSS.n252 VSS.n250 2456.71
R1043 VSS.n254 VSS.n253 2456.71
R1044 VSS.n253 VSS.n252 2456.71
R1045 VSS.n1025 VSS.n17 2456.71
R1046 VSS.n1025 VSS.n18 2456.71
R1047 VSS.n1024 VSS.n17 2456.71
R1048 VSS.n1024 VSS.n18 2456.71
R1049 VSS.n225 VSS.n221 2456.71
R1050 VSS.n223 VSS.n221 2456.71
R1051 VSS.n225 VSS.n224 2456.71
R1052 VSS.n224 VSS.n223 2456.71
R1053 VSS.n1037 VSS.n1033 2456.71
R1054 VSS.n1035 VSS.n1033 2456.71
R1055 VSS.n1037 VSS.n1036 2456.71
R1056 VSS.n1036 VSS.n1035 2456.71
R1057 VSS.n205 VSS.n202 2456.71
R1058 VSS.n203 VSS.n202 2456.71
R1059 VSS.n205 VSS.n204 2456.71
R1060 VSS.n204 VSS.n203 2456.71
R1061 VSS.n1042 VSS.n7 2456.71
R1062 VSS.n1044 VSS.n7 2456.71
R1063 VSS.n1043 VSS.n1042 2456.71
R1064 VSS.n1044 VSS.n1043 2456.71
R1065 VSS.n186 VSS.n183 2456.71
R1066 VSS.n184 VSS.n183 2456.71
R1067 VSS.n186 VSS.n185 2456.71
R1068 VSS.n185 VSS.n184 2456.71
R1069 VSS.n149 VSS.n145 2456.71
R1070 VSS.n149 VSS.n146 2456.71
R1071 VSS.n148 VSS.n145 2456.71
R1072 VSS.n148 VSS.n146 2456.71
R1073 VSS.n163 VSS.n159 2456.71
R1074 VSS.n161 VSS.n159 2456.71
R1075 VSS.n163 VSS.n162 2456.71
R1076 VSS.n162 VSS.n161 2456.71
R1077 VSS.n1051 VSS.n1 2456.71
R1078 VSS.n1051 VSS.n2 2456.71
R1079 VSS.n1050 VSS.n1 2456.71
R1080 VSS.n1050 VSS.n2 2456.71
R1081 VSS.n132 VSS.n127 2456.71
R1082 VSS.n130 VSS.n127 2456.71
R1083 VSS.n132 VSS.n131 2456.71
R1084 VSS.n131 VSS.n130 2456.71
R1085 VSS.n840 VSS.n829 2074.29
R1086 VSS.n840 VSS.n830 2074.29
R1087 VSS.n839 VSS.n829 2074.29
R1088 VSS.n839 VSS.n830 2074.29
R1089 VSS.n849 VSS.n116 2074.29
R1090 VSS.n851 VSS.n116 2074.29
R1091 VSS.n850 VSS.n849 2074.29
R1092 VSS.n851 VSS.n850 2074.29
R1093 VSS.n844 VSS.n117 2074.29
R1094 VSS.n846 VSS.n117 2074.29
R1095 VSS.n845 VSS.n844 2074.29
R1096 VSS.n846 VSS.n845 2074.29
R1097 VSS.n804 VSS.n793 2074.29
R1098 VSS.n804 VSS.n794 2074.29
R1099 VSS.n803 VSS.n793 2074.29
R1100 VSS.n803 VSS.n794 2074.29
R1101 VSS.n806 VSS.n779 2074.29
R1102 VSS.n806 VSS.n782 2074.29
R1103 VSS.n781 VSS.n779 2074.29
R1104 VSS.n782 VSS.n781 2074.29
R1105 VSS.n775 VSS.n764 2074.29
R1106 VSS.n775 VSS.n765 2074.29
R1107 VSS.n774 VSS.n764 2074.29
R1108 VSS.n774 VSS.n765 2074.29
R1109 VSS.n777 VSS.n759 2074.29
R1110 VSS.n777 VSS.n762 2074.29
R1111 VSS.n761 VSS.n759 2074.29
R1112 VSS.n762 VSS.n761 2074.29
R1113 VSS.n755 VSS.n745 2074.29
R1114 VSS.n755 VSS.n746 2074.29
R1115 VSS.n754 VSS.n745 2074.29
R1116 VSS.n754 VSS.n746 2074.29
R1117 VSS.n757 VSS.n740 2074.29
R1118 VSS.n757 VSS.n743 2074.29
R1119 VSS.n742 VSS.n740 2074.29
R1120 VSS.n743 VSS.n742 2074.29
R1121 VSS.n736 VSS.n726 2074.29
R1122 VSS.n736 VSS.n727 2074.29
R1123 VSS.n735 VSS.n726 2074.29
R1124 VSS.n735 VSS.n727 2074.29
R1125 VSS.n738 VSS.n717 2074.29
R1126 VSS.n738 VSS.n720 2074.29
R1127 VSS.n719 VSS.n717 2074.29
R1128 VSS.n720 VSS.n719 2074.29
R1129 VSS.n713 VSS.n702 2074.29
R1130 VSS.n713 VSS.n703 2074.29
R1131 VSS.n712 VSS.n702 2074.29
R1132 VSS.n712 VSS.n703 2074.29
R1133 VSS.n715 VSS.n688 2074.29
R1134 VSS.n715 VSS.n691 2074.29
R1135 VSS.n690 VSS.n688 2074.29
R1136 VSS.n691 VSS.n690 2074.29
R1137 VSS.n684 VSS.n673 2074.29
R1138 VSS.n684 VSS.n674 2074.29
R1139 VSS.n683 VSS.n673 2074.29
R1140 VSS.n683 VSS.n674 2074.29
R1141 VSS.n686 VSS.n668 2074.29
R1142 VSS.n686 VSS.n671 2074.29
R1143 VSS.n670 VSS.n668 2074.29
R1144 VSS.n671 VSS.n670 2074.29
R1145 VSS.n664 VSS.n654 2074.29
R1146 VSS.n664 VSS.n655 2074.29
R1147 VSS.n663 VSS.n654 2074.29
R1148 VSS.n663 VSS.n655 2074.29
R1149 VSS.n666 VSS.n649 2074.29
R1150 VSS.n666 VSS.n652 2074.29
R1151 VSS.n651 VSS.n649 2074.29
R1152 VSS.n652 VSS.n651 2074.29
R1153 VSS.n645 VSS.n635 2074.29
R1154 VSS.n645 VSS.n636 2074.29
R1155 VSS.n644 VSS.n635 2074.29
R1156 VSS.n644 VSS.n636 2074.29
R1157 VSS.n647 VSS.n626 2074.29
R1158 VSS.n647 VSS.n629 2074.29
R1159 VSS.n628 VSS.n626 2074.29
R1160 VSS.n629 VSS.n628 2074.29
R1161 VSS.n622 VSS.n611 2074.29
R1162 VSS.n622 VSS.n612 2074.29
R1163 VSS.n621 VSS.n611 2074.29
R1164 VSS.n621 VSS.n612 2074.29
R1165 VSS.n624 VSS.n597 2074.29
R1166 VSS.n624 VSS.n600 2074.29
R1167 VSS.n599 VSS.n597 2074.29
R1168 VSS.n600 VSS.n599 2074.29
R1169 VSS.n593 VSS.n582 2074.29
R1170 VSS.n593 VSS.n583 2074.29
R1171 VSS.n592 VSS.n582 2074.29
R1172 VSS.n592 VSS.n583 2074.29
R1173 VSS.n595 VSS.n577 2074.29
R1174 VSS.n595 VSS.n580 2074.29
R1175 VSS.n579 VSS.n577 2074.29
R1176 VSS.n580 VSS.n579 2074.29
R1177 VSS.n573 VSS.n563 2074.29
R1178 VSS.n573 VSS.n564 2074.29
R1179 VSS.n572 VSS.n563 2074.29
R1180 VSS.n572 VSS.n564 2074.29
R1181 VSS.n575 VSS.n558 2074.29
R1182 VSS.n575 VSS.n561 2074.29
R1183 VSS.n560 VSS.n558 2074.29
R1184 VSS.n561 VSS.n560 2074.29
R1185 VSS.n554 VSS.n544 2074.29
R1186 VSS.n554 VSS.n545 2074.29
R1187 VSS.n553 VSS.n544 2074.29
R1188 VSS.n553 VSS.n545 2074.29
R1189 VSS.n556 VSS.n535 2074.29
R1190 VSS.n556 VSS.n538 2074.29
R1191 VSS.n537 VSS.n535 2074.29
R1192 VSS.n538 VSS.n537 2074.29
R1193 VSS.n531 VSS.n520 2074.29
R1194 VSS.n531 VSS.n521 2074.29
R1195 VSS.n530 VSS.n520 2074.29
R1196 VSS.n530 VSS.n521 2074.29
R1197 VSS.n533 VSS.n506 2074.29
R1198 VSS.n533 VSS.n509 2074.29
R1199 VSS.n508 VSS.n506 2074.29
R1200 VSS.n509 VSS.n508 2074.29
R1201 VSS.n502 VSS.n491 2074.29
R1202 VSS.n502 VSS.n492 2074.29
R1203 VSS.n501 VSS.n491 2074.29
R1204 VSS.n501 VSS.n492 2074.29
R1205 VSS.n504 VSS.n486 2074.29
R1206 VSS.n504 VSS.n489 2074.29
R1207 VSS.n488 VSS.n486 2074.29
R1208 VSS.n489 VSS.n488 2074.29
R1209 VSS.n482 VSS.n472 2074.29
R1210 VSS.n482 VSS.n473 2074.29
R1211 VSS.n481 VSS.n472 2074.29
R1212 VSS.n481 VSS.n473 2074.29
R1213 VSS.n484 VSS.n467 2074.29
R1214 VSS.n484 VSS.n470 2074.29
R1215 VSS.n469 VSS.n467 2074.29
R1216 VSS.n470 VSS.n469 2074.29
R1217 VSS.n463 VSS.n453 2074.29
R1218 VSS.n463 VSS.n454 2074.29
R1219 VSS.n462 VSS.n453 2074.29
R1220 VSS.n462 VSS.n454 2074.29
R1221 VSS.n465 VSS.n444 2074.29
R1222 VSS.n465 VSS.n447 2074.29
R1223 VSS.n446 VSS.n444 2074.29
R1224 VSS.n447 VSS.n446 2074.29
R1225 VSS.n440 VSS.n429 2074.29
R1226 VSS.n440 VSS.n430 2074.29
R1227 VSS.n439 VSS.n429 2074.29
R1228 VSS.n439 VSS.n430 2074.29
R1229 VSS.n442 VSS.n415 2074.29
R1230 VSS.n442 VSS.n418 2074.29
R1231 VSS.n417 VSS.n415 2074.29
R1232 VSS.n418 VSS.n417 2074.29
R1233 VSS.n411 VSS.n400 2074.29
R1234 VSS.n411 VSS.n401 2074.29
R1235 VSS.n410 VSS.n400 2074.29
R1236 VSS.n410 VSS.n401 2074.29
R1237 VSS.n413 VSS.n395 2074.29
R1238 VSS.n413 VSS.n398 2074.29
R1239 VSS.n397 VSS.n395 2074.29
R1240 VSS.n398 VSS.n397 2074.29
R1241 VSS.n391 VSS.n381 2074.29
R1242 VSS.n391 VSS.n382 2074.29
R1243 VSS.n390 VSS.n381 2074.29
R1244 VSS.n390 VSS.n382 2074.29
R1245 VSS.n393 VSS.n376 2074.29
R1246 VSS.n393 VSS.n379 2074.29
R1247 VSS.n378 VSS.n376 2074.29
R1248 VSS.n379 VSS.n378 2074.29
R1249 VSS.n372 VSS.n362 2074.29
R1250 VSS.n372 VSS.n363 2074.29
R1251 VSS.n371 VSS.n362 2074.29
R1252 VSS.n371 VSS.n363 2074.29
R1253 VSS.n374 VSS.n353 2074.29
R1254 VSS.n374 VSS.n356 2074.29
R1255 VSS.n355 VSS.n353 2074.29
R1256 VSS.n356 VSS.n355 2074.29
R1257 VSS.n349 VSS.n338 2074.29
R1258 VSS.n349 VSS.n339 2074.29
R1259 VSS.n348 VSS.n338 2074.29
R1260 VSS.n348 VSS.n339 2074.29
R1261 VSS.n351 VSS.n324 2074.29
R1262 VSS.n351 VSS.n327 2074.29
R1263 VSS.n326 VSS.n324 2074.29
R1264 VSS.n327 VSS.n326 2074.29
R1265 VSS.n320 VSS.n309 2074.29
R1266 VSS.n320 VSS.n310 2074.29
R1267 VSS.n319 VSS.n309 2074.29
R1268 VSS.n319 VSS.n310 2074.29
R1269 VSS.n322 VSS.n304 2074.29
R1270 VSS.n322 VSS.n307 2074.29
R1271 VSS.n306 VSS.n304 2074.29
R1272 VSS.n307 VSS.n306 2074.29
R1273 VSS.n300 VSS.n290 2074.29
R1274 VSS.n300 VSS.n291 2074.29
R1275 VSS.n299 VSS.n290 2074.29
R1276 VSS.n299 VSS.n291 2074.29
R1277 VSS.n302 VSS.n285 2074.29
R1278 VSS.n302 VSS.n288 2074.29
R1279 VSS.n287 VSS.n285 2074.29
R1280 VSS.n288 VSS.n287 2074.29
R1281 VSS.n281 VSS.n271 2074.29
R1282 VSS.n281 VSS.n272 2074.29
R1283 VSS.n280 VSS.n271 2074.29
R1284 VSS.n280 VSS.n272 2074.29
R1285 VSS.n283 VSS.n262 2074.29
R1286 VSS.n283 VSS.n265 2074.29
R1287 VSS.n264 VSS.n262 2074.29
R1288 VSS.n265 VSS.n264 2074.29
R1289 VSS.n258 VSS.n247 2074.29
R1290 VSS.n258 VSS.n248 2074.29
R1291 VSS.n257 VSS.n247 2074.29
R1292 VSS.n257 VSS.n248 2074.29
R1293 VSS.n260 VSS.n233 2074.29
R1294 VSS.n260 VSS.n236 2074.29
R1295 VSS.n235 VSS.n233 2074.29
R1296 VSS.n236 VSS.n235 2074.29
R1297 VSS.n229 VSS.n218 2074.29
R1298 VSS.n229 VSS.n219 2074.29
R1299 VSS.n228 VSS.n218 2074.29
R1300 VSS.n228 VSS.n219 2074.29
R1301 VSS.n231 VSS.n213 2074.29
R1302 VSS.n231 VSS.n216 2074.29
R1303 VSS.n215 VSS.n213 2074.29
R1304 VSS.n216 VSS.n215 2074.29
R1305 VSS.n209 VSS.n199 2074.29
R1306 VSS.n209 VSS.n200 2074.29
R1307 VSS.n208 VSS.n199 2074.29
R1308 VSS.n208 VSS.n200 2074.29
R1309 VSS.n211 VSS.n194 2074.29
R1310 VSS.n211 VSS.n197 2074.29
R1311 VSS.n196 VSS.n194 2074.29
R1312 VSS.n197 VSS.n196 2074.29
R1313 VSS.n190 VSS.n180 2074.29
R1314 VSS.n190 VSS.n181 2074.29
R1315 VSS.n189 VSS.n180 2074.29
R1316 VSS.n189 VSS.n181 2074.29
R1317 VSS.n192 VSS.n171 2074.29
R1318 VSS.n192 VSS.n174 2074.29
R1319 VSS.n173 VSS.n171 2074.29
R1320 VSS.n174 VSS.n173 2074.29
R1321 VSS.n167 VSS.n156 2074.29
R1322 VSS.n167 VSS.n157 2074.29
R1323 VSS.n166 VSS.n156 2074.29
R1324 VSS.n166 VSS.n157 2074.29
R1325 VSS.n169 VSS.n140 2074.29
R1326 VSS.n169 VSS.n143 2074.29
R1327 VSS.n142 VSS.n140 2074.29
R1328 VSS.n143 VSS.n142 2074.29
R1329 VSS.n136 VSS.n124 2074.29
R1330 VSS.n136 VSS.n125 2074.29
R1331 VSS.n135 VSS.n124 2074.29
R1332 VSS.n135 VSS.n125 2074.29
R1333 VSS.n138 VSS.n118 2074.29
R1334 VSS.n138 VSS.n121 2074.29
R1335 VSS.n120 VSS.n118 2074.29
R1336 VSS.n121 VSS.n120 2074.29
R1337 VSS.n842 VSS.n811 2074.29
R1338 VSS.n811 VSS.n810 2074.29
R1339 VSS.n810 VSS.n808 2074.29
R1340 VSS.n842 VSS.n808 2074.29
R1341 VSS.n843 VSS.n807 1215.88
R1342 VSS.n807 VSS.n778 1215.88
R1343 VSS.n778 VSS.n758 1215.88
R1344 VSS.n758 VSS.n739 1215.88
R1345 VSS.n739 VSS.n716 1215.88
R1346 VSS.n716 VSS.n687 1215.88
R1347 VSS.n687 VSS.n667 1215.88
R1348 VSS.n667 VSS.n648 1215.88
R1349 VSS.n648 VSS.n625 1215.88
R1350 VSS.n625 VSS.n596 1215.88
R1351 VSS.n596 VSS.n576 1215.88
R1352 VSS.n576 VSS.n557 1215.88
R1353 VSS.n557 VSS.n534 1215.88
R1354 VSS.n534 VSS.n505 1215.88
R1355 VSS.n505 VSS.n485 1215.88
R1356 VSS.n485 VSS.n466 1215.88
R1357 VSS.n466 VSS.n443 1215.88
R1358 VSS.n443 VSS.n414 1215.88
R1359 VSS.n414 VSS.n394 1215.88
R1360 VSS.n394 VSS.n375 1215.88
R1361 VSS.n375 VSS.n352 1215.88
R1362 VSS.n352 VSS.n323 1215.88
R1363 VSS.n323 VSS.n303 1215.88
R1364 VSS.n303 VSS.n284 1215.88
R1365 VSS.n284 VSS.n261 1215.88
R1366 VSS.n261 VSS.n232 1215.88
R1367 VSS.n232 VSS.n212 1215.88
R1368 VSS.n212 VSS.n193 1215.88
R1369 VSS.n193 VSS.n170 1215.88
R1370 VSS.n170 VSS.n139 1215.88
R1371 VSS.n838 VSS.n837 634.759
R1372 VSS.n126 VSS.n119 586.668
R1373 VSS.n134 VSS.n133 586.668
R1374 VSS.n158 VSS.n141 586.668
R1375 VSS.n165 VSS.n164 586.668
R1376 VSS.n182 VSS.n172 586.668
R1377 VSS.n188 VSS.n187 586.668
R1378 VSS.n201 VSS.n195 586.668
R1379 VSS.n207 VSS.n206 586.668
R1380 VSS.n220 VSS.n214 586.668
R1381 VSS.n227 VSS.n226 586.668
R1382 VSS.n249 VSS.n234 586.668
R1383 VSS.n256 VSS.n255 586.668
R1384 VSS.n273 VSS.n263 586.668
R1385 VSS.n279 VSS.n278 586.668
R1386 VSS.n292 VSS.n286 586.668
R1387 VSS.n298 VSS.n297 586.668
R1388 VSS.n311 VSS.n305 586.668
R1389 VSS.n318 VSS.n317 586.668
R1390 VSS.n340 VSS.n325 586.668
R1391 VSS.n347 VSS.n346 586.668
R1392 VSS.n364 VSS.n354 586.668
R1393 VSS.n370 VSS.n369 586.668
R1394 VSS.n383 VSS.n377 586.668
R1395 VSS.n389 VSS.n388 586.668
R1396 VSS.n402 VSS.n396 586.668
R1397 VSS.n409 VSS.n408 586.668
R1398 VSS.n431 VSS.n416 586.668
R1399 VSS.n438 VSS.n437 586.668
R1400 VSS.n455 VSS.n445 586.668
R1401 VSS.n461 VSS.n460 586.668
R1402 VSS.n474 VSS.n468 586.668
R1403 VSS.n480 VSS.n479 586.668
R1404 VSS.n493 VSS.n487 586.668
R1405 VSS.n500 VSS.n499 586.668
R1406 VSS.n522 VSS.n507 586.668
R1407 VSS.n529 VSS.n528 586.668
R1408 VSS.n546 VSS.n536 586.668
R1409 VSS.n552 VSS.n551 586.668
R1410 VSS.n565 VSS.n559 586.668
R1411 VSS.n571 VSS.n570 586.668
R1412 VSS.n584 VSS.n578 586.668
R1413 VSS.n591 VSS.n590 586.668
R1414 VSS.n613 VSS.n598 586.668
R1415 VSS.n620 VSS.n619 586.668
R1416 VSS.n637 VSS.n627 586.668
R1417 VSS.n643 VSS.n642 586.668
R1418 VSS.n656 VSS.n650 586.668
R1419 VSS.n662 VSS.n661 586.668
R1420 VSS.n675 VSS.n669 586.668
R1421 VSS.n682 VSS.n681 586.668
R1422 VSS.n704 VSS.n689 586.668
R1423 VSS.n711 VSS.n710 586.668
R1424 VSS.n728 VSS.n718 586.668
R1425 VSS.n734 VSS.n733 586.668
R1426 VSS.n747 VSS.n741 586.668
R1427 VSS.n753 VSS.n752 586.668
R1428 VSS.n766 VSS.n760 586.668
R1429 VSS.n773 VSS.n772 586.668
R1430 VSS.n795 VSS.n780 586.668
R1431 VSS.n802 VSS.n801 586.668
R1432 VSS.n848 VSS.n847 586.668
R1433 VSS.n853 VSS.n852 586.668
R1434 VSS.n1049 VSS.n1048 563.944
R1435 VSS.n1047 VSS.n5 563.944
R1436 VSS.n1046 VSS.n1045 563.944
R1437 VSS.n1034 VSS.n6 563.944
R1438 VSS.n1023 VSS.n1022 563.944
R1439 VSS.n1021 VSS.n20 563.944
R1440 VSS.n1020 VSS.n1019 563.944
R1441 VSS.n1008 VSS.n21 563.944
R1442 VSS.n997 VSS.n996 563.944
R1443 VSS.n995 VSS.n35 563.944
R1444 VSS.n994 VSS.n993 563.944
R1445 VSS.n982 VSS.n36 563.944
R1446 VSS.n971 VSS.n970 563.944
R1447 VSS.n969 VSS.n50 563.944
R1448 VSS.n968 VSS.n967 563.944
R1449 VSS.n956 VSS.n51 563.944
R1450 VSS.n945 VSS.n944 563.944
R1451 VSS.n943 VSS.n65 563.944
R1452 VSS.n942 VSS.n941 563.944
R1453 VSS.n930 VSS.n66 563.944
R1454 VSS.n919 VSS.n918 563.944
R1455 VSS.n917 VSS.n80 563.944
R1456 VSS.n916 VSS.n915 563.944
R1457 VSS.n904 VSS.n81 563.944
R1458 VSS.n893 VSS.n892 563.944
R1459 VSS.n891 VSS.n95 563.944
R1460 VSS.n890 VSS.n889 563.944
R1461 VSS.n878 VSS.n96 563.944
R1462 VSS.n867 VSS.n866 563.944
R1463 VSS.n865 VSS.n110 563.944
R1464 VSS.n864 VSS.n863 563.944
R1465 VSS.n831 VSS.n809 547.351
R1466 VSS.n815 VSS.n113 479.728
R1467 VSS.n128 VSS.n3 396.62
R1468 VSS.n147 VSS.n8 396.62
R1469 VSS.n1041 VSS.n1040 396.62
R1470 VSS.n1039 VSS.n1038 396.62
R1471 VSS.n19 VSS.n10 396.62
R1472 VSS.n240 VSS.n23 396.62
R1473 VSS.n1015 VSS.n1014 396.62
R1474 VSS.n1013 VSS.n1012 396.62
R1475 VSS.n34 VSS.n25 396.62
R1476 VSS.n331 VSS.n38 396.62
R1477 VSS.n989 VSS.n988 396.62
R1478 VSS.n987 VSS.n986 396.62
R1479 VSS.n49 VSS.n40 396.62
R1480 VSS.n422 VSS.n53 396.62
R1481 VSS.n963 VSS.n962 396.62
R1482 VSS.n961 VSS.n960 396.62
R1483 VSS.n64 VSS.n55 396.62
R1484 VSS.n513 VSS.n68 396.62
R1485 VSS.n937 VSS.n936 396.62
R1486 VSS.n935 VSS.n934 396.62
R1487 VSS.n79 VSS.n70 396.62
R1488 VSS.n604 VSS.n83 396.62
R1489 VSS.n911 VSS.n910 396.62
R1490 VSS.n909 VSS.n908 396.62
R1491 VSS.n94 VSS.n85 396.62
R1492 VSS.n695 VSS.n98 396.62
R1493 VSS.n885 VSS.n884 396.62
R1494 VSS.n883 VSS.n882 396.62
R1495 VSS.n109 VSS.n100 396.62
R1496 VSS.n786 VSS.n114 396.62
R1497 VSS.n859 VSS.n858 396.62
R1498 VSS.n837 VSS.t42 394.776
R1499 VSS.n833 VSS.t42 394.776
R1500 VSS.t22 VSS.n815 394.776
R1501 VSS.t22 VSS.n111 394.776
R1502 VSS.n139 VSS.n118 359.021
R1503 VSS.n170 VSS.n140 359.021
R1504 VSS.n193 VSS.n171 359.021
R1505 VSS.n212 VSS.n194 359.021
R1506 VSS.n232 VSS.n213 359.021
R1507 VSS.n261 VSS.n233 359.021
R1508 VSS.n284 VSS.n262 359.021
R1509 VSS.n303 VSS.n285 359.021
R1510 VSS.n323 VSS.n304 359.021
R1511 VSS.n352 VSS.n324 359.021
R1512 VSS.n375 VSS.n353 359.021
R1513 VSS.n394 VSS.n376 359.021
R1514 VSS.n414 VSS.n395 359.021
R1515 VSS.n443 VSS.n415 359.021
R1516 VSS.n466 VSS.n444 359.021
R1517 VSS.n485 VSS.n467 359.021
R1518 VSS.n505 VSS.n486 359.021
R1519 VSS.n534 VSS.n506 359.021
R1520 VSS.n557 VSS.n535 359.021
R1521 VSS.n576 VSS.n558 359.021
R1522 VSS.n596 VSS.n577 359.021
R1523 VSS.n625 VSS.n597 359.021
R1524 VSS.n648 VSS.n626 359.021
R1525 VSS.n667 VSS.n649 359.021
R1526 VSS.n687 VSS.n668 359.021
R1527 VSS.n716 VSS.n688 359.021
R1528 VSS.n739 VSS.n717 359.021
R1529 VSS.n758 VSS.n740 359.021
R1530 VSS.n778 VSS.n759 359.021
R1531 VSS.n807 VSS.n779 359.021
R1532 VSS.n844 VSS.n843 359.021
R1533 VSS.n843 VSS.n808 344.762
R1534 VSS.t129 VSS.n119 326.385
R1535 VSS.t128 VSS.n126 326.385
R1536 VSS.t128 VSS.n134 326.385
R1537 VSS.n133 VSS.t86 326.385
R1538 VSS.n129 VSS.t86 326.385
R1539 VSS.t112 VSS.n3 326.385
R1540 VSS.t112 VSS.n1049 326.385
R1541 VSS.t131 VSS.n141 326.385
R1542 VSS.t130 VSS.n158 326.385
R1543 VSS.t130 VSS.n165 326.385
R1544 VSS.n164 VSS.t80 326.385
R1545 VSS.n160 VSS.t80 326.385
R1546 VSS.t114 VSS.n147 326.385
R1547 VSS.t114 VSS.n5 326.385
R1548 VSS.t133 VSS.n172 326.385
R1549 VSS.t132 VSS.n182 326.385
R1550 VSS.t132 VSS.n188 326.385
R1551 VSS.n187 VSS.t74 326.385
R1552 VSS.t74 VSS.n9 326.385
R1553 VSS.n1041 VSS.t76 326.385
R1554 VSS.n1045 VSS.t76 326.385
R1555 VSS.t135 VSS.n195 326.385
R1556 VSS.t134 VSS.n201 326.385
R1557 VSS.t134 VSS.n207 326.385
R1558 VSS.n206 VSS.t70 326.385
R1559 VSS.t70 VSS.n11 326.385
R1560 VSS.n1038 VSS.t110 326.385
R1561 VSS.n1034 VSS.t110 326.385
R1562 VSS.t137 VSS.n214 326.385
R1563 VSS.t136 VSS.n220 326.385
R1564 VSS.t136 VSS.n227 326.385
R1565 VSS.n226 VSS.t40 326.385
R1566 VSS.n222 VSS.t40 326.385
R1567 VSS.t56 VSS.n19 326.385
R1568 VSS.t56 VSS.n1023 326.385
R1569 VSS.t139 VSS.n234 326.385
R1570 VSS.t138 VSS.n249 326.385
R1571 VSS.t138 VSS.n256 326.385
R1572 VSS.n255 VSS.t106 326.385
R1573 VSS.n251 VSS.t106 326.385
R1574 VSS.t4 VSS.n240 326.385
R1575 VSS.t4 VSS.n20 326.385
R1576 VSS.t141 VSS.n263 326.385
R1577 VSS.t140 VSS.n273 326.385
R1578 VSS.t140 VSS.n279 326.385
R1579 VSS.n278 VSS.t126 326.385
R1580 VSS.t126 VSS.n24 326.385
R1581 VSS.n1015 VSS.t52 326.385
R1582 VSS.n1019 VSS.t52 326.385
R1583 VSS.t143 VSS.n286 326.385
R1584 VSS.t142 VSS.n292 326.385
R1585 VSS.t142 VSS.n298 326.385
R1586 VSS.n297 VSS.t20 326.385
R1587 VSS.t20 VSS.n26 326.385
R1588 VSS.n1012 VSS.t18 326.385
R1589 VSS.n1008 VSS.t18 326.385
R1590 VSS.t145 VSS.n305 326.385
R1591 VSS.t144 VSS.n311 326.385
R1592 VSS.t144 VSS.n318 326.385
R1593 VSS.n317 VSS.t62 326.385
R1594 VSS.n313 VSS.t62 326.385
R1595 VSS.t28 VSS.n34 326.385
R1596 VSS.t28 VSS.n997 326.385
R1597 VSS.t147 VSS.n325 326.385
R1598 VSS.t146 VSS.n340 326.385
R1599 VSS.t146 VSS.n347 326.385
R1600 VSS.n346 VSS.t92 326.385
R1601 VSS.n342 VSS.t92 326.385
R1602 VSS.t60 VSS.n331 326.385
R1603 VSS.t60 VSS.n35 326.385
R1604 VSS.t149 VSS.n354 326.385
R1605 VSS.t148 VSS.n364 326.385
R1606 VSS.t148 VSS.n370 326.385
R1607 VSS.n369 VSS.t38 326.385
R1608 VSS.t38 VSS.n39 326.385
R1609 VSS.n989 VSS.t54 326.385
R1610 VSS.n993 VSS.t54 326.385
R1611 VSS.t151 VSS.n377 326.385
R1612 VSS.t150 VSS.n383 326.385
R1613 VSS.t150 VSS.n389 326.385
R1614 VSS.n388 VSS.t30 326.385
R1615 VSS.t30 VSS.n41 326.385
R1616 VSS.n986 VSS.t90 326.385
R1617 VSS.n982 VSS.t90 326.385
R1618 VSS.t153 VSS.n396 326.385
R1619 VSS.t152 VSS.n402 326.385
R1620 VSS.t152 VSS.n409 326.385
R1621 VSS.n408 VSS.t120 326.385
R1622 VSS.n404 VSS.t120 326.385
R1623 VSS.t122 VSS.n49 326.385
R1624 VSS.t122 VSS.n971 326.385
R1625 VSS.t155 VSS.n416 326.385
R1626 VSS.t154 VSS.n431 326.385
R1627 VSS.t154 VSS.n438 326.385
R1628 VSS.n437 VSS.t116 326.385
R1629 VSS.n433 VSS.t116 326.385
R1630 VSS.t118 VSS.n422 326.385
R1631 VSS.t118 VSS.n50 326.385
R1632 VSS.t157 VSS.n445 326.385
R1633 VSS.t156 VSS.n455 326.385
R1634 VSS.t156 VSS.n461 326.385
R1635 VSS.n460 VSS.t94 326.385
R1636 VSS.t94 VSS.n54 326.385
R1637 VSS.n963 VSS.t108 326.385
R1638 VSS.n967 VSS.t108 326.385
R1639 VSS.t159 VSS.n468 326.385
R1640 VSS.t158 VSS.n474 326.385
R1641 VSS.t158 VSS.n480 326.385
R1642 VSS.n479 VSS.t96 326.385
R1643 VSS.t96 VSS.n56 326.385
R1644 VSS.n960 VSS.t104 326.385
R1645 VSS.n956 VSS.t104 326.385
R1646 VSS.t161 VSS.n487 326.385
R1647 VSS.t160 VSS.n493 326.385
R1648 VSS.t160 VSS.n500 326.385
R1649 VSS.n499 VSS.t88 326.385
R1650 VSS.n495 VSS.t88 326.385
R1651 VSS.t102 VSS.n64 326.385
R1652 VSS.t102 VSS.n945 326.385
R1653 VSS.t163 VSS.n507 326.385
R1654 VSS.t162 VSS.n522 326.385
R1655 VSS.t162 VSS.n529 326.385
R1656 VSS.n528 VSS.t36 326.385
R1657 VSS.n524 VSS.t36 326.385
R1658 VSS.t50 VSS.n513 326.385
R1659 VSS.t50 VSS.n65 326.385
R1660 VSS.t165 VSS.n536 326.385
R1661 VSS.t164 VSS.n546 326.385
R1662 VSS.t164 VSS.n552 326.385
R1663 VSS.n551 VSS.t68 326.385
R1664 VSS.t68 VSS.n69 326.385
R1665 VSS.n937 VSS.t72 326.385
R1666 VSS.n941 VSS.t72 326.385
R1667 VSS.t167 VSS.n559 326.385
R1668 VSS.t166 VSS.n565 326.385
R1669 VSS.t166 VSS.n571 326.385
R1670 VSS.n570 VSS.t16 326.385
R1671 VSS.t16 VSS.n71 326.385
R1672 VSS.n934 VSS.t6 326.385
R1673 VSS.n930 VSS.t6 326.385
R1674 VSS.t169 VSS.n578 326.385
R1675 VSS.t168 VSS.n584 326.385
R1676 VSS.t168 VSS.n591 326.385
R1677 VSS.n590 VSS.t58 326.385
R1678 VSS.n586 VSS.t58 326.385
R1679 VSS.t26 VSS.n79 326.385
R1680 VSS.t26 VSS.n919 326.385
R1681 VSS.t171 VSS.n598 326.385
R1682 VSS.t170 VSS.n613 326.385
R1683 VSS.t170 VSS.n620 326.385
R1684 VSS.n619 VSS.t24 326.385
R1685 VSS.n615 VSS.t24 326.385
R1686 VSS.t66 VSS.n604 326.385
R1687 VSS.t66 VSS.n80 326.385
R1688 VSS.t173 VSS.n627 326.385
R1689 VSS.t172 VSS.n637 326.385
R1690 VSS.t172 VSS.n643 326.385
R1691 VSS.n642 VSS.t8 326.385
R1692 VSS.t8 VSS.n84 326.385
R1693 VSS.n911 VSS.t100 326.385
R1694 VSS.n915 VSS.t100 326.385
R1695 VSS.t175 VSS.n650 326.385
R1696 VSS.t174 VSS.n656 326.385
R1697 VSS.t174 VSS.n662 326.385
R1698 VSS.n661 VSS.t64 326.385
R1699 VSS.t64 VSS.n86 326.385
R1700 VSS.n908 VSS.t48 326.385
R1701 VSS.n904 VSS.t48 326.385
R1702 VSS.t177 VSS.n669 326.385
R1703 VSS.t176 VSS.n675 326.385
R1704 VSS.t176 VSS.n682 326.385
R1705 VSS.n681 VSS.t46 326.385
R1706 VSS.n677 VSS.t46 326.385
R1707 VSS.t84 VSS.n94 326.385
R1708 VSS.t84 VSS.n893 326.385
R1709 VSS.t179 VSS.n689 326.385
R1710 VSS.t178 VSS.n704 326.385
R1711 VSS.t178 VSS.n711 326.385
R1712 VSS.n710 VSS.t32 326.385
R1713 VSS.n706 VSS.t32 326.385
R1714 VSS.t34 VSS.n695 326.385
R1715 VSS.t34 VSS.n95 326.385
R1716 VSS.t181 VSS.n718 326.385
R1717 VSS.t180 VSS.n728 326.385
R1718 VSS.t180 VSS.n734 326.385
R1719 VSS.n733 VSS.t14 326.385
R1720 VSS.t14 VSS.n99 326.385
R1721 VSS.n885 VSS.t98 326.385
R1722 VSS.n889 VSS.t98 326.385
R1723 VSS.t183 VSS.n741 326.385
R1724 VSS.t182 VSS.n747 326.385
R1725 VSS.t182 VSS.n753 326.385
R1726 VSS.n752 VSS.t0 326.385
R1727 VSS.t0 VSS.n101 326.385
R1728 VSS.n882 VSS.t12 326.385
R1729 VSS.n878 VSS.t12 326.385
R1730 VSS.t185 VSS.n760 326.385
R1731 VSS.t184 VSS.n766 326.385
R1732 VSS.t184 VSS.n773 326.385
R1733 VSS.n772 VSS.t82 326.385
R1734 VSS.n768 VSS.t82 326.385
R1735 VSS.t78 VSS.n109 326.385
R1736 VSS.t78 VSS.n867 326.385
R1737 VSS.t187 VSS.n780 326.385
R1738 VSS.t186 VSS.n795 326.385
R1739 VSS.t186 VSS.n802 326.385
R1740 VSS.n801 VSS.t44 326.385
R1741 VSS.n797 VSS.t44 326.385
R1742 VSS.t10 VSS.n786 326.385
R1743 VSS.t10 VSS.n110 326.385
R1744 VSS.n847 VSS.t189 326.385
R1745 VSS.n848 VSS.t188 326.385
R1746 VSS.n852 VSS.t188 326.385
R1747 VSS.n853 VSS.t2 326.385
R1748 VSS.n857 VSS.t2 326.385
R1749 VSS.n859 VSS.t124 326.385
R1750 VSS.n863 VSS.t124 326.385
R1751 VSS.n819 VSS.n117 305.445
R1752 VSS.n806 VSS.n805 305.445
R1753 VSS.n777 VSS.n776 305.445
R1754 VSS.n757 VSS.n756 305.445
R1755 VSS.n738 VSS.n737 305.445
R1756 VSS.n715 VSS.n714 305.445
R1757 VSS.n686 VSS.n685 305.445
R1758 VSS.n666 VSS.n665 305.445
R1759 VSS.n647 VSS.n646 305.445
R1760 VSS.n624 VSS.n623 305.445
R1761 VSS.n595 VSS.n594 305.445
R1762 VSS.n575 VSS.n574 305.445
R1763 VSS.n556 VSS.n555 305.445
R1764 VSS.n533 VSS.n532 305.445
R1765 VSS.n504 VSS.n503 305.445
R1766 VSS.n484 VSS.n483 305.445
R1767 VSS.n465 VSS.n464 305.445
R1768 VSS.n442 VSS.n441 305.445
R1769 VSS.n413 VSS.n412 305.445
R1770 VSS.n393 VSS.n392 305.445
R1771 VSS.n374 VSS.n373 305.445
R1772 VSS.n351 VSS.n350 305.445
R1773 VSS.n322 VSS.n321 305.445
R1774 VSS.n302 VSS.n301 305.445
R1775 VSS.n283 VSS.n282 305.445
R1776 VSS.n260 VSS.n259 305.445
R1777 VSS.n231 VSS.n230 305.445
R1778 VSS.n211 VSS.n210 305.445
R1779 VSS.n192 VSS.n191 305.445
R1780 VSS.n169 VSS.n168 305.445
R1781 VSS.n138 VSS.n137 305.445
R1782 VSS.n842 VSS.n841 305.445
R1783 VSS.n841 VSS.n840 304.949
R1784 VSS.n137 VSS.n136 304.949
R1785 VSS.n168 VSS.n167 304.949
R1786 VSS.n191 VSS.n190 304.949
R1787 VSS.n210 VSS.n209 304.949
R1788 VSS.n230 VSS.n229 304.949
R1789 VSS.n259 VSS.n258 304.949
R1790 VSS.n282 VSS.n281 304.949
R1791 VSS.n301 VSS.n300 304.949
R1792 VSS.n321 VSS.n320 304.949
R1793 VSS.n350 VSS.n349 304.949
R1794 VSS.n373 VSS.n372 304.949
R1795 VSS.n392 VSS.n391 304.949
R1796 VSS.n412 VSS.n411 304.949
R1797 VSS.n441 VSS.n440 304.949
R1798 VSS.n464 VSS.n463 304.949
R1799 VSS.n483 VSS.n482 304.949
R1800 VSS.n503 VSS.n502 304.949
R1801 VSS.n532 VSS.n531 304.949
R1802 VSS.n555 VSS.n554 304.949
R1803 VSS.n574 VSS.n573 304.949
R1804 VSS.n594 VSS.n593 304.949
R1805 VSS.n623 VSS.n622 304.949
R1806 VSS.n646 VSS.n645 304.949
R1807 VSS.n665 VSS.n664 304.949
R1808 VSS.n685 VSS.n684 304.949
R1809 VSS.n714 VSS.n713 304.949
R1810 VSS.n737 VSS.n736 304.949
R1811 VSS.n756 VSS.n755 304.949
R1812 VSS.n776 VSS.n775 304.949
R1813 VSS.n805 VSS.n804 304.949
R1814 VSS.n819 VSS.n116 304.949
R1815 VSS.t191 VSS.n809 304.512
R1816 VSS.t190 VSS.n831 304.512
R1817 VSS.t190 VSS.n838 304.512
R1818 VSS.n1052 VSS.n1051 304.048
R1819 VSS.n150 VSS.n149 304.048
R1820 VSS.n176 VSS.n7 304.048
R1821 VSS.n1033 VSS.n1032 304.048
R1822 VSS.n1026 VSS.n1025 304.048
R1823 VSS.n243 VSS.n242 304.048
R1824 VSS.n267 VSS.n22 304.048
R1825 VSS.n1007 VSS.n1006 304.048
R1826 VSS.n1000 VSS.n999 304.048
R1827 VSS.n334 VSS.n333 304.048
R1828 VSS.n358 VSS.n37 304.048
R1829 VSS.n981 VSS.n980 304.048
R1830 VSS.n974 VSS.n973 304.048
R1831 VSS.n425 VSS.n424 304.048
R1832 VSS.n449 VSS.n52 304.048
R1833 VSS.n955 VSS.n954 304.048
R1834 VSS.n948 VSS.n947 304.048
R1835 VSS.n516 VSS.n515 304.048
R1836 VSS.n540 VSS.n67 304.048
R1837 VSS.n929 VSS.n928 304.048
R1838 VSS.n922 VSS.n921 304.048
R1839 VSS.n607 VSS.n606 304.048
R1840 VSS.n631 VSS.n82 304.048
R1841 VSS.n903 VSS.n902 304.048
R1842 VSS.n896 VSS.n895 304.048
R1843 VSS.n698 VSS.n697 304.048
R1844 VSS.n722 VSS.n97 304.048
R1845 VSS.n877 VSS.n876 304.048
R1846 VSS.n870 VSS.n869 304.048
R1847 VSS.n789 VSS.n788 304.048
R1848 VSS.n823 VSS.n112 304.048
R1849 VSS.n818 VSS.n817 304.048
R1850 VSS.n832 VSS.n828 303.976
R1851 VSS.n127 VSS.n123 303.976
R1852 VSS.n159 VSS.n155 303.976
R1853 VSS.n183 VSS.n179 303.976
R1854 VSS.n202 VSS.n198 303.976
R1855 VSS.n221 VSS.n217 303.976
R1856 VSS.n250 VSS.n246 303.976
R1857 VSS.n274 VSS.n270 303.976
R1858 VSS.n293 VSS.n289 303.976
R1859 VSS.n312 VSS.n308 303.976
R1860 VSS.n341 VSS.n337 303.976
R1861 VSS.n365 VSS.n361 303.976
R1862 VSS.n384 VSS.n380 303.976
R1863 VSS.n403 VSS.n399 303.976
R1864 VSS.n432 VSS.n428 303.976
R1865 VSS.n456 VSS.n452 303.976
R1866 VSS.n475 VSS.n471 303.976
R1867 VSS.n494 VSS.n490 303.976
R1868 VSS.n523 VSS.n519 303.976
R1869 VSS.n547 VSS.n543 303.976
R1870 VSS.n566 VSS.n562 303.976
R1871 VSS.n585 VSS.n581 303.976
R1872 VSS.n614 VSS.n610 303.976
R1873 VSS.n638 VSS.n634 303.976
R1874 VSS.n657 VSS.n653 303.976
R1875 VSS.n676 VSS.n672 303.976
R1876 VSS.n705 VSS.n701 303.976
R1877 VSS.n729 VSS.n725 303.976
R1878 VSS.n748 VSS.n744 303.976
R1879 VSS.n767 VSS.n763 303.976
R1880 VSS.n796 VSS.n792 303.976
R1881 VSS.n820 VSS.n115 303.976
R1882 VSS.n835 VSS.t42 292.5
R1883 VSS.n832 VSS.t42 292.5
R1884 VSS.t22 VSS.n816 292.5
R1885 VSS.n817 VSS.t22 292.5
R1886 VSS.t129 VSS.n120 292.5
R1887 VSS.t129 VSS.n138 292.5
R1888 VSS.t128 VSS.n135 292.5
R1889 VSS.n136 VSS.t128 292.5
R1890 VSS.n131 VSS.t86 292.5
R1891 VSS.n127 VSS.t86 292.5
R1892 VSS.t112 VSS.n1050 292.5
R1893 VSS.n1051 VSS.t112 292.5
R1894 VSS.t131 VSS.n142 292.5
R1895 VSS.t131 VSS.n169 292.5
R1896 VSS.t130 VSS.n166 292.5
R1897 VSS.n167 VSS.t130 292.5
R1898 VSS.n162 VSS.t80 292.5
R1899 VSS.n159 VSS.t80 292.5
R1900 VSS.t114 VSS.n148 292.5
R1901 VSS.n149 VSS.t114 292.5
R1902 VSS.t133 VSS.n173 292.5
R1903 VSS.t133 VSS.n192 292.5
R1904 VSS.t132 VSS.n189 292.5
R1905 VSS.n190 VSS.t132 292.5
R1906 VSS.n185 VSS.t74 292.5
R1907 VSS.n183 VSS.t74 292.5
R1908 VSS.n1043 VSS.t76 292.5
R1909 VSS.n7 VSS.t76 292.5
R1910 VSS.t135 VSS.n196 292.5
R1911 VSS.t135 VSS.n211 292.5
R1912 VSS.t134 VSS.n208 292.5
R1913 VSS.n209 VSS.t134 292.5
R1914 VSS.n204 VSS.t70 292.5
R1915 VSS.n202 VSS.t70 292.5
R1916 VSS.n1036 VSS.t110 292.5
R1917 VSS.n1033 VSS.t110 292.5
R1918 VSS.t137 VSS.n215 292.5
R1919 VSS.t137 VSS.n231 292.5
R1920 VSS.t136 VSS.n228 292.5
R1921 VSS.n229 VSS.t136 292.5
R1922 VSS.n224 VSS.t40 292.5
R1923 VSS.n221 VSS.t40 292.5
R1924 VSS.t56 VSS.n1024 292.5
R1925 VSS.n1025 VSS.t56 292.5
R1926 VSS.t139 VSS.n235 292.5
R1927 VSS.t139 VSS.n260 292.5
R1928 VSS.t138 VSS.n257 292.5
R1929 VSS.n258 VSS.t138 292.5
R1930 VSS.n253 VSS.t106 292.5
R1931 VSS.n250 VSS.t106 292.5
R1932 VSS.t4 VSS.n241 292.5
R1933 VSS.n242 VSS.t4 292.5
R1934 VSS.t141 VSS.n264 292.5
R1935 VSS.t141 VSS.n283 292.5
R1936 VSS.t140 VSS.n280 292.5
R1937 VSS.n281 VSS.t140 292.5
R1938 VSS.n276 VSS.t126 292.5
R1939 VSS.n274 VSS.t126 292.5
R1940 VSS.n1017 VSS.t52 292.5
R1941 VSS.n22 VSS.t52 292.5
R1942 VSS.t143 VSS.n287 292.5
R1943 VSS.t143 VSS.n302 292.5
R1944 VSS.t142 VSS.n299 292.5
R1945 VSS.n300 VSS.t142 292.5
R1946 VSS.n295 VSS.t20 292.5
R1947 VSS.n293 VSS.t20 292.5
R1948 VSS.n1010 VSS.t18 292.5
R1949 VSS.n1007 VSS.t18 292.5
R1950 VSS.t145 VSS.n306 292.5
R1951 VSS.t145 VSS.n322 292.5
R1952 VSS.t144 VSS.n319 292.5
R1953 VSS.n320 VSS.t144 292.5
R1954 VSS.n315 VSS.t62 292.5
R1955 VSS.n312 VSS.t62 292.5
R1956 VSS.t28 VSS.n998 292.5
R1957 VSS.n999 VSS.t28 292.5
R1958 VSS.t147 VSS.n326 292.5
R1959 VSS.t147 VSS.n351 292.5
R1960 VSS.t146 VSS.n348 292.5
R1961 VSS.n349 VSS.t146 292.5
R1962 VSS.n344 VSS.t92 292.5
R1963 VSS.n341 VSS.t92 292.5
R1964 VSS.t60 VSS.n332 292.5
R1965 VSS.n333 VSS.t60 292.5
R1966 VSS.t149 VSS.n355 292.5
R1967 VSS.t149 VSS.n374 292.5
R1968 VSS.t148 VSS.n371 292.5
R1969 VSS.n372 VSS.t148 292.5
R1970 VSS.n367 VSS.t38 292.5
R1971 VSS.n365 VSS.t38 292.5
R1972 VSS.n991 VSS.t54 292.5
R1973 VSS.n37 VSS.t54 292.5
R1974 VSS.t151 VSS.n378 292.5
R1975 VSS.t151 VSS.n393 292.5
R1976 VSS.t150 VSS.n390 292.5
R1977 VSS.n391 VSS.t150 292.5
R1978 VSS.n386 VSS.t30 292.5
R1979 VSS.n384 VSS.t30 292.5
R1980 VSS.n984 VSS.t90 292.5
R1981 VSS.n981 VSS.t90 292.5
R1982 VSS.t153 VSS.n397 292.5
R1983 VSS.t153 VSS.n413 292.5
R1984 VSS.t152 VSS.n410 292.5
R1985 VSS.n411 VSS.t152 292.5
R1986 VSS.n406 VSS.t120 292.5
R1987 VSS.n403 VSS.t120 292.5
R1988 VSS.t122 VSS.n972 292.5
R1989 VSS.n973 VSS.t122 292.5
R1990 VSS.t155 VSS.n417 292.5
R1991 VSS.t155 VSS.n442 292.5
R1992 VSS.t154 VSS.n439 292.5
R1993 VSS.n440 VSS.t154 292.5
R1994 VSS.n435 VSS.t116 292.5
R1995 VSS.n432 VSS.t116 292.5
R1996 VSS.t118 VSS.n423 292.5
R1997 VSS.n424 VSS.t118 292.5
R1998 VSS.t157 VSS.n446 292.5
R1999 VSS.t157 VSS.n465 292.5
R2000 VSS.t156 VSS.n462 292.5
R2001 VSS.n463 VSS.t156 292.5
R2002 VSS.n458 VSS.t94 292.5
R2003 VSS.n456 VSS.t94 292.5
R2004 VSS.n965 VSS.t108 292.5
R2005 VSS.n52 VSS.t108 292.5
R2006 VSS.t159 VSS.n469 292.5
R2007 VSS.t159 VSS.n484 292.5
R2008 VSS.t158 VSS.n481 292.5
R2009 VSS.n482 VSS.t158 292.5
R2010 VSS.n477 VSS.t96 292.5
R2011 VSS.n475 VSS.t96 292.5
R2012 VSS.n958 VSS.t104 292.5
R2013 VSS.n955 VSS.t104 292.5
R2014 VSS.t161 VSS.n488 292.5
R2015 VSS.t161 VSS.n504 292.5
R2016 VSS.t160 VSS.n501 292.5
R2017 VSS.n502 VSS.t160 292.5
R2018 VSS.n497 VSS.t88 292.5
R2019 VSS.n494 VSS.t88 292.5
R2020 VSS.t102 VSS.n946 292.5
R2021 VSS.n947 VSS.t102 292.5
R2022 VSS.t163 VSS.n508 292.5
R2023 VSS.t163 VSS.n533 292.5
R2024 VSS.t162 VSS.n530 292.5
R2025 VSS.n531 VSS.t162 292.5
R2026 VSS.n526 VSS.t36 292.5
R2027 VSS.n523 VSS.t36 292.5
R2028 VSS.t50 VSS.n514 292.5
R2029 VSS.n515 VSS.t50 292.5
R2030 VSS.t165 VSS.n537 292.5
R2031 VSS.t165 VSS.n556 292.5
R2032 VSS.t164 VSS.n553 292.5
R2033 VSS.n554 VSS.t164 292.5
R2034 VSS.n549 VSS.t68 292.5
R2035 VSS.n547 VSS.t68 292.5
R2036 VSS.n939 VSS.t72 292.5
R2037 VSS.n67 VSS.t72 292.5
R2038 VSS.t167 VSS.n560 292.5
R2039 VSS.t167 VSS.n575 292.5
R2040 VSS.t166 VSS.n572 292.5
R2041 VSS.n573 VSS.t166 292.5
R2042 VSS.n568 VSS.t16 292.5
R2043 VSS.n566 VSS.t16 292.5
R2044 VSS.n932 VSS.t6 292.5
R2045 VSS.n929 VSS.t6 292.5
R2046 VSS.t169 VSS.n579 292.5
R2047 VSS.t169 VSS.n595 292.5
R2048 VSS.t168 VSS.n592 292.5
R2049 VSS.n593 VSS.t168 292.5
R2050 VSS.n588 VSS.t58 292.5
R2051 VSS.n585 VSS.t58 292.5
R2052 VSS.t26 VSS.n920 292.5
R2053 VSS.n921 VSS.t26 292.5
R2054 VSS.t171 VSS.n599 292.5
R2055 VSS.t171 VSS.n624 292.5
R2056 VSS.t170 VSS.n621 292.5
R2057 VSS.n622 VSS.t170 292.5
R2058 VSS.n617 VSS.t24 292.5
R2059 VSS.n614 VSS.t24 292.5
R2060 VSS.t66 VSS.n605 292.5
R2061 VSS.n606 VSS.t66 292.5
R2062 VSS.t173 VSS.n628 292.5
R2063 VSS.t173 VSS.n647 292.5
R2064 VSS.t172 VSS.n644 292.5
R2065 VSS.n645 VSS.t172 292.5
R2066 VSS.n640 VSS.t8 292.5
R2067 VSS.n638 VSS.t8 292.5
R2068 VSS.n913 VSS.t100 292.5
R2069 VSS.n82 VSS.t100 292.5
R2070 VSS.t175 VSS.n651 292.5
R2071 VSS.t175 VSS.n666 292.5
R2072 VSS.t174 VSS.n663 292.5
R2073 VSS.n664 VSS.t174 292.5
R2074 VSS.n659 VSS.t64 292.5
R2075 VSS.n657 VSS.t64 292.5
R2076 VSS.n906 VSS.t48 292.5
R2077 VSS.n903 VSS.t48 292.5
R2078 VSS.t177 VSS.n670 292.5
R2079 VSS.t177 VSS.n686 292.5
R2080 VSS.t176 VSS.n683 292.5
R2081 VSS.n684 VSS.t176 292.5
R2082 VSS.n679 VSS.t46 292.5
R2083 VSS.n676 VSS.t46 292.5
R2084 VSS.t84 VSS.n894 292.5
R2085 VSS.n895 VSS.t84 292.5
R2086 VSS.t179 VSS.n690 292.5
R2087 VSS.t179 VSS.n715 292.5
R2088 VSS.t178 VSS.n712 292.5
R2089 VSS.n713 VSS.t178 292.5
R2090 VSS.n708 VSS.t32 292.5
R2091 VSS.n705 VSS.t32 292.5
R2092 VSS.t34 VSS.n696 292.5
R2093 VSS.n697 VSS.t34 292.5
R2094 VSS.t181 VSS.n719 292.5
R2095 VSS.t181 VSS.n738 292.5
R2096 VSS.t180 VSS.n735 292.5
R2097 VSS.n736 VSS.t180 292.5
R2098 VSS.n731 VSS.t14 292.5
R2099 VSS.n729 VSS.t14 292.5
R2100 VSS.n887 VSS.t98 292.5
R2101 VSS.n97 VSS.t98 292.5
R2102 VSS.t183 VSS.n742 292.5
R2103 VSS.t183 VSS.n757 292.5
R2104 VSS.t182 VSS.n754 292.5
R2105 VSS.n755 VSS.t182 292.5
R2106 VSS.n750 VSS.t0 292.5
R2107 VSS.n748 VSS.t0 292.5
R2108 VSS.n880 VSS.t12 292.5
R2109 VSS.n877 VSS.t12 292.5
R2110 VSS.t185 VSS.n761 292.5
R2111 VSS.t185 VSS.n777 292.5
R2112 VSS.t184 VSS.n774 292.5
R2113 VSS.n775 VSS.t184 292.5
R2114 VSS.n770 VSS.t82 292.5
R2115 VSS.n767 VSS.t82 292.5
R2116 VSS.t78 VSS.n868 292.5
R2117 VSS.n869 VSS.t78 292.5
R2118 VSS.t187 VSS.n781 292.5
R2119 VSS.t187 VSS.n806 292.5
R2120 VSS.t186 VSS.n803 292.5
R2121 VSS.n804 VSS.t186 292.5
R2122 VSS.n799 VSS.t44 292.5
R2123 VSS.n796 VSS.t44 292.5
R2124 VSS.t10 VSS.n787 292.5
R2125 VSS.n788 VSS.t10 292.5
R2126 VSS.n845 VSS.t189 292.5
R2127 VSS.n117 VSS.t189 292.5
R2128 VSS.n850 VSS.t188 292.5
R2129 VSS.n116 VSS.t188 292.5
R2130 VSS.n855 VSS.t2 292.5
R2131 VSS.n115 VSS.t2 292.5
R2132 VSS.n861 VSS.t124 292.5
R2133 VSS.n112 VSS.t124 292.5
R2134 VSS.t190 VSS.n839 292.5
R2135 VSS.n840 VSS.t190 292.5
R2136 VSS.t191 VSS.n810 292.5
R2137 VSS.t191 VSS.n842 292.5
R2138 VSS.n833 VSS.n113 229.869
R2139 VSS.n129 VSS.n128 190.048
R2140 VSS.n160 VSS.n8 190.048
R2141 VSS.n1040 VSS.n9 190.048
R2142 VSS.n1039 VSS.n11 190.048
R2143 VSS.n222 VSS.n10 190.048
R2144 VSS.n251 VSS.n23 190.048
R2145 VSS.n1014 VSS.n24 190.048
R2146 VSS.n1013 VSS.n26 190.048
R2147 VSS.n313 VSS.n25 190.048
R2148 VSS.n342 VSS.n38 190.048
R2149 VSS.n988 VSS.n39 190.048
R2150 VSS.n987 VSS.n41 190.048
R2151 VSS.n404 VSS.n40 190.048
R2152 VSS.n433 VSS.n53 190.048
R2153 VSS.n962 VSS.n54 190.048
R2154 VSS.n961 VSS.n56 190.048
R2155 VSS.n495 VSS.n55 190.048
R2156 VSS.n524 VSS.n68 190.048
R2157 VSS.n936 VSS.n69 190.048
R2158 VSS.n935 VSS.n71 190.048
R2159 VSS.n586 VSS.n70 190.048
R2160 VSS.n615 VSS.n83 190.048
R2161 VSS.n910 VSS.n84 190.048
R2162 VSS.n909 VSS.n86 190.048
R2163 VSS.n677 VSS.n85 190.048
R2164 VSS.n706 VSS.n98 190.048
R2165 VSS.n884 VSS.n99 190.048
R2166 VSS.n883 VSS.n101 190.048
R2167 VSS.n768 VSS.n100 190.048
R2168 VSS.n797 VSS.n114 190.048
R2169 VSS.n858 VSS.n857 190.048
R2170 VSS.n121 VSS.n119 146.25
R2171 VSS.n134 VSS.n125 146.25
R2172 VSS.n126 VSS.n124 146.25
R2173 VSS.n143 VSS.n141 146.25
R2174 VSS.n165 VSS.n157 146.25
R2175 VSS.n158 VSS.n156 146.25
R2176 VSS.n174 VSS.n172 146.25
R2177 VSS.n188 VSS.n181 146.25
R2178 VSS.n182 VSS.n180 146.25
R2179 VSS.n197 VSS.n195 146.25
R2180 VSS.n207 VSS.n200 146.25
R2181 VSS.n201 VSS.n199 146.25
R2182 VSS.n216 VSS.n214 146.25
R2183 VSS.n227 VSS.n219 146.25
R2184 VSS.n220 VSS.n218 146.25
R2185 VSS.n236 VSS.n234 146.25
R2186 VSS.n256 VSS.n248 146.25
R2187 VSS.n249 VSS.n247 146.25
R2188 VSS.n265 VSS.n263 146.25
R2189 VSS.n279 VSS.n272 146.25
R2190 VSS.n273 VSS.n271 146.25
R2191 VSS.n288 VSS.n286 146.25
R2192 VSS.n298 VSS.n291 146.25
R2193 VSS.n292 VSS.n290 146.25
R2194 VSS.n307 VSS.n305 146.25
R2195 VSS.n318 VSS.n310 146.25
R2196 VSS.n311 VSS.n309 146.25
R2197 VSS.n327 VSS.n325 146.25
R2198 VSS.n347 VSS.n339 146.25
R2199 VSS.n340 VSS.n338 146.25
R2200 VSS.n356 VSS.n354 146.25
R2201 VSS.n370 VSS.n363 146.25
R2202 VSS.n364 VSS.n362 146.25
R2203 VSS.n379 VSS.n377 146.25
R2204 VSS.n389 VSS.n382 146.25
R2205 VSS.n383 VSS.n381 146.25
R2206 VSS.n398 VSS.n396 146.25
R2207 VSS.n409 VSS.n401 146.25
R2208 VSS.n402 VSS.n400 146.25
R2209 VSS.n418 VSS.n416 146.25
R2210 VSS.n438 VSS.n430 146.25
R2211 VSS.n431 VSS.n429 146.25
R2212 VSS.n447 VSS.n445 146.25
R2213 VSS.n461 VSS.n454 146.25
R2214 VSS.n455 VSS.n453 146.25
R2215 VSS.n470 VSS.n468 146.25
R2216 VSS.n480 VSS.n473 146.25
R2217 VSS.n474 VSS.n472 146.25
R2218 VSS.n489 VSS.n487 146.25
R2219 VSS.n500 VSS.n492 146.25
R2220 VSS.n493 VSS.n491 146.25
R2221 VSS.n509 VSS.n507 146.25
R2222 VSS.n529 VSS.n521 146.25
R2223 VSS.n522 VSS.n520 146.25
R2224 VSS.n538 VSS.n536 146.25
R2225 VSS.n552 VSS.n545 146.25
R2226 VSS.n546 VSS.n544 146.25
R2227 VSS.n561 VSS.n559 146.25
R2228 VSS.n571 VSS.n564 146.25
R2229 VSS.n565 VSS.n563 146.25
R2230 VSS.n580 VSS.n578 146.25
R2231 VSS.n591 VSS.n583 146.25
R2232 VSS.n584 VSS.n582 146.25
R2233 VSS.n600 VSS.n598 146.25
R2234 VSS.n620 VSS.n612 146.25
R2235 VSS.n613 VSS.n611 146.25
R2236 VSS.n629 VSS.n627 146.25
R2237 VSS.n643 VSS.n636 146.25
R2238 VSS.n637 VSS.n635 146.25
R2239 VSS.n652 VSS.n650 146.25
R2240 VSS.n662 VSS.n655 146.25
R2241 VSS.n656 VSS.n654 146.25
R2242 VSS.n671 VSS.n669 146.25
R2243 VSS.n682 VSS.n674 146.25
R2244 VSS.n675 VSS.n673 146.25
R2245 VSS.n691 VSS.n689 146.25
R2246 VSS.n711 VSS.n703 146.25
R2247 VSS.n704 VSS.n702 146.25
R2248 VSS.n720 VSS.n718 146.25
R2249 VSS.n734 VSS.n727 146.25
R2250 VSS.n728 VSS.n726 146.25
R2251 VSS.n743 VSS.n741 146.25
R2252 VSS.n753 VSS.n746 146.25
R2253 VSS.n747 VSS.n745 146.25
R2254 VSS.n762 VSS.n760 146.25
R2255 VSS.n773 VSS.n765 146.25
R2256 VSS.n766 VSS.n764 146.25
R2257 VSS.n782 VSS.n780 146.25
R2258 VSS.n802 VSS.n794 146.25
R2259 VSS.n795 VSS.n793 146.25
R2260 VSS.n847 VSS.n846 146.25
R2261 VSS.n852 VSS.n851 146.25
R2262 VSS.n849 VSS.n848 146.25
R2263 VSS.n838 VSS.n830 146.25
R2264 VSS.n831 VSS.n829 146.25
R2265 VSS.n811 VSS.n809 146.25
R2266 VSS.n139 VSS.t129 113.615
R2267 VSS.n170 VSS.t131 113.615
R2268 VSS.n193 VSS.t133 113.615
R2269 VSS.n212 VSS.t135 113.615
R2270 VSS.n232 VSS.t137 113.615
R2271 VSS.n261 VSS.t139 113.615
R2272 VSS.n284 VSS.t141 113.615
R2273 VSS.n303 VSS.t143 113.615
R2274 VSS.n323 VSS.t145 113.615
R2275 VSS.n352 VSS.t147 113.615
R2276 VSS.n375 VSS.t149 113.615
R2277 VSS.n394 VSS.t151 113.615
R2278 VSS.n414 VSS.t153 113.615
R2279 VSS.n443 VSS.t155 113.615
R2280 VSS.n466 VSS.t157 113.615
R2281 VSS.n485 VSS.t159 113.615
R2282 VSS.n505 VSS.t161 113.615
R2283 VSS.n534 VSS.t163 113.615
R2284 VSS.n557 VSS.t165 113.615
R2285 VSS.n576 VSS.t167 113.615
R2286 VSS.n596 VSS.t169 113.615
R2287 VSS.n625 VSS.t171 113.615
R2288 VSS.n648 VSS.t173 113.615
R2289 VSS.n667 VSS.t175 113.615
R2290 VSS.n687 VSS.t177 113.615
R2291 VSS.n716 VSS.t179 113.615
R2292 VSS.n739 VSS.t181 113.615
R2293 VSS.n758 VSS.t183 113.615
R2294 VSS.n778 VSS.t185 113.615
R2295 VSS.n807 VSS.t187 113.615
R2296 VSS.n843 VSS.t189 113.615
R2297 VSS.n843 VSS.t191 106.001
R2298 VSS.n834 VSS.n833 97.5005
R2299 VSS.n837 VSS.n836 97.5005
R2300 VSS.n814 VSS.n111 97.5005
R2301 VSS.n815 VSS.n813 97.5005
R2302 VSS.n130 VSS.n129 97.5005
R2303 VSS.n133 VSS.n132 97.5005
R2304 VSS.n1049 VSS.n2 97.5005
R2305 VSS.n3 VSS.n1 97.5005
R2306 VSS.n161 VSS.n160 97.5005
R2307 VSS.n164 VSS.n163 97.5005
R2308 VSS.n146 VSS.n5 97.5005
R2309 VSS.n147 VSS.n145 97.5005
R2310 VSS.n184 VSS.n9 97.5005
R2311 VSS.n187 VSS.n186 97.5005
R2312 VSS.n1045 VSS.n1044 97.5005
R2313 VSS.n1042 VSS.n1041 97.5005
R2314 VSS.n203 VSS.n11 97.5005
R2315 VSS.n206 VSS.n205 97.5005
R2316 VSS.n1035 VSS.n1034 97.5005
R2317 VSS.n1038 VSS.n1037 97.5005
R2318 VSS.n223 VSS.n222 97.5005
R2319 VSS.n226 VSS.n225 97.5005
R2320 VSS.n1023 VSS.n18 97.5005
R2321 VSS.n19 VSS.n17 97.5005
R2322 VSS.n252 VSS.n251 97.5005
R2323 VSS.n255 VSS.n254 97.5005
R2324 VSS.n239 VSS.n20 97.5005
R2325 VSS.n240 VSS.n238 97.5005
R2326 VSS.n275 VSS.n24 97.5005
R2327 VSS.n278 VSS.n277 97.5005
R2328 VSS.n1019 VSS.n1018 97.5005
R2329 VSS.n1016 VSS.n1015 97.5005
R2330 VSS.n294 VSS.n26 97.5005
R2331 VSS.n297 VSS.n296 97.5005
R2332 VSS.n1009 VSS.n1008 97.5005
R2333 VSS.n1012 VSS.n1011 97.5005
R2334 VSS.n314 VSS.n313 97.5005
R2335 VSS.n317 VSS.n316 97.5005
R2336 VSS.n997 VSS.n33 97.5005
R2337 VSS.n34 VSS.n32 97.5005
R2338 VSS.n343 VSS.n342 97.5005
R2339 VSS.n346 VSS.n345 97.5005
R2340 VSS.n330 VSS.n35 97.5005
R2341 VSS.n331 VSS.n329 97.5005
R2342 VSS.n366 VSS.n39 97.5005
R2343 VSS.n369 VSS.n368 97.5005
R2344 VSS.n993 VSS.n992 97.5005
R2345 VSS.n990 VSS.n989 97.5005
R2346 VSS.n385 VSS.n41 97.5005
R2347 VSS.n388 VSS.n387 97.5005
R2348 VSS.n983 VSS.n982 97.5005
R2349 VSS.n986 VSS.n985 97.5005
R2350 VSS.n405 VSS.n404 97.5005
R2351 VSS.n408 VSS.n407 97.5005
R2352 VSS.n971 VSS.n48 97.5005
R2353 VSS.n49 VSS.n47 97.5005
R2354 VSS.n434 VSS.n433 97.5005
R2355 VSS.n437 VSS.n436 97.5005
R2356 VSS.n421 VSS.n50 97.5005
R2357 VSS.n422 VSS.n420 97.5005
R2358 VSS.n457 VSS.n54 97.5005
R2359 VSS.n460 VSS.n459 97.5005
R2360 VSS.n967 VSS.n966 97.5005
R2361 VSS.n964 VSS.n963 97.5005
R2362 VSS.n476 VSS.n56 97.5005
R2363 VSS.n479 VSS.n478 97.5005
R2364 VSS.n957 VSS.n956 97.5005
R2365 VSS.n960 VSS.n959 97.5005
R2366 VSS.n496 VSS.n495 97.5005
R2367 VSS.n499 VSS.n498 97.5005
R2368 VSS.n945 VSS.n63 97.5005
R2369 VSS.n64 VSS.n62 97.5005
R2370 VSS.n525 VSS.n524 97.5005
R2371 VSS.n528 VSS.n527 97.5005
R2372 VSS.n512 VSS.n65 97.5005
R2373 VSS.n513 VSS.n511 97.5005
R2374 VSS.n548 VSS.n69 97.5005
R2375 VSS.n551 VSS.n550 97.5005
R2376 VSS.n941 VSS.n940 97.5005
R2377 VSS.n938 VSS.n937 97.5005
R2378 VSS.n567 VSS.n71 97.5005
R2379 VSS.n570 VSS.n569 97.5005
R2380 VSS.n931 VSS.n930 97.5005
R2381 VSS.n934 VSS.n933 97.5005
R2382 VSS.n587 VSS.n586 97.5005
R2383 VSS.n590 VSS.n589 97.5005
R2384 VSS.n919 VSS.n78 97.5005
R2385 VSS.n79 VSS.n77 97.5005
R2386 VSS.n616 VSS.n615 97.5005
R2387 VSS.n619 VSS.n618 97.5005
R2388 VSS.n603 VSS.n80 97.5005
R2389 VSS.n604 VSS.n602 97.5005
R2390 VSS.n639 VSS.n84 97.5005
R2391 VSS.n642 VSS.n641 97.5005
R2392 VSS.n915 VSS.n914 97.5005
R2393 VSS.n912 VSS.n911 97.5005
R2394 VSS.n658 VSS.n86 97.5005
R2395 VSS.n661 VSS.n660 97.5005
R2396 VSS.n905 VSS.n904 97.5005
R2397 VSS.n908 VSS.n907 97.5005
R2398 VSS.n678 VSS.n677 97.5005
R2399 VSS.n681 VSS.n680 97.5005
R2400 VSS.n893 VSS.n93 97.5005
R2401 VSS.n94 VSS.n92 97.5005
R2402 VSS.n707 VSS.n706 97.5005
R2403 VSS.n710 VSS.n709 97.5005
R2404 VSS.n694 VSS.n95 97.5005
R2405 VSS.n695 VSS.n693 97.5005
R2406 VSS.n730 VSS.n99 97.5005
R2407 VSS.n733 VSS.n732 97.5005
R2408 VSS.n889 VSS.n888 97.5005
R2409 VSS.n886 VSS.n885 97.5005
R2410 VSS.n749 VSS.n101 97.5005
R2411 VSS.n752 VSS.n751 97.5005
R2412 VSS.n879 VSS.n878 97.5005
R2413 VSS.n882 VSS.n881 97.5005
R2414 VSS.n769 VSS.n768 97.5005
R2415 VSS.n772 VSS.n771 97.5005
R2416 VSS.n867 VSS.n108 97.5005
R2417 VSS.n109 VSS.n107 97.5005
R2418 VSS.n798 VSS.n797 97.5005
R2419 VSS.n801 VSS.n800 97.5005
R2420 VSS.n785 VSS.n110 97.5005
R2421 VSS.n786 VSS.n784 97.5005
R2422 VSS.n857 VSS.n856 97.5005
R2423 VSS.n854 VSS.n853 97.5005
R2424 VSS.n863 VSS.n862 97.5005
R2425 VSS.n860 VSS.n859 97.5005
R2426 VSS.n822 VSS.t125 87.7129
R2427 VSS.n812 VSS.t23 87.7129
R2428 VSS.n783 VSS.t11 87.7129
R2429 VSS.n106 VSS.t79 87.7129
R2430 VSS.n875 VSS.t13 87.7129
R2431 VSS.n721 VSS.t99 87.7129
R2432 VSS.n692 VSS.t35 87.7129
R2433 VSS.n91 VSS.t85 87.7129
R2434 VSS.n901 VSS.t49 87.7129
R2435 VSS.n630 VSS.t101 87.7129
R2436 VSS.n601 VSS.t67 87.7129
R2437 VSS.n76 VSS.t27 87.7129
R2438 VSS.n927 VSS.t7 87.7129
R2439 VSS.n539 VSS.t73 87.7129
R2440 VSS.n510 VSS.t51 87.7129
R2441 VSS.n61 VSS.t103 87.7129
R2442 VSS.n953 VSS.t105 87.7129
R2443 VSS.n448 VSS.t109 87.7129
R2444 VSS.n419 VSS.t119 87.7129
R2445 VSS.n46 VSS.t123 87.7129
R2446 VSS.n979 VSS.t91 87.7129
R2447 VSS.n357 VSS.t55 87.7129
R2448 VSS.n328 VSS.t61 87.7129
R2449 VSS.n31 VSS.t29 87.7129
R2450 VSS.n1005 VSS.t19 87.7129
R2451 VSS.n266 VSS.t53 87.7129
R2452 VSS.n237 VSS.t5 87.7129
R2453 VSS.n16 VSS.t57 87.7129
R2454 VSS.n1031 VSS.t111 87.7129
R2455 VSS.n175 VSS.t77 87.7129
R2456 VSS.n144 VSS.t115 87.7129
R2457 VSS.n1053 VSS.t113 87.7129
R2458 VSS.n827 VSS.t43 87.574
R2459 VSS.n821 VSS.t3 87.574
R2460 VSS.n791 VSS.t45 87.574
R2461 VSS.n105 VSS.t83 87.574
R2462 VSS.n102 VSS.t1 87.574
R2463 VSS.n724 VSS.t15 87.574
R2464 VSS.n700 VSS.t33 87.574
R2465 VSS.n90 VSS.t47 87.574
R2466 VSS.n87 VSS.t65 87.574
R2467 VSS.n633 VSS.t9 87.574
R2468 VSS.n609 VSS.t25 87.574
R2469 VSS.n75 VSS.t59 87.574
R2470 VSS.n72 VSS.t17 87.574
R2471 VSS.n542 VSS.t69 87.574
R2472 VSS.n518 VSS.t37 87.574
R2473 VSS.n60 VSS.t89 87.574
R2474 VSS.n57 VSS.t97 87.574
R2475 VSS.n451 VSS.t95 87.574
R2476 VSS.n427 VSS.t117 87.574
R2477 VSS.n45 VSS.t121 87.574
R2478 VSS.n42 VSS.t31 87.574
R2479 VSS.n360 VSS.t39 87.574
R2480 VSS.n336 VSS.t93 87.574
R2481 VSS.n30 VSS.t63 87.574
R2482 VSS.n27 VSS.t21 87.574
R2483 VSS.n269 VSS.t127 87.574
R2484 VSS.n245 VSS.t107 87.574
R2485 VSS.n15 VSS.t41 87.574
R2486 VSS.n12 VSS.t71 87.574
R2487 VSS.n178 VSS.t75 87.574
R2488 VSS.n154 VSS.t81 87.574
R2489 VSS.n122 VSS.t87 87.574
R2490 VSS.n826 VSS.n825 4.95915
R2491 VSS.n825 VSS.n824 3.4105
R2492 VSS.n790 VSS.n104 3.4105
R2493 VSS.n872 VSS.n871 3.4105
R2494 VSS.n874 VSS.n873 3.4105
R2495 VSS.n723 VSS.n103 3.4105
R2496 VSS.n699 VSS.n89 3.4105
R2497 VSS.n898 VSS.n897 3.4105
R2498 VSS.n900 VSS.n899 3.4105
R2499 VSS.n632 VSS.n88 3.4105
R2500 VSS.n608 VSS.n74 3.4105
R2501 VSS.n924 VSS.n923 3.4105
R2502 VSS.n926 VSS.n925 3.4105
R2503 VSS.n541 VSS.n73 3.4105
R2504 VSS.n517 VSS.n59 3.4105
R2505 VSS.n950 VSS.n949 3.4105
R2506 VSS.n952 VSS.n951 3.4105
R2507 VSS.n450 VSS.n58 3.4105
R2508 VSS.n426 VSS.n44 3.4105
R2509 VSS.n976 VSS.n975 3.4105
R2510 VSS.n978 VSS.n977 3.4105
R2511 VSS.n359 VSS.n43 3.4105
R2512 VSS.n335 VSS.n29 3.4105
R2513 VSS.n1002 VSS.n1001 3.4105
R2514 VSS.n1004 VSS.n1003 3.4105
R2515 VSS.n268 VSS.n28 3.4105
R2516 VSS.n244 VSS.n14 3.4105
R2517 VSS.n1028 VSS.n1027 3.4105
R2518 VSS.n1030 VSS.n1029 3.4105
R2519 VSS.n177 VSS.n13 3.4105
R2520 VSS.n153 VSS.n152 3.4105
R2521 VSS.n151 VSS.n0 3.4105
R2522 VSS.n825 VSS.n104 1.54915
R2523 VSS.n872 VSS.n104 1.54915
R2524 VSS.n873 VSS.n872 1.54915
R2525 VSS.n873 VSS.n103 1.54915
R2526 VSS.n103 VSS.n89 1.54915
R2527 VSS.n898 VSS.n89 1.54915
R2528 VSS.n899 VSS.n898 1.54915
R2529 VSS.n899 VSS.n88 1.54915
R2530 VSS.n88 VSS.n74 1.54915
R2531 VSS.n924 VSS.n74 1.54915
R2532 VSS.n925 VSS.n924 1.54915
R2533 VSS.n925 VSS.n73 1.54915
R2534 VSS.n73 VSS.n59 1.54915
R2535 VSS.n950 VSS.n59 1.54915
R2536 VSS.n951 VSS.n950 1.54915
R2537 VSS.n951 VSS.n58 1.54915
R2538 VSS.n58 VSS.n44 1.54915
R2539 VSS.n976 VSS.n44 1.54915
R2540 VSS.n977 VSS.n976 1.54915
R2541 VSS.n977 VSS.n43 1.54915
R2542 VSS.n43 VSS.n29 1.54915
R2543 VSS.n1002 VSS.n29 1.54915
R2544 VSS.n1003 VSS.n1002 1.54915
R2545 VSS.n1003 VSS.n28 1.54915
R2546 VSS.n28 VSS.n14 1.54915
R2547 VSS.n1028 VSS.n14 1.54915
R2548 VSS.n1029 VSS.n1028 1.54915
R2549 VSS.n1029 VSS.n13 1.54915
R2550 VSS.n152 VSS.n13 1.54915
R2551 VSS.n152 VSS.n151 1.54915
R2552 VSS.n151 VSS 1.27068
R2553 VSS.n820 VSS.n819 0.537643
R2554 VSS.n805 VSS.n792 0.537643
R2555 VSS.n776 VSS.n763 0.537643
R2556 VSS.n756 VSS.n744 0.537643
R2557 VSS.n737 VSS.n725 0.537643
R2558 VSS.n714 VSS.n701 0.537643
R2559 VSS.n685 VSS.n672 0.537643
R2560 VSS.n665 VSS.n653 0.537643
R2561 VSS.n646 VSS.n634 0.537643
R2562 VSS.n623 VSS.n610 0.537643
R2563 VSS.n594 VSS.n581 0.537643
R2564 VSS.n574 VSS.n562 0.537643
R2565 VSS.n555 VSS.n543 0.537643
R2566 VSS.n532 VSS.n519 0.537643
R2567 VSS.n503 VSS.n490 0.537643
R2568 VSS.n483 VSS.n471 0.537643
R2569 VSS.n464 VSS.n452 0.537643
R2570 VSS.n441 VSS.n428 0.537643
R2571 VSS.n412 VSS.n399 0.537643
R2572 VSS.n392 VSS.n380 0.537643
R2573 VSS.n373 VSS.n361 0.537643
R2574 VSS.n350 VSS.n337 0.537643
R2575 VSS.n321 VSS.n308 0.537643
R2576 VSS.n301 VSS.n289 0.537643
R2577 VSS.n282 VSS.n270 0.537643
R2578 VSS.n259 VSS.n246 0.537643
R2579 VSS.n230 VSS.n217 0.537643
R2580 VSS.n210 VSS.n198 0.537643
R2581 VSS.n191 VSS.n179 0.537643
R2582 VSS.n168 VSS.n155 0.537643
R2583 VSS.n137 VSS.n123 0.537643
R2584 VSS.n841 VSS.n828 0.537643
R2585 VSS.n824 VSS.n821 0.148214
R2586 VSS.n791 VSS.n790 0.148214
R2587 VSS.n871 VSS.n105 0.148214
R2588 VSS.n874 VSS.n102 0.148214
R2589 VSS.n724 VSS.n723 0.148214
R2590 VSS.n700 VSS.n699 0.148214
R2591 VSS.n897 VSS.n90 0.148214
R2592 VSS.n900 VSS.n87 0.148214
R2593 VSS.n633 VSS.n632 0.148214
R2594 VSS.n609 VSS.n608 0.148214
R2595 VSS.n923 VSS.n75 0.148214
R2596 VSS.n926 VSS.n72 0.148214
R2597 VSS.n542 VSS.n541 0.148214
R2598 VSS.n518 VSS.n517 0.148214
R2599 VSS.n949 VSS.n60 0.148214
R2600 VSS.n952 VSS.n57 0.148214
R2601 VSS.n451 VSS.n450 0.148214
R2602 VSS.n427 VSS.n426 0.148214
R2603 VSS.n975 VSS.n45 0.148214
R2604 VSS.n978 VSS.n42 0.148214
R2605 VSS.n360 VSS.n359 0.148214
R2606 VSS.n336 VSS.n335 0.148214
R2607 VSS.n1001 VSS.n30 0.148214
R2608 VSS.n1004 VSS.n27 0.148214
R2609 VSS.n269 VSS.n268 0.148214
R2610 VSS.n245 VSS.n244 0.148214
R2611 VSS.n1027 VSS.n15 0.148214
R2612 VSS.n1030 VSS.n12 0.148214
R2613 VSS.n178 VSS.n177 0.148214
R2614 VSS.n154 VSS.n153 0.148214
R2615 VSS.n122 VSS.n0 0.148214
R2616 VSS.n827 VSS.n826 0.148214
R2617 VSS.n822 VSS 0.143179
R2618 VSS.n812 VSS 0.143179
R2619 VSS.n783 VSS 0.143179
R2620 VSS.n106 VSS 0.143179
R2621 VSS.n875 VSS 0.143179
R2622 VSS.n721 VSS 0.143179
R2623 VSS.n692 VSS 0.143179
R2624 VSS.n91 VSS 0.143179
R2625 VSS.n901 VSS 0.143179
R2626 VSS.n630 VSS 0.143179
R2627 VSS.n601 VSS 0.143179
R2628 VSS.n76 VSS 0.143179
R2629 VSS.n927 VSS 0.143179
R2630 VSS.n539 VSS 0.143179
R2631 VSS.n510 VSS 0.143179
R2632 VSS.n61 VSS 0.143179
R2633 VSS.n953 VSS 0.143179
R2634 VSS.n448 VSS 0.143179
R2635 VSS.n419 VSS 0.143179
R2636 VSS.n46 VSS 0.143179
R2637 VSS.n979 VSS 0.143179
R2638 VSS.n357 VSS 0.143179
R2639 VSS.n328 VSS 0.143179
R2640 VSS.n31 VSS 0.143179
R2641 VSS.n1005 VSS 0.143179
R2642 VSS.n266 VSS 0.143179
R2643 VSS.n237 VSS 0.143179
R2644 VSS.n16 VSS 0.143179
R2645 VSS.n1031 VSS 0.143179
R2646 VSS.n175 VSS 0.143179
R2647 VSS.n144 VSS 0.143179
R2648 VSS VSS.n1053 0.143179
R2649 VSS.n824 VSS.n823 0.114643
R2650 VSS.n826 VSS.n818 0.114643
R2651 VSS.n790 VSS.n789 0.114643
R2652 VSS.n871 VSS.n870 0.114643
R2653 VSS.n876 VSS.n874 0.114643
R2654 VSS.n723 VSS.n722 0.114643
R2655 VSS.n699 VSS.n698 0.114643
R2656 VSS.n897 VSS.n896 0.114643
R2657 VSS.n902 VSS.n900 0.114643
R2658 VSS.n632 VSS.n631 0.114643
R2659 VSS.n608 VSS.n607 0.114643
R2660 VSS.n923 VSS.n922 0.114643
R2661 VSS.n928 VSS.n926 0.114643
R2662 VSS.n541 VSS.n540 0.114643
R2663 VSS.n517 VSS.n516 0.114643
R2664 VSS.n949 VSS.n948 0.114643
R2665 VSS.n954 VSS.n952 0.114643
R2666 VSS.n450 VSS.n449 0.114643
R2667 VSS.n426 VSS.n425 0.114643
R2668 VSS.n975 VSS.n974 0.114643
R2669 VSS.n980 VSS.n978 0.114643
R2670 VSS.n359 VSS.n358 0.114643
R2671 VSS.n335 VSS.n334 0.114643
R2672 VSS.n1001 VSS.n1000 0.114643
R2673 VSS.n1006 VSS.n1004 0.114643
R2674 VSS.n268 VSS.n267 0.114643
R2675 VSS.n244 VSS.n243 0.114643
R2676 VSS.n1027 VSS.n1026 0.114643
R2677 VSS.n1032 VSS.n1030 0.114643
R2678 VSS.n177 VSS.n176 0.114643
R2679 VSS.n153 VSS.n150 0.114643
R2680 VSS.n1052 VSS.n0 0.114643
R2681 VSS.n823 VSS.n822 0.0900238
R2682 VSS.n821 VSS.n820 0.0900238
R2683 VSS.n818 VSS.n812 0.0900238
R2684 VSS.n789 VSS.n783 0.0900238
R2685 VSS.n792 VSS.n791 0.0900238
R2686 VSS.n870 VSS.n106 0.0900238
R2687 VSS.n763 VSS.n105 0.0900238
R2688 VSS.n876 VSS.n875 0.0900238
R2689 VSS.n744 VSS.n102 0.0900238
R2690 VSS.n722 VSS.n721 0.0900238
R2691 VSS.n725 VSS.n724 0.0900238
R2692 VSS.n698 VSS.n692 0.0900238
R2693 VSS.n701 VSS.n700 0.0900238
R2694 VSS.n896 VSS.n91 0.0900238
R2695 VSS.n672 VSS.n90 0.0900238
R2696 VSS.n902 VSS.n901 0.0900238
R2697 VSS.n653 VSS.n87 0.0900238
R2698 VSS.n631 VSS.n630 0.0900238
R2699 VSS.n634 VSS.n633 0.0900238
R2700 VSS.n607 VSS.n601 0.0900238
R2701 VSS.n610 VSS.n609 0.0900238
R2702 VSS.n922 VSS.n76 0.0900238
R2703 VSS.n581 VSS.n75 0.0900238
R2704 VSS.n928 VSS.n927 0.0900238
R2705 VSS.n562 VSS.n72 0.0900238
R2706 VSS.n540 VSS.n539 0.0900238
R2707 VSS.n543 VSS.n542 0.0900238
R2708 VSS.n516 VSS.n510 0.0900238
R2709 VSS.n519 VSS.n518 0.0900238
R2710 VSS.n948 VSS.n61 0.0900238
R2711 VSS.n490 VSS.n60 0.0900238
R2712 VSS.n954 VSS.n953 0.0900238
R2713 VSS.n471 VSS.n57 0.0900238
R2714 VSS.n449 VSS.n448 0.0900238
R2715 VSS.n452 VSS.n451 0.0900238
R2716 VSS.n425 VSS.n419 0.0900238
R2717 VSS.n428 VSS.n427 0.0900238
R2718 VSS.n974 VSS.n46 0.0900238
R2719 VSS.n399 VSS.n45 0.0900238
R2720 VSS.n980 VSS.n979 0.0900238
R2721 VSS.n380 VSS.n42 0.0900238
R2722 VSS.n358 VSS.n357 0.0900238
R2723 VSS.n361 VSS.n360 0.0900238
R2724 VSS.n334 VSS.n328 0.0900238
R2725 VSS.n337 VSS.n336 0.0900238
R2726 VSS.n1000 VSS.n31 0.0900238
R2727 VSS.n308 VSS.n30 0.0900238
R2728 VSS.n1006 VSS.n1005 0.0900238
R2729 VSS.n289 VSS.n27 0.0900238
R2730 VSS.n267 VSS.n266 0.0900238
R2731 VSS.n270 VSS.n269 0.0900238
R2732 VSS.n243 VSS.n237 0.0900238
R2733 VSS.n246 VSS.n245 0.0900238
R2734 VSS.n1026 VSS.n16 0.0900238
R2735 VSS.n217 VSS.n15 0.0900238
R2736 VSS.n1032 VSS.n1031 0.0900238
R2737 VSS.n198 VSS.n12 0.0900238
R2738 VSS.n176 VSS.n175 0.0900238
R2739 VSS.n179 VSS.n178 0.0900238
R2740 VSS.n150 VSS.n144 0.0900238
R2741 VSS.n155 VSS.n154 0.0900238
R2742 VSS.n1053 VSS.n1052 0.0900238
R2743 VSS.n123 VSS.n122 0.0900238
R2744 VSS.n828 VSS.n827 0.0900238
R2745 a_665_916.t1 a_665_916.n2 667.521
R2746 a_665_916.n2 a_665_916.n0 4.34871
R2747 a_665_916.n0 a_665_916.n1 0.179548
R2748 a_665_916.n1 a_665_916.t2 233.82
R2749 a_665_916.n1 a_665_916.t4 312.329
R2750 a_665_916.n0 a_665_916.t3 433.293
R2751 a_665_916.n2 a_665_916.t0 85.1015
R2752 a_617_828.t0 a_617_828.n2 667.313
R2753 a_617_828.n2 a_617_828.n1 3.85693
R2754 a_617_828.n1 a_617_828.t2 234.183
R2755 a_617_828.n1 a_617_828.n0 4.41538
R2756 a_617_828.n0 a_617_828.t3 430.065
R2757 a_617_828.n0 a_617_828.t4 308.337
R2758 a_617_828.n2 a_617_828.t1 85.2404
R2759 a_665_3568.t0 a_665_3568.n2 667.521
R2760 a_665_3568.n2 a_665_3568.n0 4.34871
R2761 a_665_3568.n0 a_665_3568.n1 0.179548
R2762 a_665_3568.n1 a_665_3568.t2 233.82
R2763 a_665_3568.n1 a_665_3568.t4 312.329
R2764 a_665_3568.n0 a_665_3568.t3 433.293
R2765 a_665_3568.n2 a_665_3568.t1 85.1015
R2766 a_617_3480.t0 a_617_3480.n2 667.313
R2767 a_617_3480.n2 a_617_3480.n1 3.85693
R2768 a_617_3480.n1 a_617_3480.t2 234.183
R2769 a_617_3480.n1 a_617_3480.n0 4.41538
R2770 a_617_3480.n0 a_617_3480.t3 430.065
R2771 a_617_3480.n0 a_617_3480.t4 308.337
R2772 a_617_3480.n2 a_617_3480.t1 85.2404
R2773 a_665_6220.t1 a_665_6220.n2 667.521
R2774 a_665_6220.n2 a_665_6220.n0 4.34871
R2775 a_665_6220.n0 a_665_6220.n1 0.179548
R2776 a_665_6220.n1 a_665_6220.t2 233.82
R2777 a_665_6220.n1 a_665_6220.t4 312.329
R2778 a_665_6220.n0 a_665_6220.t3 433.293
R2779 a_665_6220.n2 a_665_6220.t0 85.1015
R2780 a_617_6132.t0 a_617_6132.n2 667.313
R2781 a_617_6132.n2 a_617_6132.n1 3.85693
R2782 a_617_6132.n1 a_617_6132.t2 234.183
R2783 a_617_6132.n1 a_617_6132.n0 4.41538
R2784 a_617_6132.n0 a_617_6132.t3 430.065
R2785 a_617_6132.n0 a_617_6132.t4 308.337
R2786 a_617_6132.n2 a_617_6132.t1 85.2404
R2787 a_665_8872.t1 a_665_8872.n2 667.521
R2788 a_665_8872.n2 a_665_8872.n0 4.34871
R2789 a_665_8872.n0 a_665_8872.n1 0.179548
R2790 a_665_8872.n1 a_665_8872.t2 233.82
R2791 a_665_8872.n1 a_665_8872.t4 312.329
R2792 a_665_8872.n0 a_665_8872.t3 433.293
R2793 a_665_8872.n2 a_665_8872.t0 85.1015
R2794 a_617_8784.t0 a_617_8784.n2 667.313
R2795 a_617_8784.n2 a_617_8784.n1 3.85693
R2796 a_617_8784.n1 a_617_8784.t2 234.183
R2797 a_617_8784.n1 a_617_8784.n0 4.41538
R2798 a_617_8784.n0 a_617_8784.t3 430.065
R2799 a_617_8784.n0 a_617_8784.t4 308.337
R2800 a_617_8784.n2 a_617_8784.t1 85.2404
R2801 a_665_11524.t1 a_665_11524.n2 667.521
R2802 a_665_11524.n2 a_665_11524.n0 4.34871
R2803 a_665_11524.n0 a_665_11524.n1 0.179548
R2804 a_665_11524.n1 a_665_11524.t2 233.82
R2805 a_665_11524.n1 a_665_11524.t4 312.329
R2806 a_665_11524.n0 a_665_11524.t3 433.293
R2807 a_665_11524.n2 a_665_11524.t0 85.1015
R2808 a_617_11436.t0 a_617_11436.n2 667.313
R2809 a_617_11436.n2 a_617_11436.n1 3.85693
R2810 a_617_11436.n1 a_617_11436.t2 234.183
R2811 a_617_11436.n1 a_617_11436.n0 4.41538
R2812 a_617_11436.n0 a_617_11436.t3 430.065
R2813 a_617_11436.n0 a_617_11436.t4 308.337
R2814 a_617_11436.n2 a_617_11436.t1 85.2404
R2815 a_665_14176.t0 a_665_14176.n2 667.521
R2816 a_665_14176.n2 a_665_14176.n0 4.34871
R2817 a_665_14176.n0 a_665_14176.n1 0.179548
R2818 a_665_14176.n1 a_665_14176.t2 233.82
R2819 a_665_14176.n1 a_665_14176.t4 312.329
R2820 a_665_14176.n0 a_665_14176.t3 433.293
R2821 a_665_14176.n2 a_665_14176.t1 85.1015
R2822 a_617_14088.t0 a_617_14088.n2 667.313
R2823 a_617_14088.n2 a_617_14088.n1 3.85693
R2824 a_617_14088.n1 a_617_14088.t2 234.183
R2825 a_617_14088.n1 a_617_14088.n0 4.41538
R2826 a_617_14088.n0 a_617_14088.t3 430.065
R2827 a_617_14088.n0 a_617_14088.t4 308.337
R2828 a_617_14088.n2 a_617_14088.t1 85.2404
R2829 a_665_16828.t1 a_665_16828.n2 667.521
R2830 a_665_16828.n2 a_665_16828.n0 4.34871
R2831 a_665_16828.n0 a_665_16828.n1 0.179548
R2832 a_665_16828.n1 a_665_16828.t2 233.82
R2833 a_665_16828.n1 a_665_16828.t4 312.329
R2834 a_665_16828.n0 a_665_16828.t3 433.293
R2835 a_665_16828.n2 a_665_16828.t0 85.1015
R2836 a_617_16740.t0 a_617_16740.n2 667.313
R2837 a_617_16740.n2 a_617_16740.n1 3.85693
R2838 a_617_16740.n1 a_617_16740.t2 234.183
R2839 a_617_16740.n1 a_617_16740.n0 4.41538
R2840 a_617_16740.n0 a_617_16740.t3 430.065
R2841 a_617_16740.n0 a_617_16740.t4 308.337
R2842 a_617_16740.n2 a_617_16740.t1 85.2404
R2843 a_665_19480.t0 a_665_19480.n2 667.521
R2844 a_665_19480.n2 a_665_19480.n0 4.34871
R2845 a_665_19480.n0 a_665_19480.n1 0.179548
R2846 a_665_19480.n1 a_665_19480.t2 233.82
R2847 a_665_19480.n1 a_665_19480.t4 312.329
R2848 a_665_19480.n0 a_665_19480.t3 433.293
R2849 a_665_19480.n2 a_665_19480.t1 85.1015
R2850 a_617_19392.t0 a_617_19392.n2 667.313
R2851 a_617_19392.n2 a_617_19392.n1 3.85693
R2852 a_617_19392.n1 a_617_19392.t2 234.183
R2853 a_617_19392.n1 a_617_19392.n0 4.41538
R2854 a_617_19392.n0 a_617_19392.t3 430.065
R2855 a_617_19392.n0 a_617_19392.t4 308.337
R2856 a_617_19392.n2 a_617_19392.t1 85.2404
R2857 a_665_22132.t1 a_665_22132.n2 667.521
R2858 a_665_22132.n2 a_665_22132.n0 4.34871
R2859 a_665_22132.n0 a_665_22132.n1 0.179548
R2860 a_665_22132.n1 a_665_22132.t2 233.82
R2861 a_665_22132.n1 a_665_22132.t4 312.329
R2862 a_665_22132.n0 a_665_22132.t3 433.293
R2863 a_665_22132.n2 a_665_22132.t0 85.1015
R2864 a_617_22044.t0 a_617_22044.n2 667.313
R2865 a_617_22044.n2 a_617_22044.n1 3.85693
R2866 a_617_22044.n1 a_617_22044.t2 234.183
R2867 a_617_22044.n1 a_617_22044.n0 4.41538
R2868 a_617_22044.n0 a_617_22044.t3 430.065
R2869 a_617_22044.n0 a_617_22044.t4 308.337
R2870 a_617_22044.n2 a_617_22044.t1 85.2404
R2871 a_665_24784.t0 a_665_24784.n2 667.521
R2872 a_665_24784.n2 a_665_24784.n0 4.34871
R2873 a_665_24784.n0 a_665_24784.n1 0.179548
R2874 a_665_24784.n1 a_665_24784.t2 233.82
R2875 a_665_24784.n1 a_665_24784.t4 312.329
R2876 a_665_24784.n0 a_665_24784.t3 433.293
R2877 a_665_24784.n2 a_665_24784.t1 85.1015
R2878 a_617_24696.t0 a_617_24696.n2 667.313
R2879 a_617_24696.n2 a_617_24696.n1 3.85693
R2880 a_617_24696.n1 a_617_24696.t2 234.183
R2881 a_617_24696.n1 a_617_24696.n0 4.41538
R2882 a_617_24696.n0 a_617_24696.t3 430.065
R2883 a_617_24696.n0 a_617_24696.t4 308.337
R2884 a_617_24696.n2 a_617_24696.t1 85.2404
R2885 a_665_27436.t0 a_665_27436.n2 667.521
R2886 a_665_27436.n2 a_665_27436.n0 4.34871
R2887 a_665_27436.n0 a_665_27436.n1 0.179548
R2888 a_665_27436.n1 a_665_27436.t2 233.82
R2889 a_665_27436.n1 a_665_27436.t4 312.329
R2890 a_665_27436.n0 a_665_27436.t3 433.293
R2891 a_665_27436.n2 a_665_27436.t1 85.1015
R2892 a_617_27348.t0 a_617_27348.n2 667.313
R2893 a_617_27348.n2 a_617_27348.n1 3.85693
R2894 a_617_27348.n1 a_617_27348.t2 234.183
R2895 a_617_27348.n1 a_617_27348.n0 4.41538
R2896 a_617_27348.n0 a_617_27348.t3 430.065
R2897 a_617_27348.n0 a_617_27348.t4 308.337
R2898 a_617_27348.n2 a_617_27348.t1 85.2404
R2899 a_665_30088.t1 a_665_30088.n2 667.521
R2900 a_665_30088.n2 a_665_30088.n0 4.34871
R2901 a_665_30088.n0 a_665_30088.n1 0.179548
R2902 a_665_30088.n1 a_665_30088.t2 233.82
R2903 a_665_30088.n1 a_665_30088.t4 312.329
R2904 a_665_30088.n0 a_665_30088.t3 433.293
R2905 a_665_30088.n2 a_665_30088.t0 85.1015
R2906 a_617_30000.t0 a_617_30000.n2 667.313
R2907 a_617_30000.n2 a_617_30000.n1 3.85693
R2908 a_617_30000.n1 a_617_30000.t2 234.183
R2909 a_617_30000.n1 a_617_30000.n0 4.41538
R2910 a_617_30000.n0 a_617_30000.t3 430.065
R2911 a_617_30000.n0 a_617_30000.t4 308.337
R2912 a_617_30000.n2 a_617_30000.t1 85.2404
R2913 a_665_32740.t1 a_665_32740.n2 667.521
R2914 a_665_32740.n2 a_665_32740.n0 4.34871
R2915 a_665_32740.n0 a_665_32740.n1 0.179548
R2916 a_665_32740.n1 a_665_32740.t2 233.82
R2917 a_665_32740.n1 a_665_32740.t4 312.329
R2918 a_665_32740.n0 a_665_32740.t3 433.293
R2919 a_665_32740.n2 a_665_32740.t0 85.1015
R2920 a_617_32652.t0 a_617_32652.n2 667.313
R2921 a_617_32652.n2 a_617_32652.n1 3.85693
R2922 a_617_32652.n1 a_617_32652.t2 234.183
R2923 a_617_32652.n1 a_617_32652.n0 4.41538
R2924 a_617_32652.n0 a_617_32652.t3 430.065
R2925 a_617_32652.n0 a_617_32652.t4 308.337
R2926 a_617_32652.n2 a_617_32652.t1 85.2404
R2927 a_665_35392.t0 a_665_35392.n2 667.521
R2928 a_665_35392.n2 a_665_35392.n0 4.34871
R2929 a_665_35392.n0 a_665_35392.n1 0.179548
R2930 a_665_35392.n1 a_665_35392.t2 233.82
R2931 a_665_35392.n1 a_665_35392.t4 312.329
R2932 a_665_35392.n0 a_665_35392.t3 433.293
R2933 a_665_35392.n2 a_665_35392.t1 85.1015
R2934 a_617_35304.t0 a_617_35304.n2 667.313
R2935 a_617_35304.n2 a_617_35304.n1 3.85693
R2936 a_617_35304.n1 a_617_35304.t2 234.183
R2937 a_617_35304.n1 a_617_35304.n0 4.41538
R2938 a_617_35304.n0 a_617_35304.t3 430.065
R2939 a_617_35304.n0 a_617_35304.t4 308.337
R2940 a_617_35304.n2 a_617_35304.t1 85.2404
R2941 a_665_38044.t0 a_665_38044.n2 667.521
R2942 a_665_38044.n2 a_665_38044.n0 4.34871
R2943 a_665_38044.n0 a_665_38044.n1 0.179548
R2944 a_665_38044.n1 a_665_38044.t2 233.82
R2945 a_665_38044.n1 a_665_38044.t4 312.329
R2946 a_665_38044.n0 a_665_38044.t3 433.293
R2947 a_665_38044.n2 a_665_38044.t1 85.1015
R2948 a_617_37956.t0 a_617_37956.n2 667.313
R2949 a_617_37956.n2 a_617_37956.n1 3.85693
R2950 a_617_37956.n1 a_617_37956.t2 234.183
R2951 a_617_37956.n1 a_617_37956.n0 4.41538
R2952 a_617_37956.n0 a_617_37956.t3 430.065
R2953 a_617_37956.n0 a_617_37956.t4 308.337
R2954 a_617_37956.n2 a_617_37956.t1 85.2404
R2955 a_665_40696.t0 a_665_40696.n2 667.521
R2956 a_665_40696.n2 a_665_40696.n0 4.34871
R2957 a_665_40696.n0 a_665_40696.n1 0.179548
R2958 a_665_40696.n1 a_665_40696.t2 233.82
R2959 a_665_40696.n1 a_665_40696.t4 312.329
R2960 a_665_40696.n0 a_665_40696.t3 433.293
R2961 a_665_40696.n2 a_665_40696.t1 85.1015
R2962 a_617_40608.t0 a_617_40608.n2 667.313
R2963 a_617_40608.n2 a_617_40608.n1 3.85693
R2964 a_617_40608.n1 a_617_40608.t2 234.183
R2965 a_617_40608.n1 a_617_40608.n0 4.41538
R2966 a_617_40608.n0 a_617_40608.t3 430.065
R2967 a_617_40608.n0 a_617_40608.t4 308.337
R2968 a_617_40608.n2 a_617_40608.t1 85.2404
R2969 a_665_43348.t0 a_665_43348.n2 667.521
R2970 a_665_43348.n2 a_665_43348.n0 4.34871
R2971 a_665_43348.n0 a_665_43348.n1 0.179548
R2972 a_665_43348.n1 a_665_43348.t2 233.82
R2973 a_665_43348.n1 a_665_43348.t4 312.329
R2974 a_665_43348.n0 a_665_43348.t3 433.293
R2975 a_665_43348.n2 a_665_43348.t1 85.1015
R2976 a_617_43260.t0 a_617_43260.n2 667.313
R2977 a_617_43260.n2 a_617_43260.n1 3.85693
R2978 a_617_43260.n1 a_617_43260.t2 234.183
R2979 a_617_43260.n1 a_617_43260.n0 4.41538
R2980 a_617_43260.n0 a_617_43260.t3 430.065
R2981 a_617_43260.n0 a_617_43260.t4 308.337
R2982 a_617_43260.n2 a_617_43260.t1 85.2404
R2983 a_665_46000.t0 a_665_46000.n2 667.521
R2984 a_665_46000.n2 a_665_46000.n0 4.34871
R2985 a_665_46000.n0 a_665_46000.n1 0.179548
R2986 a_665_46000.n1 a_665_46000.t2 233.82
R2987 a_665_46000.n1 a_665_46000.t4 312.329
R2988 a_665_46000.n0 a_665_46000.t3 433.293
R2989 a_665_46000.n2 a_665_46000.t1 85.1015
R2990 a_617_45912.t0 a_617_45912.n2 667.313
R2991 a_617_45912.n2 a_617_45912.n1 3.85693
R2992 a_617_45912.n1 a_617_45912.t2 234.183
R2993 a_617_45912.n1 a_617_45912.n0 4.41538
R2994 a_617_45912.n0 a_617_45912.t3 430.065
R2995 a_617_45912.n0 a_617_45912.t4 308.337
R2996 a_617_45912.n2 a_617_45912.t1 85.2404
R2997 a_665_48652.t1 a_665_48652.n2 667.521
R2998 a_665_48652.n2 a_665_48652.n0 4.34871
R2999 a_665_48652.n0 a_665_48652.n1 0.179548
R3000 a_665_48652.n1 a_665_48652.t2 233.82
R3001 a_665_48652.n1 a_665_48652.t4 312.329
R3002 a_665_48652.n0 a_665_48652.t3 433.293
R3003 a_665_48652.n2 a_665_48652.t0 85.1015
R3004 a_617_48564.t0 a_617_48564.n2 667.313
R3005 a_617_48564.n2 a_617_48564.n1 3.85693
R3006 a_617_48564.n1 a_617_48564.t2 234.183
R3007 a_617_48564.n1 a_617_48564.n0 4.41538
R3008 a_617_48564.n0 a_617_48564.t3 430.065
R3009 a_617_48564.n0 a_617_48564.t4 308.337
R3010 a_617_48564.n2 a_617_48564.t1 85.2404
R3011 a_665_51304.t1 a_665_51304.n2 667.521
R3012 a_665_51304.n2 a_665_51304.n0 4.34871
R3013 a_665_51304.n0 a_665_51304.n1 0.179548
R3014 a_665_51304.n1 a_665_51304.t2 233.82
R3015 a_665_51304.n1 a_665_51304.t4 312.329
R3016 a_665_51304.n0 a_665_51304.t3 433.293
R3017 a_665_51304.n2 a_665_51304.t0 85.1015
R3018 a_617_51216.t0 a_617_51216.n2 667.313
R3019 a_617_51216.n2 a_617_51216.n1 3.85693
R3020 a_617_51216.n1 a_617_51216.t2 234.183
R3021 a_617_51216.n1 a_617_51216.n0 4.41538
R3022 a_617_51216.n0 a_617_51216.t3 430.065
R3023 a_617_51216.n0 a_617_51216.t4 308.337
R3024 a_617_51216.n2 a_617_51216.t1 85.2404
R3025 a_665_53956.t1 a_665_53956.n2 667.521
R3026 a_665_53956.n2 a_665_53956.n0 4.34871
R3027 a_665_53956.n0 a_665_53956.n1 0.179548
R3028 a_665_53956.n1 a_665_53956.t2 233.82
R3029 a_665_53956.n1 a_665_53956.t4 312.329
R3030 a_665_53956.n0 a_665_53956.t3 433.293
R3031 a_665_53956.n2 a_665_53956.t0 85.1015
R3032 a_617_53868.t0 a_617_53868.n2 667.313
R3033 a_617_53868.n2 a_617_53868.n1 3.85693
R3034 a_617_53868.n1 a_617_53868.t2 234.183
R3035 a_617_53868.n1 a_617_53868.n0 4.41538
R3036 a_617_53868.n0 a_617_53868.t3 430.065
R3037 a_617_53868.n0 a_617_53868.t4 308.337
R3038 a_617_53868.n2 a_617_53868.t1 85.2404
R3039 a_665_56608.t1 a_665_56608.n2 667.521
R3040 a_665_56608.n2 a_665_56608.n0 4.34871
R3041 a_665_56608.n0 a_665_56608.n1 0.179548
R3042 a_665_56608.n1 a_665_56608.t2 233.82
R3043 a_665_56608.n1 a_665_56608.t4 312.329
R3044 a_665_56608.n0 a_665_56608.t3 433.293
R3045 a_665_56608.n2 a_665_56608.t0 85.1015
R3046 a_617_56520.t0 a_617_56520.n2 667.313
R3047 a_617_56520.n2 a_617_56520.n1 3.85693
R3048 a_617_56520.n1 a_617_56520.t2 234.183
R3049 a_617_56520.n1 a_617_56520.n0 4.41538
R3050 a_617_56520.n0 a_617_56520.t3 430.065
R3051 a_617_56520.n0 a_617_56520.t4 308.337
R3052 a_617_56520.n2 a_617_56520.t1 85.2404
R3053 a_665_59260.t0 a_665_59260.n2 667.521
R3054 a_665_59260.n2 a_665_59260.n0 4.34871
R3055 a_665_59260.n0 a_665_59260.n1 0.179548
R3056 a_665_59260.n1 a_665_59260.t2 233.82
R3057 a_665_59260.n1 a_665_59260.t4 312.329
R3058 a_665_59260.n0 a_665_59260.t3 433.293
R3059 a_665_59260.n2 a_665_59260.t1 85.1015
R3060 a_617_59172.t0 a_617_59172.n2 667.313
R3061 a_617_59172.n2 a_617_59172.n1 3.85693
R3062 a_617_59172.n1 a_617_59172.t2 234.183
R3063 a_617_59172.n1 a_617_59172.n0 4.41538
R3064 a_617_59172.n0 a_617_59172.t3 430.065
R3065 a_617_59172.n0 a_617_59172.t4 308.337
R3066 a_617_59172.n2 a_617_59172.t1 85.2404
R3067 a_665_61912.t1 a_665_61912.n2 667.521
R3068 a_665_61912.n2 a_665_61912.n0 4.34871
R3069 a_665_61912.n0 a_665_61912.n1 0.179548
R3070 a_665_61912.n1 a_665_61912.t2 233.82
R3071 a_665_61912.n1 a_665_61912.t4 312.329
R3072 a_665_61912.n0 a_665_61912.t3 433.293
R3073 a_665_61912.n2 a_665_61912.t0 85.1015
R3074 a_617_61824.t0 a_617_61824.n2 667.313
R3075 a_617_61824.n2 a_617_61824.n1 3.85693
R3076 a_617_61824.n1 a_617_61824.t2 234.183
R3077 a_617_61824.n1 a_617_61824.n0 4.41538
R3078 a_617_61824.n0 a_617_61824.t3 430.065
R3079 a_617_61824.n0 a_617_61824.t4 308.337
R3080 a_617_61824.n2 a_617_61824.t1 85.2404
R3081 a_665_64564.t1 a_665_64564.n2 667.521
R3082 a_665_64564.n2 a_665_64564.n0 4.34871
R3083 a_665_64564.n0 a_665_64564.n1 0.179548
R3084 a_665_64564.n1 a_665_64564.t2 233.82
R3085 a_665_64564.n1 a_665_64564.t4 312.329
R3086 a_665_64564.n0 a_665_64564.t3 433.293
R3087 a_665_64564.n2 a_665_64564.t0 85.1015
R3088 a_617_64476.t0 a_617_64476.n2 667.313
R3089 a_617_64476.n2 a_617_64476.n1 3.85693
R3090 a_617_64476.n1 a_617_64476.t2 234.183
R3091 a_617_64476.n1 a_617_64476.n0 4.41538
R3092 a_617_64476.n0 a_617_64476.t3 430.065
R3093 a_617_64476.n0 a_617_64476.t4 308.337
R3094 a_617_64476.n2 a_617_64476.t1 85.2404
R3095 a_665_67216.t0 a_665_67216.n2 667.521
R3096 a_665_67216.n2 a_665_67216.n0 4.34871
R3097 a_665_67216.n0 a_665_67216.n1 0.179548
R3098 a_665_67216.n1 a_665_67216.t2 233.82
R3099 a_665_67216.n1 a_665_67216.t4 312.329
R3100 a_665_67216.n0 a_665_67216.t3 433.293
R3101 a_665_67216.n2 a_665_67216.t1 85.1015
R3102 a_617_67128.t0 a_617_67128.n2 667.313
R3103 a_617_67128.n2 a_617_67128.n1 3.85693
R3104 a_617_67128.n1 a_617_67128.t2 234.183
R3105 a_617_67128.n1 a_617_67128.n0 4.41538
R3106 a_617_67128.n0 a_617_67128.t3 430.065
R3107 a_617_67128.n0 a_617_67128.t4 308.337
R3108 a_617_67128.n2 a_617_67128.t1 85.2404
R3109 a_665_69868.t1 a_665_69868.n2 667.521
R3110 a_665_69868.n2 a_665_69868.n0 4.34871
R3111 a_665_69868.n0 a_665_69868.n1 0.179548
R3112 a_665_69868.n1 a_665_69868.t2 233.82
R3113 a_665_69868.n1 a_665_69868.t4 312.329
R3114 a_665_69868.n0 a_665_69868.t3 433.293
R3115 a_665_69868.n2 a_665_69868.t0 85.1015
R3116 a_617_69780.t0 a_617_69780.n2 667.313
R3117 a_617_69780.n2 a_617_69780.n1 3.85693
R3118 a_617_69780.n1 a_617_69780.t2 234.183
R3119 a_617_69780.n1 a_617_69780.n0 4.41538
R3120 a_617_69780.n0 a_617_69780.t3 430.065
R3121 a_617_69780.n0 a_617_69780.t4 308.337
R3122 a_617_69780.n2 a_617_69780.t1 85.2404
R3123 a_665_72520.t0 a_665_72520.n2 667.521
R3124 a_665_72520.n2 a_665_72520.n0 4.34871
R3125 a_665_72520.n0 a_665_72520.n1 0.179548
R3126 a_665_72520.n1 a_665_72520.t2 233.82
R3127 a_665_72520.n1 a_665_72520.t4 312.329
R3128 a_665_72520.n0 a_665_72520.t3 433.293
R3129 a_665_72520.n2 a_665_72520.t1 85.1015
R3130 a_617_72432.t0 a_617_72432.n2 667.313
R3131 a_617_72432.n2 a_617_72432.n1 3.85693
R3132 a_617_72432.n1 a_617_72432.t2 234.183
R3133 a_617_72432.n1 a_617_72432.n0 4.41538
R3134 a_617_72432.n0 a_617_72432.t3 430.065
R3135 a_617_72432.n0 a_617_72432.t4 308.337
R3136 a_617_72432.n2 a_617_72432.t1 85.2404
R3137 a_665_75172.t0 a_665_75172.n2 667.521
R3138 a_665_75172.n2 a_665_75172.n0 4.34871
R3139 a_665_75172.n0 a_665_75172.n1 0.179548
R3140 a_665_75172.n1 a_665_75172.t2 233.82
R3141 a_665_75172.n1 a_665_75172.t4 312.329
R3142 a_665_75172.n0 a_665_75172.t3 433.293
R3143 a_665_75172.n2 a_665_75172.t1 85.1015
R3144 a_617_75084.t0 a_617_75084.n2 667.313
R3145 a_617_75084.n2 a_617_75084.n1 3.85693
R3146 a_617_75084.n1 a_617_75084.t2 234.183
R3147 a_617_75084.n1 a_617_75084.n0 4.41538
R3148 a_617_75084.n0 a_617_75084.t3 430.065
R3149 a_617_75084.n0 a_617_75084.t4 308.337
R3150 a_617_75084.n2 a_617_75084.t1 85.2404
R3151 a_665_77824.t0 a_665_77824.n2 667.521
R3152 a_665_77824.n2 a_665_77824.n0 4.34871
R3153 a_665_77824.n0 a_665_77824.n1 0.179548
R3154 a_665_77824.n1 a_665_77824.t2 233.82
R3155 a_665_77824.n1 a_665_77824.t4 312.329
R3156 a_665_77824.n0 a_665_77824.t3 433.293
R3157 a_665_77824.n2 a_665_77824.t1 85.1015
R3158 a_617_77736.t0 a_617_77736.n2 667.313
R3159 a_617_77736.n2 a_617_77736.n1 3.85693
R3160 a_617_77736.n1 a_617_77736.t2 234.183
R3161 a_617_77736.n1 a_617_77736.n0 4.41538
R3162 a_617_77736.n0 a_617_77736.t3 430.065
R3163 a_617_77736.n0 a_617_77736.t4 308.337
R3164 a_617_77736.n2 a_617_77736.t1 85.2404
R3165 a_665_80476.t0 a_665_80476.n2 667.521
R3166 a_665_80476.n2 a_665_80476.n0 4.34871
R3167 a_665_80476.n0 a_665_80476.n1 0.179548
R3168 a_665_80476.n1 a_665_80476.t2 233.82
R3169 a_665_80476.n1 a_665_80476.t4 312.329
R3170 a_665_80476.n0 a_665_80476.t3 433.293
R3171 a_665_80476.n2 a_665_80476.t1 85.1015
R3172 a_617_80388.t0 a_617_80388.n2 667.313
R3173 a_617_80388.n2 a_617_80388.n1 3.85693
R3174 a_617_80388.n1 a_617_80388.t2 234.183
R3175 a_617_80388.n1 a_617_80388.n0 4.41538
R3176 a_617_80388.n0 a_617_80388.t3 430.065
R3177 a_617_80388.n0 a_617_80388.t4 308.337
R3178 a_617_80388.n2 a_617_80388.t1 85.2404
R3179 a_665_83128.t0 a_665_83128.n2 667.521
R3180 a_665_83128.n2 a_665_83128.n0 4.34871
R3181 a_665_83128.n0 a_665_83128.n1 0.179548
R3182 a_665_83128.n1 a_665_83128.t2 233.82
R3183 a_665_83128.n1 a_665_83128.t4 312.329
R3184 a_665_83128.n0 a_665_83128.t3 433.293
R3185 a_665_83128.n2 a_665_83128.t1 85.1015
R3186 a_617_83040.t0 a_617_83040.n2 667.313
R3187 a_617_83040.n2 a_617_83040.n1 3.85693
R3188 a_617_83040.n1 a_617_83040.t2 234.183
R3189 a_617_83040.n1 a_617_83040.n0 4.41538
R3190 a_617_83040.n0 a_617_83040.t3 430.065
R3191 a_617_83040.n0 a_617_83040.t4 308.337
R3192 a_617_83040.n2 a_617_83040.t1 85.2404
C6 BLB VSS 72.12333f
C7 BL VSS 45.09605f
C8 WLOFF VSS 0.1592p
C9 VDD VSS 0.12403p
C10 a_617_83040.t0 VSS 0.03239f $ **FLOATING
C11 a_617_83040.t1 VSS 0.11379f $ **FLOATING
C12 a_617_83040.t4 VSS 0.0614f $ **FLOATING
C13 a_617_83040.n0 VSS 1.06718f $ **FLOATING
C14 a_617_83040.t3 VSS 0.08266f $ **FLOATING
C15 a_617_83040.t2 VSS 0.06931f $ **FLOATING
C16 a_617_83040.n1 VSS 2.81269f $ **FLOATING
C17 a_617_83040.n2 VSS 1.07601f $ **FLOATING
C18 a_665_83128.t0 VSS 0.04034f $ **FLOATING
C19 a_665_83128.t1 VSS 0.1399f $ **FLOATING
C20 a_665_83128.t3 VSS 0.1109f $ **FLOATING
C21 a_665_83128.n0 VSS 2.1681f $ **FLOATING
C22 a_665_83128.t4 VSS 0.08257f $ **FLOATING
C23 a_665_83128.n1 VSS 3.051f $ **FLOATING
C24 a_665_83128.t2 VSS 0.08432f $ **FLOATING
C25 a_665_83128.n2 VSS 1.48906f $ **FLOATING
C26 a_617_80388.t0 VSS 0.03251f $ **FLOATING
C27 a_617_80388.t1 VSS 0.11421f $ **FLOATING
C28 a_617_80388.t4 VSS 0.06163f $ **FLOATING
C29 a_617_80388.n0 VSS 1.07118f $ **FLOATING
C30 a_617_80388.t3 VSS 0.08297f $ **FLOATING
C31 a_617_80388.t2 VSS 0.06956f $ **FLOATING
C32 a_617_80388.n1 VSS 2.82323f $ **FLOATING
C33 a_617_80388.n2 VSS 1.08005f $ **FLOATING
C34 a_665_80476.t0 VSS 0.04057f $ **FLOATING
C35 a_665_80476.t1 VSS 0.14071f $ **FLOATING
C36 a_665_80476.t3 VSS 0.11155f $ **FLOATING
C37 a_665_80476.n0 VSS 2.18072f $ **FLOATING
C38 a_665_80476.t4 VSS 0.08305f $ **FLOATING
C39 a_665_80476.n1 VSS 3.06877f $ **FLOATING
C40 a_665_80476.t2 VSS 0.08481f $ **FLOATING
C41 a_665_80476.n2 VSS 1.49773f $ **FLOATING
C42 a_617_77736.t0 VSS 0.03251f $ **FLOATING
C43 a_617_77736.t1 VSS 0.11421f $ **FLOATING
C44 a_617_77736.t4 VSS 0.06163f $ **FLOATING
C45 a_617_77736.n0 VSS 1.07118f $ **FLOATING
C46 a_617_77736.t3 VSS 0.08297f $ **FLOATING
C47 a_617_77736.t2 VSS 0.06956f $ **FLOATING
C48 a_617_77736.n1 VSS 2.82324f $ **FLOATING
C49 a_617_77736.n2 VSS 1.08005f $ **FLOATING
C50 a_665_77824.t0 VSS 0.04057f $ **FLOATING
C51 a_665_77824.t1 VSS 0.14071f $ **FLOATING
C52 a_665_77824.t3 VSS 0.11155f $ **FLOATING
C53 a_665_77824.n0 VSS 2.18072f $ **FLOATING
C54 a_665_77824.t4 VSS 0.08305f $ **FLOATING
C55 a_665_77824.n1 VSS 3.06877f $ **FLOATING
C56 a_665_77824.t2 VSS 0.08481f $ **FLOATING
C57 a_665_77824.n2 VSS 1.49773f $ **FLOATING
C58 a_617_75084.t0 VSS 0.03251f $ **FLOATING
C59 a_617_75084.t1 VSS 0.11421f $ **FLOATING
C60 a_617_75084.t4 VSS 0.06163f $ **FLOATING
C61 a_617_75084.n0 VSS 1.07118f $ **FLOATING
C62 a_617_75084.t3 VSS 0.08297f $ **FLOATING
C63 a_617_75084.t2 VSS 0.06956f $ **FLOATING
C64 a_617_75084.n1 VSS 2.82324f $ **FLOATING
C65 a_617_75084.n2 VSS 1.08005f $ **FLOATING
C66 a_665_75172.t0 VSS 0.04057f $ **FLOATING
C67 a_665_75172.t1 VSS 0.14071f $ **FLOATING
C68 a_665_75172.t3 VSS 0.11155f $ **FLOATING
C69 a_665_75172.n0 VSS 2.18072f $ **FLOATING
C70 a_665_75172.t4 VSS 0.08305f $ **FLOATING
C71 a_665_75172.n1 VSS 3.06877f $ **FLOATING
C72 a_665_75172.t2 VSS 0.08481f $ **FLOATING
C73 a_665_75172.n2 VSS 1.49773f $ **FLOATING
C74 a_617_72432.t0 VSS 0.03251f $ **FLOATING
C75 a_617_72432.t1 VSS 0.11421f $ **FLOATING
C76 a_617_72432.t4 VSS 0.06163f $ **FLOATING
C77 a_617_72432.n0 VSS 1.07118f $ **FLOATING
C78 a_617_72432.t3 VSS 0.08297f $ **FLOATING
C79 a_617_72432.t2 VSS 0.06956f $ **FLOATING
C80 a_617_72432.n1 VSS 2.82323f $ **FLOATING
C81 a_617_72432.n2 VSS 1.08005f $ **FLOATING
C82 a_665_72520.t0 VSS 0.04057f $ **FLOATING
C83 a_665_72520.t1 VSS 0.14071f $ **FLOATING
C84 a_665_72520.t3 VSS 0.11155f $ **FLOATING
C85 a_665_72520.n0 VSS 2.18072f $ **FLOATING
C86 a_665_72520.t4 VSS 0.08305f $ **FLOATING
C87 a_665_72520.n1 VSS 3.06877f $ **FLOATING
C88 a_665_72520.t2 VSS 0.08481f $ **FLOATING
C89 a_665_72520.n2 VSS 1.49773f $ **FLOATING
C90 a_617_69780.t0 VSS 0.03251f $ **FLOATING
C91 a_617_69780.t1 VSS 0.11421f $ **FLOATING
C92 a_617_69780.t4 VSS 0.06163f $ **FLOATING
C93 a_617_69780.n0 VSS 1.07118f $ **FLOATING
C94 a_617_69780.t3 VSS 0.08297f $ **FLOATING
C95 a_617_69780.t2 VSS 0.06956f $ **FLOATING
C96 a_617_69780.n1 VSS 2.82324f $ **FLOATING
C97 a_617_69780.n2 VSS 1.08005f $ **FLOATING
C98 a_665_69868.t1 VSS 0.04057f $ **FLOATING
C99 a_665_69868.t0 VSS 0.14071f $ **FLOATING
C100 a_665_69868.t3 VSS 0.11155f $ **FLOATING
C101 a_665_69868.n0 VSS 2.18072f $ **FLOATING
C102 a_665_69868.t4 VSS 0.08305f $ **FLOATING
C103 a_665_69868.n1 VSS 3.06877f $ **FLOATING
C104 a_665_69868.t2 VSS 0.08481f $ **FLOATING
C105 a_665_69868.n2 VSS 1.49773f $ **FLOATING
C106 a_617_67128.t0 VSS 0.03251f $ **FLOATING
C107 a_617_67128.t1 VSS 0.11421f $ **FLOATING
C108 a_617_67128.t4 VSS 0.06163f $ **FLOATING
C109 a_617_67128.n0 VSS 1.07118f $ **FLOATING
C110 a_617_67128.t3 VSS 0.08297f $ **FLOATING
C111 a_617_67128.t2 VSS 0.06956f $ **FLOATING
C112 a_617_67128.n1 VSS 2.82324f $ **FLOATING
C113 a_617_67128.n2 VSS 1.08005f $ **FLOATING
C114 a_665_67216.t0 VSS 0.04057f $ **FLOATING
C115 a_665_67216.t1 VSS 0.14071f $ **FLOATING
C116 a_665_67216.t3 VSS 0.11155f $ **FLOATING
C117 a_665_67216.n0 VSS 2.18072f $ **FLOATING
C118 a_665_67216.t4 VSS 0.08305f $ **FLOATING
C119 a_665_67216.n1 VSS 3.06877f $ **FLOATING
C120 a_665_67216.t2 VSS 0.08481f $ **FLOATING
C121 a_665_67216.n2 VSS 1.49773f $ **FLOATING
C122 a_617_64476.t0 VSS 0.03251f $ **FLOATING
C123 a_617_64476.t1 VSS 0.11421f $ **FLOATING
C124 a_617_64476.t4 VSS 0.06163f $ **FLOATING
C125 a_617_64476.n0 VSS 1.07118f $ **FLOATING
C126 a_617_64476.t3 VSS 0.08297f $ **FLOATING
C127 a_617_64476.t2 VSS 0.06956f $ **FLOATING
C128 a_617_64476.n1 VSS 2.82324f $ **FLOATING
C129 a_617_64476.n2 VSS 1.08005f $ **FLOATING
C130 a_665_64564.t1 VSS 0.04057f $ **FLOATING
C131 a_665_64564.t0 VSS 0.14071f $ **FLOATING
C132 a_665_64564.t3 VSS 0.11155f $ **FLOATING
C133 a_665_64564.n0 VSS 2.18072f $ **FLOATING
C134 a_665_64564.t4 VSS 0.08305f $ **FLOATING
C135 a_665_64564.n1 VSS 3.06877f $ **FLOATING
C136 a_665_64564.t2 VSS 0.08481f $ **FLOATING
C137 a_665_64564.n2 VSS 1.49773f $ **FLOATING
C138 a_617_61824.t0 VSS 0.03251f $ **FLOATING
C139 a_617_61824.t1 VSS 0.11421f $ **FLOATING
C140 a_617_61824.t4 VSS 0.06163f $ **FLOATING
C141 a_617_61824.n0 VSS 1.07118f $ **FLOATING
C142 a_617_61824.t3 VSS 0.08297f $ **FLOATING
C143 a_617_61824.t2 VSS 0.06956f $ **FLOATING
C144 a_617_61824.n1 VSS 2.82324f $ **FLOATING
C145 a_617_61824.n2 VSS 1.08005f $ **FLOATING
C146 a_665_61912.t1 VSS 0.04057f $ **FLOATING
C147 a_665_61912.t0 VSS 0.14071f $ **FLOATING
C148 a_665_61912.t3 VSS 0.11155f $ **FLOATING
C149 a_665_61912.n0 VSS 2.18072f $ **FLOATING
C150 a_665_61912.t4 VSS 0.08305f $ **FLOATING
C151 a_665_61912.n1 VSS 3.06877f $ **FLOATING
C152 a_665_61912.t2 VSS 0.08481f $ **FLOATING
C153 a_665_61912.n2 VSS 1.49773f $ **FLOATING
C154 a_617_59172.t0 VSS 0.03251f $ **FLOATING
C155 a_617_59172.t1 VSS 0.11421f $ **FLOATING
C156 a_617_59172.t4 VSS 0.06163f $ **FLOATING
C157 a_617_59172.n0 VSS 1.07118f $ **FLOATING
C158 a_617_59172.t3 VSS 0.08297f $ **FLOATING
C159 a_617_59172.t2 VSS 0.06956f $ **FLOATING
C160 a_617_59172.n1 VSS 2.82324f $ **FLOATING
C161 a_617_59172.n2 VSS 1.08005f $ **FLOATING
C162 a_665_59260.t0 VSS 0.04057f $ **FLOATING
C163 a_665_59260.t1 VSS 0.14071f $ **FLOATING
C164 a_665_59260.t3 VSS 0.11155f $ **FLOATING
C165 a_665_59260.n0 VSS 2.18072f $ **FLOATING
C166 a_665_59260.t4 VSS 0.08305f $ **FLOATING
C167 a_665_59260.n1 VSS 3.06877f $ **FLOATING
C168 a_665_59260.t2 VSS 0.08481f $ **FLOATING
C169 a_665_59260.n2 VSS 1.49773f $ **FLOATING
C170 a_617_56520.t0 VSS 0.03251f $ **FLOATING
C171 a_617_56520.t1 VSS 0.11421f $ **FLOATING
C172 a_617_56520.t4 VSS 0.06163f $ **FLOATING
C173 a_617_56520.n0 VSS 1.07118f $ **FLOATING
C174 a_617_56520.t3 VSS 0.08297f $ **FLOATING
C175 a_617_56520.t2 VSS 0.06956f $ **FLOATING
C176 a_617_56520.n1 VSS 2.82324f $ **FLOATING
C177 a_617_56520.n2 VSS 1.08005f $ **FLOATING
C178 a_665_56608.t1 VSS 0.04057f $ **FLOATING
C179 a_665_56608.t0 VSS 0.14071f $ **FLOATING
C180 a_665_56608.t3 VSS 0.11155f $ **FLOATING
C181 a_665_56608.n0 VSS 2.18072f $ **FLOATING
C182 a_665_56608.t4 VSS 0.08305f $ **FLOATING
C183 a_665_56608.n1 VSS 3.06877f $ **FLOATING
C184 a_665_56608.t2 VSS 0.08481f $ **FLOATING
C185 a_665_56608.n2 VSS 1.49773f $ **FLOATING
C186 a_617_53868.t0 VSS 0.03251f $ **FLOATING
C187 a_617_53868.t1 VSS 0.11421f $ **FLOATING
C188 a_617_53868.t4 VSS 0.06163f $ **FLOATING
C189 a_617_53868.n0 VSS 1.07118f $ **FLOATING
C190 a_617_53868.t3 VSS 0.08297f $ **FLOATING
C191 a_617_53868.t2 VSS 0.06956f $ **FLOATING
C192 a_617_53868.n1 VSS 2.82324f $ **FLOATING
C193 a_617_53868.n2 VSS 1.08005f $ **FLOATING
C194 a_665_53956.t1 VSS 0.04057f $ **FLOATING
C195 a_665_53956.t0 VSS 0.14071f $ **FLOATING
C196 a_665_53956.t3 VSS 0.11155f $ **FLOATING
C197 a_665_53956.n0 VSS 2.18072f $ **FLOATING
C198 a_665_53956.t4 VSS 0.08305f $ **FLOATING
C199 a_665_53956.n1 VSS 3.06877f $ **FLOATING
C200 a_665_53956.t2 VSS 0.08481f $ **FLOATING
C201 a_665_53956.n2 VSS 1.49773f $ **FLOATING
C202 a_617_51216.t0 VSS 0.03251f $ **FLOATING
C203 a_617_51216.t1 VSS 0.11421f $ **FLOATING
C204 a_617_51216.t4 VSS 0.06163f $ **FLOATING
C205 a_617_51216.n0 VSS 1.07118f $ **FLOATING
C206 a_617_51216.t3 VSS 0.08297f $ **FLOATING
C207 a_617_51216.t2 VSS 0.06956f $ **FLOATING
C208 a_617_51216.n1 VSS 2.82324f $ **FLOATING
C209 a_617_51216.n2 VSS 1.08005f $ **FLOATING
C210 a_665_51304.t1 VSS 0.04057f $ **FLOATING
C211 a_665_51304.t0 VSS 0.14071f $ **FLOATING
C212 a_665_51304.t3 VSS 0.11155f $ **FLOATING
C213 a_665_51304.n0 VSS 2.18072f $ **FLOATING
C214 a_665_51304.t4 VSS 0.08305f $ **FLOATING
C215 a_665_51304.n1 VSS 3.06877f $ **FLOATING
C216 a_665_51304.t2 VSS 0.08481f $ **FLOATING
C217 a_665_51304.n2 VSS 1.49773f $ **FLOATING
C218 a_617_48564.t0 VSS 0.03251f $ **FLOATING
C219 a_617_48564.t1 VSS 0.11421f $ **FLOATING
C220 a_617_48564.t4 VSS 0.06163f $ **FLOATING
C221 a_617_48564.n0 VSS 1.07118f $ **FLOATING
C222 a_617_48564.t3 VSS 0.08297f $ **FLOATING
C223 a_617_48564.t2 VSS 0.06956f $ **FLOATING
C224 a_617_48564.n1 VSS 2.82323f $ **FLOATING
C225 a_617_48564.n2 VSS 1.08005f $ **FLOATING
C226 a_665_48652.t1 VSS 0.04057f $ **FLOATING
C227 a_665_48652.t0 VSS 0.14071f $ **FLOATING
C228 a_665_48652.t3 VSS 0.11155f $ **FLOATING
C229 a_665_48652.n0 VSS 2.18072f $ **FLOATING
C230 a_665_48652.t4 VSS 0.08305f $ **FLOATING
C231 a_665_48652.n1 VSS 3.06877f $ **FLOATING
C232 a_665_48652.t2 VSS 0.08481f $ **FLOATING
C233 a_665_48652.n2 VSS 1.49773f $ **FLOATING
C234 a_617_45912.t0 VSS 0.03251f $ **FLOATING
C235 a_617_45912.t1 VSS 0.11421f $ **FLOATING
C236 a_617_45912.t4 VSS 0.06163f $ **FLOATING
C237 a_617_45912.n0 VSS 1.07118f $ **FLOATING
C238 a_617_45912.t3 VSS 0.08297f $ **FLOATING
C239 a_617_45912.t2 VSS 0.06956f $ **FLOATING
C240 a_617_45912.n1 VSS 2.82324f $ **FLOATING
C241 a_617_45912.n2 VSS 1.08005f $ **FLOATING
C242 a_665_46000.t0 VSS 0.04057f $ **FLOATING
C243 a_665_46000.t1 VSS 0.14071f $ **FLOATING
C244 a_665_46000.t3 VSS 0.11155f $ **FLOATING
C245 a_665_46000.n0 VSS 2.18072f $ **FLOATING
C246 a_665_46000.t4 VSS 0.08305f $ **FLOATING
C247 a_665_46000.n1 VSS 3.06877f $ **FLOATING
C248 a_665_46000.t2 VSS 0.08481f $ **FLOATING
C249 a_665_46000.n2 VSS 1.49773f $ **FLOATING
C250 a_617_43260.t0 VSS 0.03251f $ **FLOATING
C251 a_617_43260.t1 VSS 0.11421f $ **FLOATING
C252 a_617_43260.t4 VSS 0.06163f $ **FLOATING
C253 a_617_43260.n0 VSS 1.07118f $ **FLOATING
C254 a_617_43260.t3 VSS 0.08297f $ **FLOATING
C255 a_617_43260.t2 VSS 0.06956f $ **FLOATING
C256 a_617_43260.n1 VSS 2.82324f $ **FLOATING
C257 a_617_43260.n2 VSS 1.08005f $ **FLOATING
C258 a_665_43348.t0 VSS 0.04057f $ **FLOATING
C259 a_665_43348.t1 VSS 0.14071f $ **FLOATING
C260 a_665_43348.t3 VSS 0.11155f $ **FLOATING
C261 a_665_43348.n0 VSS 2.18072f $ **FLOATING
C262 a_665_43348.t4 VSS 0.08305f $ **FLOATING
C263 a_665_43348.n1 VSS 3.06877f $ **FLOATING
C264 a_665_43348.t2 VSS 0.08481f $ **FLOATING
C265 a_665_43348.n2 VSS 1.49773f $ **FLOATING
C266 a_617_40608.t0 VSS 0.03251f $ **FLOATING
C267 a_617_40608.t1 VSS 0.11421f $ **FLOATING
C268 a_617_40608.t4 VSS 0.06163f $ **FLOATING
C269 a_617_40608.n0 VSS 1.07118f $ **FLOATING
C270 a_617_40608.t3 VSS 0.08297f $ **FLOATING
C271 a_617_40608.t2 VSS 0.06956f $ **FLOATING
C272 a_617_40608.n1 VSS 2.82324f $ **FLOATING
C273 a_617_40608.n2 VSS 1.08005f $ **FLOATING
C274 a_665_40696.t0 VSS 0.04057f $ **FLOATING
C275 a_665_40696.t1 VSS 0.14071f $ **FLOATING
C276 a_665_40696.t3 VSS 0.11155f $ **FLOATING
C277 a_665_40696.n0 VSS 2.18072f $ **FLOATING
C278 a_665_40696.t4 VSS 0.08305f $ **FLOATING
C279 a_665_40696.n1 VSS 3.06877f $ **FLOATING
C280 a_665_40696.t2 VSS 0.08481f $ **FLOATING
C281 a_665_40696.n2 VSS 1.49773f $ **FLOATING
C282 a_617_37956.t0 VSS 0.03251f $ **FLOATING
C283 a_617_37956.t1 VSS 0.11421f $ **FLOATING
C284 a_617_37956.t4 VSS 0.06163f $ **FLOATING
C285 a_617_37956.n0 VSS 1.07118f $ **FLOATING
C286 a_617_37956.t3 VSS 0.08297f $ **FLOATING
C287 a_617_37956.t2 VSS 0.06956f $ **FLOATING
C288 a_617_37956.n1 VSS 2.82324f $ **FLOATING
C289 a_617_37956.n2 VSS 1.08005f $ **FLOATING
C290 a_665_38044.t0 VSS 0.04057f $ **FLOATING
C291 a_665_38044.t1 VSS 0.14071f $ **FLOATING
C292 a_665_38044.t3 VSS 0.11155f $ **FLOATING
C293 a_665_38044.n0 VSS 2.18072f $ **FLOATING
C294 a_665_38044.t4 VSS 0.08305f $ **FLOATING
C295 a_665_38044.n1 VSS 3.06877f $ **FLOATING
C296 a_665_38044.t2 VSS 0.08481f $ **FLOATING
C297 a_665_38044.n2 VSS 1.49773f $ **FLOATING
C298 a_617_35304.t0 VSS 0.03251f $ **FLOATING
C299 a_617_35304.t1 VSS 0.11421f $ **FLOATING
C300 a_617_35304.t4 VSS 0.06163f $ **FLOATING
C301 a_617_35304.n0 VSS 1.07118f $ **FLOATING
C302 a_617_35304.t3 VSS 0.08297f $ **FLOATING
C303 a_617_35304.t2 VSS 0.06956f $ **FLOATING
C304 a_617_35304.n1 VSS 2.82324f $ **FLOATING
C305 a_617_35304.n2 VSS 1.08005f $ **FLOATING
C306 a_665_35392.t0 VSS 0.04057f $ **FLOATING
C307 a_665_35392.t1 VSS 0.14071f $ **FLOATING
C308 a_665_35392.t3 VSS 0.11155f $ **FLOATING
C309 a_665_35392.n0 VSS 2.18072f $ **FLOATING
C310 a_665_35392.t4 VSS 0.08305f $ **FLOATING
C311 a_665_35392.n1 VSS 3.06877f $ **FLOATING
C312 a_665_35392.t2 VSS 0.08481f $ **FLOATING
C313 a_665_35392.n2 VSS 1.49773f $ **FLOATING
C314 a_617_32652.t0 VSS 0.03251f $ **FLOATING
C315 a_617_32652.t1 VSS 0.11421f $ **FLOATING
C316 a_617_32652.t4 VSS 0.06163f $ **FLOATING
C317 a_617_32652.n0 VSS 1.07118f $ **FLOATING
C318 a_617_32652.t3 VSS 0.08297f $ **FLOATING
C319 a_617_32652.t2 VSS 0.06956f $ **FLOATING
C320 a_617_32652.n1 VSS 2.82324f $ **FLOATING
C321 a_617_32652.n2 VSS 1.08005f $ **FLOATING
C322 a_665_32740.t1 VSS 0.04057f $ **FLOATING
C323 a_665_32740.t0 VSS 0.14071f $ **FLOATING
C324 a_665_32740.t3 VSS 0.11155f $ **FLOATING
C325 a_665_32740.n0 VSS 2.18072f $ **FLOATING
C326 a_665_32740.t4 VSS 0.08305f $ **FLOATING
C327 a_665_32740.n1 VSS 3.06877f $ **FLOATING
C328 a_665_32740.t2 VSS 0.08481f $ **FLOATING
C329 a_665_32740.n2 VSS 1.49773f $ **FLOATING
C330 a_617_30000.t0 VSS 0.03251f $ **FLOATING
C331 a_617_30000.t1 VSS 0.11421f $ **FLOATING
C332 a_617_30000.t4 VSS 0.06163f $ **FLOATING
C333 a_617_30000.n0 VSS 1.07118f $ **FLOATING
C334 a_617_30000.t3 VSS 0.08297f $ **FLOATING
C335 a_617_30000.t2 VSS 0.06956f $ **FLOATING
C336 a_617_30000.n1 VSS 2.82324f $ **FLOATING
C337 a_617_30000.n2 VSS 1.08005f $ **FLOATING
C338 a_665_30088.t1 VSS 0.04057f $ **FLOATING
C339 a_665_30088.t0 VSS 0.14071f $ **FLOATING
C340 a_665_30088.t3 VSS 0.11155f $ **FLOATING
C341 a_665_30088.n0 VSS 2.18072f $ **FLOATING
C342 a_665_30088.t4 VSS 0.08305f $ **FLOATING
C343 a_665_30088.n1 VSS 3.06877f $ **FLOATING
C344 a_665_30088.t2 VSS 0.08481f $ **FLOATING
C345 a_665_30088.n2 VSS 1.49773f $ **FLOATING
C346 a_617_27348.t0 VSS 0.03251f $ **FLOATING
C347 a_617_27348.t1 VSS 0.11421f $ **FLOATING
C348 a_617_27348.t4 VSS 0.06163f $ **FLOATING
C349 a_617_27348.n0 VSS 1.07118f $ **FLOATING
C350 a_617_27348.t3 VSS 0.08297f $ **FLOATING
C351 a_617_27348.t2 VSS 0.06956f $ **FLOATING
C352 a_617_27348.n1 VSS 2.82324f $ **FLOATING
C353 a_617_27348.n2 VSS 1.08005f $ **FLOATING
C354 a_665_27436.t0 VSS 0.04057f $ **FLOATING
C355 a_665_27436.t1 VSS 0.14071f $ **FLOATING
C356 a_665_27436.t3 VSS 0.11155f $ **FLOATING
C357 a_665_27436.n0 VSS 2.18072f $ **FLOATING
C358 a_665_27436.t4 VSS 0.08305f $ **FLOATING
C359 a_665_27436.n1 VSS 3.06877f $ **FLOATING
C360 a_665_27436.t2 VSS 0.08481f $ **FLOATING
C361 a_665_27436.n2 VSS 1.49773f $ **FLOATING
C362 a_617_24696.t0 VSS 0.03251f $ **FLOATING
C363 a_617_24696.t1 VSS 0.11421f $ **FLOATING
C364 a_617_24696.t4 VSS 0.06163f $ **FLOATING
C365 a_617_24696.n0 VSS 1.07118f $ **FLOATING
C366 a_617_24696.t3 VSS 0.08297f $ **FLOATING
C367 a_617_24696.t2 VSS 0.06956f $ **FLOATING
C368 a_617_24696.n1 VSS 2.82324f $ **FLOATING
C369 a_617_24696.n2 VSS 1.08005f $ **FLOATING
C370 a_665_24784.t0 VSS 0.04057f $ **FLOATING
C371 a_665_24784.t1 VSS 0.14071f $ **FLOATING
C372 a_665_24784.t3 VSS 0.11155f $ **FLOATING
C373 a_665_24784.n0 VSS 2.18072f $ **FLOATING
C374 a_665_24784.t4 VSS 0.08305f $ **FLOATING
C375 a_665_24784.n1 VSS 3.06877f $ **FLOATING
C376 a_665_24784.t2 VSS 0.08481f $ **FLOATING
C377 a_665_24784.n2 VSS 1.49773f $ **FLOATING
C378 a_617_22044.t0 VSS 0.03251f $ **FLOATING
C379 a_617_22044.t1 VSS 0.11421f $ **FLOATING
C380 a_617_22044.t4 VSS 0.06163f $ **FLOATING
C381 a_617_22044.n0 VSS 1.07118f $ **FLOATING
C382 a_617_22044.t3 VSS 0.08297f $ **FLOATING
C383 a_617_22044.t2 VSS 0.06956f $ **FLOATING
C384 a_617_22044.n1 VSS 2.82324f $ **FLOATING
C385 a_617_22044.n2 VSS 1.08005f $ **FLOATING
C386 a_665_22132.t1 VSS 0.04057f $ **FLOATING
C387 a_665_22132.t0 VSS 0.14071f $ **FLOATING
C388 a_665_22132.t3 VSS 0.11155f $ **FLOATING
C389 a_665_22132.n0 VSS 2.18072f $ **FLOATING
C390 a_665_22132.t4 VSS 0.08305f $ **FLOATING
C391 a_665_22132.n1 VSS 3.06877f $ **FLOATING
C392 a_665_22132.t2 VSS 0.08481f $ **FLOATING
C393 a_665_22132.n2 VSS 1.49773f $ **FLOATING
C394 a_617_19392.t0 VSS 0.03251f $ **FLOATING
C395 a_617_19392.t1 VSS 0.11421f $ **FLOATING
C396 a_617_19392.t4 VSS 0.06163f $ **FLOATING
C397 a_617_19392.n0 VSS 1.07118f $ **FLOATING
C398 a_617_19392.t3 VSS 0.08297f $ **FLOATING
C399 a_617_19392.t2 VSS 0.06956f $ **FLOATING
C400 a_617_19392.n1 VSS 2.82324f $ **FLOATING
C401 a_617_19392.n2 VSS 1.08005f $ **FLOATING
C402 a_665_19480.t0 VSS 0.04057f $ **FLOATING
C403 a_665_19480.t1 VSS 0.14071f $ **FLOATING
C404 a_665_19480.t3 VSS 0.11155f $ **FLOATING
C405 a_665_19480.n0 VSS 2.18072f $ **FLOATING
C406 a_665_19480.t4 VSS 0.08305f $ **FLOATING
C407 a_665_19480.n1 VSS 3.06877f $ **FLOATING
C408 a_665_19480.t2 VSS 0.08481f $ **FLOATING
C409 a_665_19480.n2 VSS 1.49773f $ **FLOATING
C410 a_617_16740.t0 VSS 0.03251f $ **FLOATING
C411 a_617_16740.t1 VSS 0.11421f $ **FLOATING
C412 a_617_16740.t4 VSS 0.06163f $ **FLOATING
C413 a_617_16740.n0 VSS 1.07118f $ **FLOATING
C414 a_617_16740.t3 VSS 0.08297f $ **FLOATING
C415 a_617_16740.t2 VSS 0.06956f $ **FLOATING
C416 a_617_16740.n1 VSS 2.82324f $ **FLOATING
C417 a_617_16740.n2 VSS 1.08005f $ **FLOATING
C418 a_665_16828.t1 VSS 0.04057f $ **FLOATING
C419 a_665_16828.t0 VSS 0.14071f $ **FLOATING
C420 a_665_16828.t3 VSS 0.11155f $ **FLOATING
C421 a_665_16828.n0 VSS 2.18072f $ **FLOATING
C422 a_665_16828.t4 VSS 0.08305f $ **FLOATING
C423 a_665_16828.n1 VSS 3.06877f $ **FLOATING
C424 a_665_16828.t2 VSS 0.08481f $ **FLOATING
C425 a_665_16828.n2 VSS 1.49773f $ **FLOATING
C426 a_617_14088.t0 VSS 0.03251f $ **FLOATING
C427 a_617_14088.t1 VSS 0.11421f $ **FLOATING
C428 a_617_14088.t4 VSS 0.06163f $ **FLOATING
C429 a_617_14088.n0 VSS 1.07118f $ **FLOATING
C430 a_617_14088.t3 VSS 0.08297f $ **FLOATING
C431 a_617_14088.t2 VSS 0.06956f $ **FLOATING
C432 a_617_14088.n1 VSS 2.82324f $ **FLOATING
C433 a_617_14088.n2 VSS 1.08005f $ **FLOATING
C434 a_665_14176.t0 VSS 0.04057f $ **FLOATING
C435 a_665_14176.t1 VSS 0.14071f $ **FLOATING
C436 a_665_14176.t3 VSS 0.11155f $ **FLOATING
C437 a_665_14176.n0 VSS 2.18072f $ **FLOATING
C438 a_665_14176.t4 VSS 0.08305f $ **FLOATING
C439 a_665_14176.n1 VSS 3.06877f $ **FLOATING
C440 a_665_14176.t2 VSS 0.08481f $ **FLOATING
C441 a_665_14176.n2 VSS 1.49773f $ **FLOATING
C442 a_617_11436.t0 VSS 0.03251f $ **FLOATING
C443 a_617_11436.t1 VSS 0.11421f $ **FLOATING
C444 a_617_11436.t4 VSS 0.06163f $ **FLOATING
C445 a_617_11436.n0 VSS 1.07118f $ **FLOATING
C446 a_617_11436.t3 VSS 0.08297f $ **FLOATING
C447 a_617_11436.t2 VSS 0.06956f $ **FLOATING
C448 a_617_11436.n1 VSS 2.82324f $ **FLOATING
C449 a_617_11436.n2 VSS 1.08005f $ **FLOATING
C450 a_665_11524.t1 VSS 0.04057f $ **FLOATING
C451 a_665_11524.t0 VSS 0.14071f $ **FLOATING
C452 a_665_11524.t3 VSS 0.11155f $ **FLOATING
C453 a_665_11524.n0 VSS 2.18072f $ **FLOATING
C454 a_665_11524.t4 VSS 0.08305f $ **FLOATING
C455 a_665_11524.n1 VSS 3.06877f $ **FLOATING
C456 a_665_11524.t2 VSS 0.08481f $ **FLOATING
C457 a_665_11524.n2 VSS 1.49773f $ **FLOATING
C458 a_617_8784.t0 VSS 0.03251f $ **FLOATING
C459 a_617_8784.t1 VSS 0.11421f $ **FLOATING
C460 a_617_8784.t4 VSS 0.06163f $ **FLOATING
C461 a_617_8784.n0 VSS 1.07118f $ **FLOATING
C462 a_617_8784.t3 VSS 0.08297f $ **FLOATING
C463 a_617_8784.t2 VSS 0.06956f $ **FLOATING
C464 a_617_8784.n1 VSS 2.82324f $ **FLOATING
C465 a_617_8784.n2 VSS 1.08005f $ **FLOATING
C466 a_665_8872.t1 VSS 0.04057f $ **FLOATING
C467 a_665_8872.t0 VSS 0.14071f $ **FLOATING
C468 a_665_8872.t3 VSS 0.11155f $ **FLOATING
C469 a_665_8872.n0 VSS 2.18072f $ **FLOATING
C470 a_665_8872.t4 VSS 0.08305f $ **FLOATING
C471 a_665_8872.n1 VSS 3.06877f $ **FLOATING
C472 a_665_8872.t2 VSS 0.08481f $ **FLOATING
C473 a_665_8872.n2 VSS 1.49773f $ **FLOATING
C474 a_617_6132.t0 VSS 0.03251f $ **FLOATING
C475 a_617_6132.t1 VSS 0.11421f $ **FLOATING
C476 a_617_6132.t4 VSS 0.06163f $ **FLOATING
C477 a_617_6132.n0 VSS 1.07118f $ **FLOATING
C478 a_617_6132.t3 VSS 0.08297f $ **FLOATING
C479 a_617_6132.t2 VSS 0.06956f $ **FLOATING
C480 a_617_6132.n1 VSS 2.82323f $ **FLOATING
C481 a_617_6132.n2 VSS 1.08005f $ **FLOATING
C482 a_665_6220.t1 VSS 0.04057f $ **FLOATING
C483 a_665_6220.t0 VSS 0.14071f $ **FLOATING
C484 a_665_6220.t3 VSS 0.11155f $ **FLOATING
C485 a_665_6220.n0 VSS 2.18072f $ **FLOATING
C486 a_665_6220.t4 VSS 0.08305f $ **FLOATING
C487 a_665_6220.n1 VSS 3.06877f $ **FLOATING
C488 a_665_6220.t2 VSS 0.08481f $ **FLOATING
C489 a_665_6220.n2 VSS 1.49773f $ **FLOATING
C490 a_617_3480.t0 VSS 0.03251f $ **FLOATING
C491 a_617_3480.t1 VSS 0.11421f $ **FLOATING
C492 a_617_3480.t4 VSS 0.06163f $ **FLOATING
C493 a_617_3480.n0 VSS 1.07118f $ **FLOATING
C494 a_617_3480.t3 VSS 0.08297f $ **FLOATING
C495 a_617_3480.t2 VSS 0.06956f $ **FLOATING
C496 a_617_3480.n1 VSS 2.82323f $ **FLOATING
C497 a_617_3480.n2 VSS 1.08005f $ **FLOATING
C498 a_665_3568.t0 VSS 0.04057f $ **FLOATING
C499 a_665_3568.t1 VSS 0.14071f $ **FLOATING
C500 a_665_3568.t3 VSS 0.11155f $ **FLOATING
C501 a_665_3568.n0 VSS 2.18072f $ **FLOATING
C502 a_665_3568.t4 VSS 0.08305f $ **FLOATING
C503 a_665_3568.n1 VSS 3.06877f $ **FLOATING
C504 a_665_3568.t2 VSS 0.08481f $ **FLOATING
C505 a_665_3568.n2 VSS 1.49773f $ **FLOATING
C506 a_617_828.t0 VSS 0.03237f $ **FLOATING
C507 a_617_828.t1 VSS 0.11369f $ **FLOATING
C508 a_617_828.t4 VSS 0.06135f $ **FLOATING
C509 a_617_828.n0 VSS 1.0663f $ **FLOATING
C510 a_617_828.t3 VSS 0.0826f $ **FLOATING
C511 a_617_828.t2 VSS 0.06925f $ **FLOATING
C512 a_617_828.n1 VSS 2.81039f $ **FLOATING
C513 a_617_828.n2 VSS 1.07513f $ **FLOATING
C514 a_665_916.t1 VSS 0.04046f $ **FLOATING
C515 a_665_916.t0 VSS 0.14035f $ **FLOATING
C516 a_665_916.t3 VSS 0.11126f $ **FLOATING
C517 a_665_916.n0 VSS 2.17502f $ **FLOATING
C518 a_665_916.t4 VSS 0.08284f $ **FLOATING
C519 a_665_916.n1 VSS 3.06075f $ **FLOATING
C520 a_665_916.t2 VSS 0.08459f $ **FLOATING
C521 a_665_916.n2 VSS 1.49382f $ **FLOATING
C522 VDD.t58 VSS 1.37636f $ **FLOATING
C523 VDD.t78 VSS 1.37636f $ **FLOATING
C524 VDD.t81 VSS 0.03038f $ **FLOATING
C525 VDD.n0 VSS 0.54009f $ **FLOATING
C526 VDD.t80 VSS 1.37408f $ **FLOATING
C527 VDD.n1 VSS 0.59063f $ **FLOATING
C528 VDD.t79 VSS 0.03057f $ **FLOATING
C529 VDD.n2 VSS 0.5795f $ **FLOATING
C530 VDD.n3 VSS 1.64182f $ **FLOATING
C531 VDD.n4 VSS 0.67151f $ **FLOATING
C532 VDD.t102 VSS 1.37636f $ **FLOATING
C533 VDD.t15 VSS 0.03038f $ **FLOATING
C534 VDD.n5 VSS 0.54009f $ **FLOATING
C535 VDD.t14 VSS 1.37408f $ **FLOATING
C536 VDD.n6 VSS 0.59063f $ **FLOATING
C537 VDD.t103 VSS 0.03057f $ **FLOATING
C538 VDD.n7 VSS 0.5795f $ **FLOATING
C539 VDD.n8 VSS 1.64182f $ **FLOATING
C540 VDD.n9 VSS 1.27573f $ **FLOATING
C541 VDD.t66 VSS 1.37636f $ **FLOATING
C542 VDD.t69 VSS 0.03038f $ **FLOATING
C543 VDD.n10 VSS 0.54009f $ **FLOATING
C544 VDD.t68 VSS 1.37408f $ **FLOATING
C545 VDD.n11 VSS 0.59063f $ **FLOATING
C546 VDD.t67 VSS 0.03057f $ **FLOATING
C547 VDD.n12 VSS 0.5795f $ **FLOATING
C548 VDD.n13 VSS 1.64182f $ **FLOATING
C549 VDD.n14 VSS 1.27573f $ **FLOATING
C550 VDD.t106 VSS 1.37636f $ **FLOATING
C551 VDD.t13 VSS 0.03038f $ **FLOATING
C552 VDD.n15 VSS 0.54009f $ **FLOATING
C553 VDD.t12 VSS 1.37408f $ **FLOATING
C554 VDD.n16 VSS 0.59063f $ **FLOATING
C555 VDD.t107 VSS 0.03057f $ **FLOATING
C556 VDD.n17 VSS 0.5795f $ **FLOATING
C557 VDD.n18 VSS 1.64182f $ **FLOATING
C558 VDD.n19 VSS 1.27573f $ **FLOATING
C559 VDD.t104 VSS 1.37636f $ **FLOATING
C560 VDD.t7 VSS 0.03038f $ **FLOATING
C561 VDD.n20 VSS 0.54009f $ **FLOATING
C562 VDD.t6 VSS 1.37408f $ **FLOATING
C563 VDD.n21 VSS 0.59063f $ **FLOATING
C564 VDD.t105 VSS 0.03057f $ **FLOATING
C565 VDD.n22 VSS 0.5795f $ **FLOATING
C566 VDD.n23 VSS 1.64182f $ **FLOATING
C567 VDD.n24 VSS 1.27573f $ **FLOATING
C568 VDD.t24 VSS 1.37636f $ **FLOATING
C569 VDD.t31 VSS 0.03038f $ **FLOATING
C570 VDD.n25 VSS 0.54009f $ **FLOATING
C571 VDD.t30 VSS 1.37408f $ **FLOATING
C572 VDD.n26 VSS 0.59063f $ **FLOATING
C573 VDD.t25 VSS 0.03057f $ **FLOATING
C574 VDD.n27 VSS 0.5795f $ **FLOATING
C575 VDD.n28 VSS 1.64182f $ **FLOATING
C576 VDD.n29 VSS 1.27573f $ **FLOATING
C577 VDD.t42 VSS 1.37636f $ **FLOATING
C578 VDD.t23 VSS 0.03038f $ **FLOATING
C579 VDD.n30 VSS 0.54009f $ **FLOATING
C580 VDD.t22 VSS 1.37408f $ **FLOATING
C581 VDD.n31 VSS 0.59063f $ **FLOATING
C582 VDD.t43 VSS 0.03057f $ **FLOATING
C583 VDD.n32 VSS 0.5795f $ **FLOATING
C584 VDD.n33 VSS 1.64182f $ **FLOATING
C585 VDD.n34 VSS 1.27573f $ **FLOATING
C586 VDD.t8 VSS 1.37636f $ **FLOATING
C587 VDD.t27 VSS 0.03038f $ **FLOATING
C588 VDD.n35 VSS 0.54009f $ **FLOATING
C589 VDD.t26 VSS 1.37408f $ **FLOATING
C590 VDD.n36 VSS 0.59063f $ **FLOATING
C591 VDD.t9 VSS 0.03057f $ **FLOATING
C592 VDD.n37 VSS 0.5795f $ **FLOATING
C593 VDD.n38 VSS 1.64182f $ **FLOATING
C594 VDD.n39 VSS 1.27573f $ **FLOATING
C595 VDD.t56 VSS 1.37636f $ **FLOATING
C596 VDD.t85 VSS 0.03038f $ **FLOATING
C597 VDD.n40 VSS 0.54009f $ **FLOATING
C598 VDD.t84 VSS 1.37408f $ **FLOATING
C599 VDD.n41 VSS 0.59063f $ **FLOATING
C600 VDD.t57 VSS 0.03057f $ **FLOATING
C601 VDD.n42 VSS 0.5795f $ **FLOATING
C602 VDD.n43 VSS 1.64182f $ **FLOATING
C603 VDD.n44 VSS 1.27573f $ **FLOATING
C604 VDD.t82 VSS 1.37636f $ **FLOATING
C605 VDD.t41 VSS 0.03038f $ **FLOATING
C606 VDD.n45 VSS 0.54009f $ **FLOATING
C607 VDD.t40 VSS 1.37408f $ **FLOATING
C608 VDD.n46 VSS 0.59063f $ **FLOATING
C609 VDD.t83 VSS 0.03057f $ **FLOATING
C610 VDD.n47 VSS 0.5795f $ **FLOATING
C611 VDD.n48 VSS 1.64182f $ **FLOATING
C612 VDD.n49 VSS 1.27573f $ **FLOATING
C613 VDD.t48 VSS 1.37636f $ **FLOATING
C614 VDD.t51 VSS 0.03038f $ **FLOATING
C615 VDD.n50 VSS 0.54009f $ **FLOATING
C616 VDD.t50 VSS 1.37408f $ **FLOATING
C617 VDD.n51 VSS 0.59063f $ **FLOATING
C618 VDD.t49 VSS 0.03057f $ **FLOATING
C619 VDD.n52 VSS 0.5795f $ **FLOATING
C620 VDD.n53 VSS 1.64182f $ **FLOATING
C621 VDD.n54 VSS 1.27573f $ **FLOATING
C622 VDD.t90 VSS 1.37636f $ **FLOATING
C623 VDD.t99 VSS 0.03038f $ **FLOATING
C624 VDD.n55 VSS 0.54009f $ **FLOATING
C625 VDD.t98 VSS 1.37408f $ **FLOATING
C626 VDD.n56 VSS 0.59063f $ **FLOATING
C627 VDD.t91 VSS 0.03057f $ **FLOATING
C628 VDD.n57 VSS 0.5795f $ **FLOATING
C629 VDD.n58 VSS 1.64182f $ **FLOATING
C630 VDD.n59 VSS 1.27573f $ **FLOATING
C631 VDD.t112 VSS 1.37636f $ **FLOATING
C632 VDD.t127 VSS 0.03038f $ **FLOATING
C633 VDD.n60 VSS 0.54009f $ **FLOATING
C634 VDD.t126 VSS 1.37408f $ **FLOATING
C635 VDD.n61 VSS 0.59063f $ **FLOATING
C636 VDD.t113 VSS 0.03057f $ **FLOATING
C637 VDD.n62 VSS 0.5795f $ **FLOATING
C638 VDD.n63 VSS 1.64182f $ **FLOATING
C639 VDD.n64 VSS 1.27573f $ **FLOATING
C640 VDD.t108 VSS 1.37636f $ **FLOATING
C641 VDD.t111 VSS 0.03038f $ **FLOATING
C642 VDD.n65 VSS 0.54009f $ **FLOATING
C643 VDD.t110 VSS 1.37408f $ **FLOATING
C644 VDD.n66 VSS 0.59063f $ **FLOATING
C645 VDD.t109 VSS 0.03057f $ **FLOATING
C646 VDD.n67 VSS 0.5795f $ **FLOATING
C647 VDD.n68 VSS 1.64182f $ **FLOATING
C648 VDD.n69 VSS 1.27573f $ **FLOATING
C649 VDD.t92 VSS 1.37636f $ **FLOATING
C650 VDD.t87 VSS 0.03038f $ **FLOATING
C651 VDD.n70 VSS 0.54009f $ **FLOATING
C652 VDD.t86 VSS 1.37408f $ **FLOATING
C653 VDD.n71 VSS 0.59063f $ **FLOATING
C654 VDD.t93 VSS 0.03057f $ **FLOATING
C655 VDD.n72 VSS 0.5795f $ **FLOATING
C656 VDD.n73 VSS 1.64182f $ **FLOATING
C657 VDD.n74 VSS 1.27573f $ **FLOATING
C658 VDD.t88 VSS 1.37636f $ **FLOATING
C659 VDD.t101 VSS 0.03038f $ **FLOATING
C660 VDD.n75 VSS 0.54009f $ **FLOATING
C661 VDD.t100 VSS 1.37408f $ **FLOATING
C662 VDD.n76 VSS 0.59063f $ **FLOATING
C663 VDD.t89 VSS 0.03057f $ **FLOATING
C664 VDD.n77 VSS 0.5795f $ **FLOATING
C665 VDD.n78 VSS 1.64182f $ **FLOATING
C666 VDD.n79 VSS 1.27573f $ **FLOATING
C667 VDD.t94 VSS 1.37636f $ **FLOATING
C668 VDD.t97 VSS 0.03038f $ **FLOATING
C669 VDD.n80 VSS 0.54009f $ **FLOATING
C670 VDD.t96 VSS 1.37408f $ **FLOATING
C671 VDD.n81 VSS 0.59063f $ **FLOATING
C672 VDD.t95 VSS 0.03057f $ **FLOATING
C673 VDD.n82 VSS 0.5795f $ **FLOATING
C674 VDD.n83 VSS 1.64182f $ **FLOATING
C675 VDD.n84 VSS 1.27573f $ **FLOATING
C676 VDD.t18 VSS 1.37636f $ **FLOATING
C677 VDD.t21 VSS 0.03038f $ **FLOATING
C678 VDD.n85 VSS 0.54009f $ **FLOATING
C679 VDD.t20 VSS 1.37408f $ **FLOATING
C680 VDD.n86 VSS 0.59063f $ **FLOATING
C681 VDD.t19 VSS 0.03057f $ **FLOATING
C682 VDD.n87 VSS 0.5795f $ **FLOATING
C683 VDD.n88 VSS 1.64182f $ **FLOATING
C684 VDD.n89 VSS 1.27573f $ **FLOATING
C685 VDD.t28 VSS 1.37636f $ **FLOATING
C686 VDD.t55 VSS 0.03038f $ **FLOATING
C687 VDD.n90 VSS 0.54009f $ **FLOATING
C688 VDD.t54 VSS 1.37408f $ **FLOATING
C689 VDD.n91 VSS 0.59063f $ **FLOATING
C690 VDD.t29 VSS 0.03057f $ **FLOATING
C691 VDD.n92 VSS 0.5795f $ **FLOATING
C692 VDD.n93 VSS 1.64182f $ **FLOATING
C693 VDD.n94 VSS 1.27573f $ **FLOATING
C694 VDD.t76 VSS 1.37636f $ **FLOATING
C695 VDD.t17 VSS 0.03038f $ **FLOATING
C696 VDD.n95 VSS 0.54009f $ **FLOATING
C697 VDD.t16 VSS 1.37408f $ **FLOATING
C698 VDD.n96 VSS 0.59063f $ **FLOATING
C699 VDD.t77 VSS 0.03057f $ **FLOATING
C700 VDD.n97 VSS 0.5795f $ **FLOATING
C701 VDD.n98 VSS 1.64182f $ **FLOATING
C702 VDD.n99 VSS 1.27573f $ **FLOATING
C703 VDD.t10 VSS 1.37636f $ **FLOATING
C704 VDD.t75 VSS 0.03038f $ **FLOATING
C705 VDD.n100 VSS 0.54009f $ **FLOATING
C706 VDD.t74 VSS 1.37408f $ **FLOATING
C707 VDD.n101 VSS 0.59063f $ **FLOATING
C708 VDD.t11 VSS 0.03057f $ **FLOATING
C709 VDD.n102 VSS 0.5795f $ **FLOATING
C710 VDD.n103 VSS 1.64182f $ **FLOATING
C711 VDD.n104 VSS 1.27573f $ **FLOATING
C712 VDD.t52 VSS 1.37636f $ **FLOATING
C713 VDD.t47 VSS 0.03038f $ **FLOATING
C714 VDD.n105 VSS 0.54009f $ **FLOATING
C715 VDD.t46 VSS 1.37408f $ **FLOATING
C716 VDD.n106 VSS 0.59063f $ **FLOATING
C717 VDD.t53 VSS 0.03057f $ **FLOATING
C718 VDD.n107 VSS 0.5795f $ **FLOATING
C719 VDD.n108 VSS 1.64182f $ **FLOATING
C720 VDD.n109 VSS 1.27573f $ **FLOATING
C721 VDD.t60 VSS 1.37636f $ **FLOATING
C722 VDD.t73 VSS 0.03038f $ **FLOATING
C723 VDD.n110 VSS 0.54009f $ **FLOATING
C724 VDD.t72 VSS 1.37408f $ **FLOATING
C725 VDD.n111 VSS 0.59063f $ **FLOATING
C726 VDD.t61 VSS 0.03057f $ **FLOATING
C727 VDD.n112 VSS 0.5795f $ **FLOATING
C728 VDD.n113 VSS 1.64182f $ **FLOATING
C729 VDD.n114 VSS 1.27573f $ **FLOATING
C730 VDD.t4 VSS 1.37636f $ **FLOATING
C731 VDD.t123 VSS 0.03038f $ **FLOATING
C732 VDD.n115 VSS 0.54009f $ **FLOATING
C733 VDD.t122 VSS 1.37408f $ **FLOATING
C734 VDD.n116 VSS 0.59063f $ **FLOATING
C735 VDD.t5 VSS 0.03057f $ **FLOATING
C736 VDD.n117 VSS 0.5795f $ **FLOATING
C737 VDD.n118 VSS 1.64182f $ **FLOATING
C738 VDD.n119 VSS 1.27573f $ **FLOATING
C739 VDD.t38 VSS 1.37636f $ **FLOATING
C740 VDD.t45 VSS 0.03038f $ **FLOATING
C741 VDD.n120 VSS 0.54009f $ **FLOATING
C742 VDD.t44 VSS 1.37408f $ **FLOATING
C743 VDD.n121 VSS 0.59063f $ **FLOATING
C744 VDD.t39 VSS 0.03057f $ **FLOATING
C745 VDD.n122 VSS 0.5795f $ **FLOATING
C746 VDD.n123 VSS 1.64182f $ **FLOATING
C747 VDD.n124 VSS 1.27573f $ **FLOATING
C748 VDD.t36 VSS 1.37636f $ **FLOATING
C749 VDD.t65 VSS 0.03038f $ **FLOATING
C750 VDD.n125 VSS 0.54009f $ **FLOATING
C751 VDD.t64 VSS 1.37408f $ **FLOATING
C752 VDD.n126 VSS 0.59063f $ **FLOATING
C753 VDD.t37 VSS 0.03057f $ **FLOATING
C754 VDD.n127 VSS 0.5795f $ **FLOATING
C755 VDD.n128 VSS 1.64182f $ **FLOATING
C756 VDD.n129 VSS 1.27573f $ **FLOATING
C757 VDD.t116 VSS 1.37636f $ **FLOATING
C758 VDD.t71 VSS 0.03038f $ **FLOATING
C759 VDD.n130 VSS 0.54009f $ **FLOATING
C760 VDD.t70 VSS 1.37408f $ **FLOATING
C761 VDD.n131 VSS 0.59063f $ **FLOATING
C762 VDD.t117 VSS 0.03057f $ **FLOATING
C763 VDD.n132 VSS 0.5795f $ **FLOATING
C764 VDD.n133 VSS 1.64182f $ **FLOATING
C765 VDD.n134 VSS 1.27573f $ **FLOATING
C766 VDD.t0 VSS 1.37636f $ **FLOATING
C767 VDD.t125 VSS 0.03038f $ **FLOATING
C768 VDD.n135 VSS 0.54009f $ **FLOATING
C769 VDD.t124 VSS 1.37408f $ **FLOATING
C770 VDD.n136 VSS 0.59063f $ **FLOATING
C771 VDD.t1 VSS 0.03057f $ **FLOATING
C772 VDD.n137 VSS 0.5795f $ **FLOATING
C773 VDD.n138 VSS 1.64182f $ **FLOATING
C774 VDD.n139 VSS 1.27573f $ **FLOATING
C775 VDD.t2 VSS 1.37636f $ **FLOATING
C776 VDD.t121 VSS 0.03038f $ **FLOATING
C777 VDD.n140 VSS 0.54009f $ **FLOATING
C778 VDD.t120 VSS 1.37408f $ **FLOATING
C779 VDD.n141 VSS 0.59063f $ **FLOATING
C780 VDD.t3 VSS 0.03057f $ **FLOATING
C781 VDD.n142 VSS 0.5795f $ **FLOATING
C782 VDD.n143 VSS 1.64182f $ **FLOATING
C783 VDD.n144 VSS 1.27573f $ **FLOATING
C784 VDD.t62 VSS 1.37636f $ **FLOATING
C785 VDD.t115 VSS 0.03038f $ **FLOATING
C786 VDD.n145 VSS 0.54009f $ **FLOATING
C787 VDD.t114 VSS 1.37408f $ **FLOATING
C788 VDD.n146 VSS 0.59063f $ **FLOATING
C789 VDD.t63 VSS 0.03057f $ **FLOATING
C790 VDD.n147 VSS 0.5795f $ **FLOATING
C791 VDD.n148 VSS 1.64182f $ **FLOATING
C792 VDD.n149 VSS 1.27573f $ **FLOATING
C793 VDD.t32 VSS 1.37636f $ **FLOATING
C794 VDD.t35 VSS 0.03038f $ **FLOATING
C795 VDD.n150 VSS 0.54009f $ **FLOATING
C796 VDD.t34 VSS 1.37408f $ **FLOATING
C797 VDD.n151 VSS 0.59063f $ **FLOATING
C798 VDD.t33 VSS 0.03057f $ **FLOATING
C799 VDD.n152 VSS 0.5795f $ **FLOATING
C800 VDD.n153 VSS 1.64182f $ **FLOATING
C801 VDD.n154 VSS 0.88792f $ **FLOATING
C802 VDD.n155 VSS 1.46569f $ **FLOATING
C803 VDD.t59 VSS 0.03057f $ **FLOATING
C804 VDD.n156 VSS 0.5795f $ **FLOATING
C805 VDD.t118 VSS 1.37408f $ **FLOATING
C806 VDD.n157 VSS 0.59063f $ **FLOATING
C807 VDD.t119 VSS 0.03038f $ **FLOATING
C808 VDD.n158 VSS 0.54009f $ **FLOATING
C809 WLOFF.t1 VSS 0.05298f $ **FLOATING
C810 WLOFF.t0 VSS 0.05229f $ **FLOATING
C811 WLOFF.n0 VSS 0.60037f $ **FLOATING
C812 WLOFF.t63 VSS 0.05298f $ **FLOATING
C813 WLOFF.t62 VSS 0.05229f $ **FLOATING
C814 WLOFF.n1 VSS 0.60037f $ **FLOATING
C815 WLOFF.n2 VSS 1.58319f $ **FLOATING
C816 WLOFF.n3 VSS 1.19641f $ **FLOATING
C817 WLOFF.t61 VSS 0.05298f $ **FLOATING
C818 WLOFF.t60 VSS 0.05229f $ **FLOATING
C819 WLOFF.n4 VSS 0.60037f $ **FLOATING
C820 WLOFF.n5 VSS 1.58319f $ **FLOATING
C821 WLOFF.n6 VSS 1.27374f $ **FLOATING
C822 WLOFF.t59 VSS 0.05298f $ **FLOATING
C823 WLOFF.t58 VSS 0.05229f $ **FLOATING
C824 WLOFF.n7 VSS 0.60037f $ **FLOATING
C825 WLOFF.n8 VSS 1.58319f $ **FLOATING
C826 WLOFF.n9 VSS 1.27374f $ **FLOATING
C827 WLOFF.t57 VSS 0.05298f $ **FLOATING
C828 WLOFF.t56 VSS 0.05229f $ **FLOATING
C829 WLOFF.n10 VSS 0.60037f $ **FLOATING
C830 WLOFF.n11 VSS 1.58319f $ **FLOATING
C831 WLOFF.n12 VSS 1.27374f $ **FLOATING
C832 WLOFF.t55 VSS 0.05298f $ **FLOATING
C833 WLOFF.t54 VSS 0.05229f $ **FLOATING
C834 WLOFF.n13 VSS 0.60037f $ **FLOATING
C835 WLOFF.n14 VSS 1.58319f $ **FLOATING
C836 WLOFF.n15 VSS 1.27374f $ **FLOATING
C837 WLOFF.t53 VSS 0.05298f $ **FLOATING
C838 WLOFF.t52 VSS 0.05229f $ **FLOATING
C839 WLOFF.n16 VSS 0.60037f $ **FLOATING
C840 WLOFF.n17 VSS 1.58319f $ **FLOATING
C841 WLOFF.n18 VSS 1.27374f $ **FLOATING
C842 WLOFF.t51 VSS 0.05298f $ **FLOATING
C843 WLOFF.t50 VSS 0.05229f $ **FLOATING
C844 WLOFF.n19 VSS 0.60037f $ **FLOATING
C845 WLOFF.n20 VSS 1.58319f $ **FLOATING
C846 WLOFF.n21 VSS 1.27374f $ **FLOATING
C847 WLOFF.t49 VSS 0.05298f $ **FLOATING
C848 WLOFF.t48 VSS 0.05229f $ **FLOATING
C849 WLOFF.n22 VSS 0.60037f $ **FLOATING
C850 WLOFF.n23 VSS 1.58319f $ **FLOATING
C851 WLOFF.n24 VSS 1.27374f $ **FLOATING
C852 WLOFF.t47 VSS 0.05298f $ **FLOATING
C853 WLOFF.t46 VSS 0.05229f $ **FLOATING
C854 WLOFF.n25 VSS 0.60037f $ **FLOATING
C855 WLOFF.n26 VSS 1.58319f $ **FLOATING
C856 WLOFF.n27 VSS 1.27374f $ **FLOATING
C857 WLOFF.t45 VSS 0.05298f $ **FLOATING
C858 WLOFF.t44 VSS 0.05229f $ **FLOATING
C859 WLOFF.n28 VSS 0.60037f $ **FLOATING
C860 WLOFF.n29 VSS 1.58319f $ **FLOATING
C861 WLOFF.n30 VSS 1.27374f $ **FLOATING
C862 WLOFF.t43 VSS 0.05298f $ **FLOATING
C863 WLOFF.t42 VSS 0.05229f $ **FLOATING
C864 WLOFF.n31 VSS 0.60037f $ **FLOATING
C865 WLOFF.n32 VSS 1.58319f $ **FLOATING
C866 WLOFF.n33 VSS 1.27374f $ **FLOATING
C867 WLOFF.t41 VSS 0.05298f $ **FLOATING
C868 WLOFF.t40 VSS 0.05229f $ **FLOATING
C869 WLOFF.n34 VSS 0.60037f $ **FLOATING
C870 WLOFF.n35 VSS 1.58319f $ **FLOATING
C871 WLOFF.n36 VSS 1.27374f $ **FLOATING
C872 WLOFF.t39 VSS 0.05298f $ **FLOATING
C873 WLOFF.t38 VSS 0.05229f $ **FLOATING
C874 WLOFF.n37 VSS 0.60037f $ **FLOATING
C875 WLOFF.n38 VSS 1.58319f $ **FLOATING
C876 WLOFF.n39 VSS 1.27374f $ **FLOATING
C877 WLOFF.t37 VSS 0.05298f $ **FLOATING
C878 WLOFF.t36 VSS 0.05229f $ **FLOATING
C879 WLOFF.n40 VSS 0.60037f $ **FLOATING
C880 WLOFF.n41 VSS 1.58319f $ **FLOATING
C881 WLOFF.n42 VSS 1.27374f $ **FLOATING
C882 WLOFF.t35 VSS 0.05298f $ **FLOATING
C883 WLOFF.t34 VSS 0.05229f $ **FLOATING
C884 WLOFF.n43 VSS 0.60037f $ **FLOATING
C885 WLOFF.n44 VSS 1.58319f $ **FLOATING
C886 WLOFF.n45 VSS 1.27374f $ **FLOATING
C887 WLOFF.t33 VSS 0.05298f $ **FLOATING
C888 WLOFF.t32 VSS 0.05229f $ **FLOATING
C889 WLOFF.n46 VSS 0.60037f $ **FLOATING
C890 WLOFF.n47 VSS 1.58319f $ **FLOATING
C891 WLOFF.n48 VSS 1.27374f $ **FLOATING
C892 WLOFF.t31 VSS 0.05298f $ **FLOATING
C893 WLOFF.t30 VSS 0.05229f $ **FLOATING
C894 WLOFF.n49 VSS 0.60037f $ **FLOATING
C895 WLOFF.n50 VSS 1.58319f $ **FLOATING
C896 WLOFF.n51 VSS 1.27374f $ **FLOATING
C897 WLOFF.t29 VSS 0.05298f $ **FLOATING
C898 WLOFF.t28 VSS 0.05229f $ **FLOATING
C899 WLOFF.n52 VSS 0.60037f $ **FLOATING
C900 WLOFF.n53 VSS 1.58319f $ **FLOATING
C901 WLOFF.n54 VSS 1.27374f $ **FLOATING
C902 WLOFF.t27 VSS 0.05298f $ **FLOATING
C903 WLOFF.t26 VSS 0.05229f $ **FLOATING
C904 WLOFF.n55 VSS 0.60037f $ **FLOATING
C905 WLOFF.n56 VSS 1.58319f $ **FLOATING
C906 WLOFF.n57 VSS 1.27374f $ **FLOATING
C907 WLOFF.t25 VSS 0.05298f $ **FLOATING
C908 WLOFF.t24 VSS 0.05229f $ **FLOATING
C909 WLOFF.n58 VSS 0.60037f $ **FLOATING
C910 WLOFF.n59 VSS 1.58319f $ **FLOATING
C911 WLOFF.n60 VSS 1.27374f $ **FLOATING
C912 WLOFF.t23 VSS 0.05298f $ **FLOATING
C913 WLOFF.t22 VSS 0.05229f $ **FLOATING
C914 WLOFF.n61 VSS 0.60037f $ **FLOATING
C915 WLOFF.n62 VSS 1.58319f $ **FLOATING
C916 WLOFF.n63 VSS 1.27374f $ **FLOATING
C917 WLOFF.t21 VSS 0.05298f $ **FLOATING
C918 WLOFF.t20 VSS 0.05229f $ **FLOATING
C919 WLOFF.n64 VSS 0.60037f $ **FLOATING
C920 WLOFF.n65 VSS 1.58319f $ **FLOATING
C921 WLOFF.n66 VSS 1.27374f $ **FLOATING
C922 WLOFF.t19 VSS 0.05298f $ **FLOATING
C923 WLOFF.t18 VSS 0.05229f $ **FLOATING
C924 WLOFF.n67 VSS 0.60037f $ **FLOATING
C925 WLOFF.n68 VSS 1.58319f $ **FLOATING
C926 WLOFF.n69 VSS 1.27374f $ **FLOATING
C927 WLOFF.t17 VSS 0.05298f $ **FLOATING
C928 WLOFF.t16 VSS 0.05229f $ **FLOATING
C929 WLOFF.n70 VSS 0.60037f $ **FLOATING
C930 WLOFF.n71 VSS 1.58319f $ **FLOATING
C931 WLOFF.n72 VSS 1.27374f $ **FLOATING
C932 WLOFF.t15 VSS 0.05298f $ **FLOATING
C933 WLOFF.t14 VSS 0.05229f $ **FLOATING
C934 WLOFF.n73 VSS 0.60037f $ **FLOATING
C935 WLOFF.n74 VSS 1.58319f $ **FLOATING
C936 WLOFF.n75 VSS 1.27374f $ **FLOATING
C937 WLOFF.t13 VSS 0.05298f $ **FLOATING
C938 WLOFF.t12 VSS 0.05229f $ **FLOATING
C939 WLOFF.n76 VSS 0.60037f $ **FLOATING
C940 WLOFF.n77 VSS 1.58319f $ **FLOATING
C941 WLOFF.n78 VSS 1.27374f $ **FLOATING
C942 WLOFF.t11 VSS 0.05298f $ **FLOATING
C943 WLOFF.t10 VSS 0.05229f $ **FLOATING
C944 WLOFF.n79 VSS 0.60037f $ **FLOATING
C945 WLOFF.n80 VSS 1.58319f $ **FLOATING
C946 WLOFF.n81 VSS 1.27374f $ **FLOATING
C947 WLOFF.t9 VSS 0.05298f $ **FLOATING
C948 WLOFF.t8 VSS 0.05229f $ **FLOATING
C949 WLOFF.n82 VSS 0.60037f $ **FLOATING
C950 WLOFF.n83 VSS 1.58319f $ **FLOATING
C951 WLOFF.n84 VSS 1.27374f $ **FLOATING
C952 WLOFF.t7 VSS 0.05298f $ **FLOATING
C953 WLOFF.t6 VSS 0.05229f $ **FLOATING
C954 WLOFF.n85 VSS 0.60037f $ **FLOATING
C955 WLOFF.n86 VSS 1.58319f $ **FLOATING
C956 WLOFF.n87 VSS 1.27374f $ **FLOATING
C957 WLOFF.t5 VSS 0.05298f $ **FLOATING
C958 WLOFF.t4 VSS 0.05229f $ **FLOATING
C959 WLOFF.n88 VSS 0.60037f $ **FLOATING
C960 WLOFF.n89 VSS 1.58319f $ **FLOATING
C961 WLOFF.n90 VSS 1.27374f $ **FLOATING
C962 WLOFF.t3 VSS 0.05298f $ **FLOATING
C963 WLOFF.t2 VSS 0.05229f $ **FLOATING
C964 WLOFF.n91 VSS 0.60037f $ **FLOATING
C965 WLOFF.n92 VSS 1.58319f $ **FLOATING
C966 WLOFF.n93 VSS 1.60795f $ **FLOATING
C967 WLOFF.n94 VSS 1.73497f $ **FLOATING
C968 BL.t5 VSS 0.08871f $ **FLOATING
C969 BL.t11 VSS 0.08871f $ **FLOATING
C970 BL.n0 VSS 3.38308f $ **FLOATING
C971 BL.n1 VSS 1.91072f $ **FLOATING
C972 BL.t28 VSS 0.08871f $ **FLOATING
C973 BL.n2 VSS 3.38308f $ **FLOATING
C974 BL.n3 VSS 1.97516f $ **FLOATING
C975 BL.t2 VSS 0.08871f $ **FLOATING
C976 BL.n4 VSS 3.38308f $ **FLOATING
C977 BL.n5 VSS 1.97516f $ **FLOATING
C978 BL.t30 VSS 0.08871f $ **FLOATING
C979 BL.n6 VSS 3.38308f $ **FLOATING
C980 BL.n7 VSS 1.97516f $ **FLOATING
C981 BL.t22 VSS 0.08871f $ **FLOATING
C982 BL.n8 VSS 3.38308f $ **FLOATING
C983 BL.n9 VSS 1.97516f $ **FLOATING
C984 BL.t31 VSS 0.08871f $ **FLOATING
C985 BL.n10 VSS 3.38308f $ **FLOATING
C986 BL.n11 VSS 1.97516f $ **FLOATING
C987 BL.t4 VSS 0.08871f $ **FLOATING
C988 BL.n12 VSS 3.38308f $ **FLOATING
C989 BL.n13 VSS 1.97516f $ **FLOATING
C990 BL.t7 VSS 0.08871f $ **FLOATING
C991 BL.n14 VSS 3.38308f $ **FLOATING
C992 BL.n15 VSS 1.97516f $ **FLOATING
C993 BL.t8 VSS 0.08871f $ **FLOATING
C994 BL.n16 VSS 3.38308f $ **FLOATING
C995 BL.n17 VSS 1.97516f $ **FLOATING
C996 BL.t24 VSS 0.08871f $ **FLOATING
C997 BL.n18 VSS 3.38308f $ **FLOATING
C998 BL.n19 VSS 1.97516f $ **FLOATING
C999 BL.t23 VSS 0.08871f $ **FLOATING
C1000 BL.n20 VSS 3.38308f $ **FLOATING
C1001 BL.n21 VSS 1.97516f $ **FLOATING
C1002 BL.t9 VSS 0.08871f $ **FLOATING
C1003 BL.n22 VSS 3.38308f $ **FLOATING
C1004 BL.n23 VSS 1.97516f $ **FLOATING
C1005 BL.t19 VSS 0.08871f $ **FLOATING
C1006 BL.n24 VSS 3.38308f $ **FLOATING
C1007 BL.n25 VSS 1.97516f $ **FLOATING
C1008 BL.t14 VSS 0.08871f $ **FLOATING
C1009 BL.n26 VSS 3.38308f $ **FLOATING
C1010 BL.n27 VSS 1.97516f $ **FLOATING
C1011 BL.t27 VSS 0.08871f $ **FLOATING
C1012 BL.n28 VSS 3.38308f $ **FLOATING
C1013 BL.n29 VSS 1.97516f $ **FLOATING
C1014 BL.t10 VSS 0.08871f $ **FLOATING
C1015 BL.n30 VSS 3.38308f $ **FLOATING
C1016 BL.n31 VSS 1.97516f $ **FLOATING
C1017 BL.t13 VSS 0.08871f $ **FLOATING
C1018 BL.n32 VSS 3.38308f $ **FLOATING
C1019 BL.n33 VSS 1.97516f $ **FLOATING
C1020 BL.t12 VSS 0.08871f $ **FLOATING
C1021 BL.n34 VSS 3.38308f $ **FLOATING
C1022 BL.n35 VSS 1.97516f $ **FLOATING
C1023 BL.t18 VSS 0.08871f $ **FLOATING
C1024 BL.n36 VSS 3.38308f $ **FLOATING
C1025 BL.n37 VSS 1.97516f $ **FLOATING
C1026 BL.t15 VSS 0.08871f $ **FLOATING
C1027 BL.n38 VSS 3.38308f $ **FLOATING
C1028 BL.n39 VSS 1.97516f $ **FLOATING
C1029 BL.t29 VSS 0.08871f $ **FLOATING
C1030 BL.n40 VSS 3.38308f $ **FLOATING
C1031 BL.n41 VSS 1.97516f $ **FLOATING
C1032 BL.t17 VSS 0.08871f $ **FLOATING
C1033 BL.n42 VSS 3.38308f $ **FLOATING
C1034 BL.n43 VSS 1.97516f $ **FLOATING
C1035 BL.t0 VSS 0.08871f $ **FLOATING
C1036 BL.n44 VSS 3.38308f $ **FLOATING
C1037 BL.n45 VSS 1.97516f $ **FLOATING
C1038 BL.t26 VSS 0.08871f $ **FLOATING
C1039 BL.n46 VSS 3.38308f $ **FLOATING
C1040 BL.n47 VSS 1.97516f $ **FLOATING
C1041 BL.t6 VSS 0.08871f $ **FLOATING
C1042 BL.n48 VSS 3.38308f $ **FLOATING
C1043 BL.n49 VSS 1.97516f $ **FLOATING
C1044 BL.t1 VSS 0.08871f $ **FLOATING
C1045 BL.n50 VSS 3.38308f $ **FLOATING
C1046 BL.n51 VSS 1.97516f $ **FLOATING
C1047 BL.t21 VSS 0.08871f $ **FLOATING
C1048 BL.n52 VSS 3.38308f $ **FLOATING
C1049 BL.n53 VSS 1.97516f $ **FLOATING
C1050 BL.t20 VSS 0.08871f $ **FLOATING
C1051 BL.n54 VSS 3.38308f $ **FLOATING
C1052 BL.n55 VSS 1.97516f $ **FLOATING
C1053 BL.t16 VSS 0.08871f $ **FLOATING
C1054 BL.n56 VSS 3.38308f $ **FLOATING
C1055 BL.n57 VSS 1.97516f $ **FLOATING
C1056 BL.t3 VSS 0.08871f $ **FLOATING
C1057 BL.n58 VSS 3.38308f $ **FLOATING
C1058 BL.n59 VSS 1.97516f $ **FLOATING
C1059 BL.t25 VSS 0.08871f $ **FLOATING
C1060 BL.n60 VSS 3.38308f $ **FLOATING
C1061 BL.n61 VSS 2.56969f $ **FLOATING
C1062 BL.n62 VSS 3.65309f $ **FLOATING
C1063 BLB.t7 VSS 0.08355f $ **FLOATING
C1064 BLB.t21 VSS 0.08355f $ **FLOATING
C1065 BLB.n0 VSS 3.10398f $ **FLOATING
C1066 BLB.n1 VSS 1.84218f $ **FLOATING
C1067 BLB.t6 VSS 0.08355f $ **FLOATING
C1068 BLB.n2 VSS 3.10398f $ **FLOATING
C1069 BLB.n3 VSS 1.85059f $ **FLOATING
C1070 BLB.t4 VSS 0.08355f $ **FLOATING
C1071 BLB.n4 VSS 3.10398f $ **FLOATING
C1072 BLB.n5 VSS 1.85059f $ **FLOATING
C1073 BLB.t1 VSS 0.08355f $ **FLOATING
C1074 BLB.n6 VSS 3.10398f $ **FLOATING
C1075 BLB.n7 VSS 1.85059f $ **FLOATING
C1076 BLB.t22 VSS 0.08355f $ **FLOATING
C1077 BLB.n8 VSS 3.10398f $ **FLOATING
C1078 BLB.n9 VSS 1.85059f $ **FLOATING
C1079 BLB.t11 VSS 0.08355f $ **FLOATING
C1080 BLB.n10 VSS 3.10398f $ **FLOATING
C1081 BLB.n11 VSS 1.85059f $ **FLOATING
C1082 BLB.t10 VSS 0.08355f $ **FLOATING
C1083 BLB.n12 VSS 3.10398f $ **FLOATING
C1084 BLB.n13 VSS 1.85059f $ **FLOATING
C1085 BLB.t19 VSS 0.08355f $ **FLOATING
C1086 BLB.n14 VSS 3.10398f $ **FLOATING
C1087 BLB.n15 VSS 1.85059f $ **FLOATING
C1088 BLB.t25 VSS 0.08355f $ **FLOATING
C1089 BLB.n16 VSS 3.10398f $ **FLOATING
C1090 BLB.n17 VSS 1.85059f $ **FLOATING
C1091 BLB.t2 VSS 0.08355f $ **FLOATING
C1092 BLB.n18 VSS 3.10398f $ **FLOATING
C1093 BLB.n19 VSS 1.85059f $ **FLOATING
C1094 BLB.t26 VSS 0.08355f $ **FLOATING
C1095 BLB.n20 VSS 3.10398f $ **FLOATING
C1096 BLB.n21 VSS 1.85059f $ **FLOATING
C1097 BLB.t29 VSS 0.08355f $ **FLOATING
C1098 BLB.n22 VSS 3.10398f $ **FLOATING
C1099 BLB.n23 VSS 1.85059f $ **FLOATING
C1100 BLB.t8 VSS 0.08355f $ **FLOATING
C1101 BLB.n24 VSS 3.10398f $ **FLOATING
C1102 BLB.n25 VSS 1.85059f $ **FLOATING
C1103 BLB.t20 VSS 0.08355f $ **FLOATING
C1104 BLB.n26 VSS 3.10398f $ **FLOATING
C1105 BLB.n27 VSS 1.85059f $ **FLOATING
C1106 BLB.t13 VSS 0.08355f $ **FLOATING
C1107 BLB.n28 VSS 3.10398f $ **FLOATING
C1108 BLB.n29 VSS 1.85059f $ **FLOATING
C1109 BLB.t15 VSS 0.08355f $ **FLOATING
C1110 BLB.n30 VSS 3.10398f $ **FLOATING
C1111 BLB.n31 VSS 1.85059f $ **FLOATING
C1112 BLB.t17 VSS 0.08355f $ **FLOATING
C1113 BLB.n32 VSS 3.10398f $ **FLOATING
C1114 BLB.n33 VSS 1.85059f $ **FLOATING
C1115 BLB.t3 VSS 0.08355f $ **FLOATING
C1116 BLB.n34 VSS 3.10398f $ **FLOATING
C1117 BLB.n35 VSS 1.85059f $ **FLOATING
C1118 BLB.t28 VSS 0.08355f $ **FLOATING
C1119 BLB.n36 VSS 3.10398f $ **FLOATING
C1120 BLB.n37 VSS 1.85059f $ **FLOATING
C1121 BLB.t5 VSS 0.08355f $ **FLOATING
C1122 BLB.n38 VSS 3.10398f $ **FLOATING
C1123 BLB.n39 VSS 1.85059f $ **FLOATING
C1124 BLB.t31 VSS 0.08355f $ **FLOATING
C1125 BLB.n40 VSS 3.10398f $ **FLOATING
C1126 BLB.n41 VSS 1.85059f $ **FLOATING
C1127 BLB.t12 VSS 0.08355f $ **FLOATING
C1128 BLB.n42 VSS 3.10398f $ **FLOATING
C1129 BLB.n43 VSS 1.85059f $ **FLOATING
C1130 BLB.t24 VSS 0.08355f $ **FLOATING
C1131 BLB.n44 VSS 3.10398f $ **FLOATING
C1132 BLB.n45 VSS 1.85059f $ **FLOATING
C1133 BLB.t27 VSS 0.08355f $ **FLOATING
C1134 BLB.n46 VSS 3.10398f $ **FLOATING
C1135 BLB.n47 VSS 1.85059f $ **FLOATING
C1136 BLB.t23 VSS 0.08355f $ **FLOATING
C1137 BLB.n48 VSS 3.10398f $ **FLOATING
C1138 BLB.n49 VSS 1.85059f $ **FLOATING
C1139 BLB.t18 VSS 0.08355f $ **FLOATING
C1140 BLB.n50 VSS 3.10398f $ **FLOATING
C1141 BLB.n51 VSS 1.85059f $ **FLOATING
C1142 BLB.t14 VSS 0.08355f $ **FLOATING
C1143 BLB.n52 VSS 3.10398f $ **FLOATING
C1144 BLB.n53 VSS 1.85059f $ **FLOATING
C1145 BLB.t16 VSS 0.08355f $ **FLOATING
C1146 BLB.n54 VSS 3.10398f $ **FLOATING
C1147 BLB.n55 VSS 1.85059f $ **FLOATING
C1148 BLB.t30 VSS 0.08355f $ **FLOATING
C1149 BLB.n56 VSS 3.10398f $ **FLOATING
C1150 BLB.n57 VSS 1.85059f $ **FLOATING
C1151 BLB.t9 VSS 0.08355f $ **FLOATING
C1152 BLB.n58 VSS 3.10398f $ **FLOATING
C1153 BLB.n59 VSS 1.85059f $ **FLOATING
C1154 BLB.t0 VSS 0.08355f $ **FLOATING
C1155 BLB.n60 VSS 3.10398f $ **FLOATING
C1156 BLB.n61 VSS 2.47909f $ **FLOATING
C1157 BLB.n62 VSS 3.38942f $ **FLOATING
.ends
