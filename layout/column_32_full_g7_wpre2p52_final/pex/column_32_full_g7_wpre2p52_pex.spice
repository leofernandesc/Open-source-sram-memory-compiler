* NGSPICE file created from column_32_full_g7_wpre2p52_flat.ext - technology: sky130A

.subckt column_32_full_g7_wpre2p52_flat BL BLB VSS VDD WLOFF PRECH SCLK WE DATA_B
+ DATA
X0 BLB.t32 WLOFF.t28 a_576_26220.t2 VSS.t61 sky130_fd_pr__nfet_01v8 ad=0.171 pd=1.77 as=0.171 ps=1.77 w=0.6 l=0.15
X1 a_576_20820.t1 a_623_20916.t4 VDD.t15 VDD.t14 sky130_fd_pr__pfet_01v8 ad=0.1197 pd=1.41 as=0.1197 ps=1.41 w=0.42 l=0.15
X2 BLB.t15 WLOFF.t54 a_576_49620.t2 VSS.t61 sky130_fd_pr__nfet_01v8 ad=0.171 pd=1.77 as=0.171 ps=1.77 w=0.6 l=0.15
X3 BL.t20 WLOFF.t3 a_623_2916.t1 VSS.t60 sky130_fd_pr__nfet_01v8 ad=0.171 pd=1.77 as=0.171 ps=1.77 w=0.6 l=0.15
X4 a_623_17316.t1 a_576_17220.t4 VDD.t77 VDD.t76 sky130_fd_pr__pfet_01v8 ad=0.1197 pd=1.41 as=0.1197 ps=1.41 w=0.42 l=0.15
X5 a_623_28116.t0 a_576_28020.t3 VSS.t48 VSS.t1 sky130_fd_pr__nfet_01v8 ad=0.3591 pd=3.09 as=0.3591 ps=3.09 w=1.26 l=0.15
X6 a_576_44220.t0 a_623_44316.t3 VSS.t24 VSS.t3 sky130_fd_pr__nfet_01v8 ad=0.3591 pd=3.09 as=0.3591 ps=3.09 w=1.26 l=0.15
X7 a_3077_n9274.t1 DATA.t1 BLB.t33 VDD.t137 sky130_fd_pr__pfet_01v8 ad=1.4616 pd=10.66 as=1.4616 ps=10.66 w=5.04 l=0.15
X8 BL.t7 WLOFF.t39 a_623_35316.t1 VSS.t60 sky130_fd_pr__nfet_01v8 ad=0.171 pd=1.77 as=0.171 ps=1.77 w=0.6 l=0.15
X9 a_1065_n6268.t1 sense_amp_scale1p5_flat_0.SA_OUT.t3 sense_amp_scale1p5_flat_0.SA_OUTB.t0 VSS.t5 sky130_fd_pr__nfet_01v8 ad=0.2842 pd=2.54 as=0.2842 ps=2.54 w=0.98 l=0.15
X10 VDD.t143 PRECH.t1 BLB.t35 VDD.t142 sky130_fd_pr__pfet_01v8 ad=0.7308 pd=5.62 as=0.7308 ps=5.62 w=2.52 l=0.15
X11 BLB.t3 WLOFF.t32 a_576_29820.t2 VSS.t61 sky130_fd_pr__nfet_01v8 ad=0.171 pd=1.77 as=0.171 ps=1.77 w=0.6 l=0.15
X12 a_576_24420.t0 a_623_24516.t3 VSS.t10 VSS.t3 sky130_fd_pr__nfet_01v8 ad=0.3591 pd=3.09 as=0.3591 ps=3.09 w=1.26 l=0.15
X13 BL.t24 WLOFF.t17 a_623_15516.t2 VSS.t60 sky130_fd_pr__nfet_01v8 ad=0.171 pd=1.77 as=0.171 ps=1.77 w=0.6 l=0.15
X14 a_576_47820.t0 a_623_47916.t3 VSS.t70 VSS.t3 sky130_fd_pr__nfet_01v8 ad=0.3591 pd=3.09 as=0.3591 ps=3.09 w=1.26 l=0.15
X15 a_576_44220.t1 a_623_44316.t4 VDD.t134 VDD.t133 sky130_fd_pr__pfet_01v8 ad=0.1197 pd=1.41 as=0.1197 ps=1.41 w=0.42 l=0.15
X16 BL.t5 WLOFF.t43 a_623_38916.t2 VSS.t60 sky130_fd_pr__nfet_01v8 ad=0.171 pd=1.77 as=0.171 ps=1.77 w=0.6 l=0.15
X17 BLB.t14 WLOFF.t56 a_576_51420.t2 VSS.t61 sky130_fd_pr__nfet_01v8 ad=0.171 pd=1.77 as=0.171 ps=1.77 w=0.6 l=0.15
X18 a_576_28020.t0 a_623_28116.t3 VSS.t34 VSS.t3 sky130_fd_pr__nfet_01v8 ad=0.3591 pd=3.09 as=0.3591 ps=3.09 w=1.26 l=0.15
X19 a_576_24420.t1 a_623_24516.t4 VDD.t33 VDD.t32 sky130_fd_pr__pfet_01v8 ad=0.1197 pd=1.41 as=0.1197 ps=1.41 w=0.42 l=0.15
X20 a_576_1020.t1 a_623_1116.t4 VDD.t5 VDD.t4 sky130_fd_pr__pfet_01v8 ad=0.1197 pd=1.41 as=0.1197 ps=1.41 w=0.42 l=0.15
X21 BL.t15 WLOFF.t21 a_623_19116.t2 VSS.t60 sky130_fd_pr__nfet_01v8 ad=0.171 pd=1.77 as=0.171 ps=1.77 w=0.6 l=0.15
X22 a_623_42516.t0 a_576_42420.t4 VDD.t31 VDD.t30 sky130_fd_pr__pfet_01v8 ad=0.1197 pd=1.41 as=0.1197 ps=1.41 w=0.42 l=0.15
X23 VSS.t64 SCLK.t0 a_1065_n6268.t2 VSS.t63 sky130_fd_pr__nfet_01v8 ad=0.2842 pd=2.54 as=0.2842 ps=2.54 w=0.98 l=0.15
X24 a_623_2916.t0 a_576_2820.t3 VSS.t16 VSS.t1 sky130_fd_pr__nfet_01v8 ad=0.3591 pd=3.09 as=0.3591 ps=3.09 w=1.26 l=0.15
X25 BL.t28 WLOFF.t7 a_623_6516.t2 VSS.t60 sky130_fd_pr__nfet_01v8 ad=0.171 pd=1.77 as=0.171 ps=1.77 w=0.6 l=0.15
X26 a_576_47820.t1 a_623_47916.t4 VDD.t39 VDD.t38 sky130_fd_pr__pfet_01v8 ad=0.1197 pd=1.41 as=0.1197 ps=1.41 w=0.42 l=0.15
X27 a_623_53316.t0 a_576_53220.t3 VSS.t39 VSS.t1 sky130_fd_pr__nfet_01v8 ad=0.3591 pd=3.09 as=0.3591 ps=3.09 w=1.26 l=0.15
X28 BLB.t4 WLOFF.t34 a_576_31620.t2 VSS.t61 sky130_fd_pr__nfet_01v8 ad=0.171 pd=1.77 as=0.171 ps=1.77 w=0.6 l=0.15
X29 a_623_10116.t2 a_576_10020.t3 VSS.t69 VSS.t1 sky130_fd_pr__nfet_01v8 ad=0.3591 pd=3.09 as=0.3591 ps=3.09 w=1.26 l=0.15
X30 BLB.t24 WLOFF.t60 a_576_55020.t2 VSS.t61 sky130_fd_pr__nfet_01v8 ad=0.171 pd=1.77 as=0.171 ps=1.77 w=0.6 l=0.15
X31 a_623_22716.t1 a_576_22620.t4 VDD.t29 VDD.t28 sky130_fd_pr__pfet_01v8 ad=0.1197 pd=1.41 as=0.1197 ps=1.41 w=0.42 l=0.15
X32 a_576_4620.t1 a_623_4716.t4 VDD.t81 VDD.t80 sky130_fd_pr__pfet_01v8 ad=0.1197 pd=1.41 as=0.1197 ps=1.41 w=0.42 l=0.15
X33 a_623_33516.t0 a_576_33420.t3 VSS.t58 VSS.t1 sky130_fd_pr__nfet_01v8 ad=0.3591 pd=3.09 as=0.3591 ps=3.09 w=1.26 l=0.15
X34 BL.t22 WLOFF.t11 a_623_10116.t1 VSS.t60 sky130_fd_pr__nfet_01v8 ad=0.171 pd=1.77 as=0.171 ps=1.77 w=0.6 l=0.15
X35 BLB.t23 WLOFF.t12 a_576_11820.t2 VSS.t61 sky130_fd_pr__nfet_01v8 ad=0.171 pd=1.77 as=0.171 ps=1.77 w=0.6 l=0.15
X36 BL.t27 WLOFF.t45 a_623_40716.t2 VSS.t60 sky130_fd_pr__nfet_01v8 ad=0.171 pd=1.77 as=0.171 ps=1.77 w=0.6 l=0.15
X37 VDD.t141 WE.t3 a_677_n8854.t1 VDD.t140 sky130_fd_pr__pfet_01v8 ad=0.2436 pd=2.26 as=0.2436 ps=2.26 w=0.84 l=0.15
X38 a_623_56916.t1 a_576_56820.t3 VSS.t56 VSS.t1 sky130_fd_pr__nfet_01v8 ad=0.3591 pd=3.09 as=0.3591 ps=3.09 w=1.26 l=0.15
X39 a_623_1116.t0 a_576_1020.t4 VDD.t41 VDD.t40 sky130_fd_pr__pfet_01v8 ad=0.1197 pd=1.41 as=0.1197 ps=1.41 w=0.42 l=0.15
X40 a_623_13716.t0 a_576_13620.t3 VSS.t6 VSS.t1 sky130_fd_pr__nfet_01v8 ad=0.3591 pd=3.09 as=0.3591 ps=3.09 w=1.26 l=0.15
X41 VSS.t75 WE.t2 a_677_n8854.t0 VSS.t74 sky130_fd_pr__nfet_01v8 ad=0.2436 pd=2.26 as=0.2436 ps=2.26 w=0.84 l=0.15
X42 BL.t2 WLOFF.t23 a_623_20916.t2 VSS.t60 sky130_fd_pr__nfet_01v8 ad=0.171 pd=1.77 as=0.171 ps=1.77 w=0.6 l=0.15
X43 a_576_28020.t1 a_623_28116.t4 VDD.t105 VDD.t104 sky130_fd_pr__pfet_01v8 ad=0.1197 pd=1.41 as=0.1197 ps=1.41 w=0.42 l=0.15
X44 BLB.t36 PRECH.t0 BL.t36 VDD.t146 sky130_fd_pr__pfet_01v8 ad=0.7308 pd=5.62 as=0.7308 ps=5.62 w=2.52 l=0.15
X45 BLB.t28 WLOFF.t0 a_576_1020.t2 VSS.t61 sky130_fd_pr__nfet_01v8 ad=0.171 pd=1.77 as=0.171 ps=1.77 w=0.6 l=0.15
X46 a_623_6516.t0 a_576_6420.t3 VSS.t27 VSS.t1 sky130_fd_pr__nfet_01v8 ad=0.3591 pd=3.09 as=0.3591 ps=3.09 w=1.26 l=0.15
X47 a_623_46116.t0 a_576_46020.t4 VDD.t59 VDD.t58 sky130_fd_pr__pfet_01v8 ad=0.1197 pd=1.41 as=0.1197 ps=1.41 w=0.42 l=0.15
X48 a_623_4716.t0 a_576_4620.t4 VDD.t7 VDD.t6 sky130_fd_pr__pfet_01v8 ad=0.1197 pd=1.41 as=0.1197 ps=1.41 w=0.42 l=0.15
X49 a_1865_n13274.t0 DATA_B.t0 BL.t29 VSS.t62 sky130_fd_pr__nfet_01v8 ad=1.4616 pd=10.66 as=1.4616 ps=10.66 w=5.04 l=0.15
X50 BLB.t26 WLOFF.t38 a_576_35220.t2 VSS.t61 sky130_fd_pr__nfet_01v8 ad=0.171 pd=1.77 as=0.171 ps=1.77 w=0.6 l=0.15
X51 a_623_26316.t1 a_576_26220.t4 VDD.t109 VDD.t108 sky130_fd_pr__pfet_01v8 ad=0.1197 pd=1.41 as=0.1197 ps=1.41 w=0.42 l=0.15
X52 a_576_8220.t1 a_623_8316.t4 VDD.t13 VDD.t12 sky130_fd_pr__pfet_01v8 ad=0.1197 pd=1.41 as=0.1197 ps=1.41 w=0.42 l=0.15
X53 a_576_53220.t0 a_623_53316.t3 VSS.t22 VSS.t3 sky130_fd_pr__nfet_01v8 ad=0.3591 pd=3.09 as=0.3591 ps=3.09 w=1.26 l=0.15
X54 a_623_49716.t1 a_576_49620.t4 VDD.t101 VDD.t100 sky130_fd_pr__pfet_01v8 ad=0.1197 pd=1.41 as=0.1197 ps=1.41 w=0.42 l=0.15
X55 a_623_37116.t1 a_576_37020.t3 VSS.t46 VSS.t1 sky130_fd_pr__nfet_01v8 ad=0.3591 pd=3.09 as=0.3591 ps=3.09 w=1.26 l=0.15
X56 BLB.t7 WLOFF.t16 a_576_15420.t2 VSS.t61 sky130_fd_pr__nfet_01v8 ad=0.171 pd=1.77 as=0.171 ps=1.77 w=0.6 l=0.15
X57 BL.t10 WLOFF.t49 a_623_44316.t2 VSS.t60 sky130_fd_pr__nfet_01v8 ad=0.171 pd=1.77 as=0.171 ps=1.77 w=0.6 l=0.15
X58 BLB.t10 WLOFF.t42 a_576_38820.t2 VSS.t61 sky130_fd_pr__nfet_01v8 ad=0.171 pd=1.77 as=0.171 ps=1.77 w=0.6 l=0.15
X59 BLB.t16 WLOFF.t4 a_576_4620.t2 VSS.t61 sky130_fd_pr__nfet_01v8 ad=0.171 pd=1.77 as=0.171 ps=1.77 w=0.6 l=0.15
X60 a_623_17316.t0 a_576_17220.t3 VSS.t33 VSS.t1 sky130_fd_pr__nfet_01v8 ad=0.3591 pd=3.09 as=0.3591 ps=3.09 w=1.26 l=0.15
X61 a_576_33420.t0 a_623_33516.t3 VSS.t57 VSS.t3 sky130_fd_pr__nfet_01v8 ad=0.3591 pd=3.09 as=0.3591 ps=3.09 w=1.26 l=0.15
X62 a_623_29916.t1 a_576_29820.t4 VDD.t117 VDD.t116 sky130_fd_pr__pfet_01v8 ad=0.1197 pd=1.41 as=0.1197 ps=1.41 w=0.42 l=0.15
X63 BL.t21 WLOFF.t27 a_623_24516.t2 VSS.t60 sky130_fd_pr__nfet_01v8 ad=0.171 pd=1.77 as=0.171 ps=1.77 w=0.6 l=0.15
X64 BLB.t21 WLOFF.t20 a_576_19020.t2 VSS.t61 sky130_fd_pr__nfet_01v8 ad=0.171 pd=1.77 as=0.171 ps=1.77 w=0.6 l=0.15
X65 a_576_56820.t0 a_623_56916.t3 VSS.t42 VSS.t3 sky130_fd_pr__nfet_01v8 ad=0.3591 pd=3.09 as=0.3591 ps=3.09 w=1.26 l=0.15
X66 a_576_53220.t1 a_623_53316.t4 VDD.t79 VDD.t78 sky130_fd_pr__pfet_01v8 ad=0.1197 pd=1.41 as=0.1197 ps=1.41 w=0.42 l=0.15
X67 BL.t12 WLOFF.t53 a_623_47916.t2 VSS.t60 sky130_fd_pr__nfet_01v8 ad=0.171 pd=1.77 as=0.171 ps=1.77 w=0.6 l=0.15
X68 BL.t23 WLOFF.t1 a_623_1116.t2 VSS.t60 sky130_fd_pr__nfet_01v8 ad=0.171 pd=1.77 as=0.171 ps=1.77 w=0.6 l=0.15
X69 a_576_4620.t0 a_623_4716.t3 VSS.t35 VSS.t3 sky130_fd_pr__nfet_01v8 ad=0.3591 pd=3.09 as=0.3591 ps=3.09 w=1.26 l=0.15
X70 a_623_8316.t1 a_576_8220.t4 VDD.t97 VDD.t96 sky130_fd_pr__pfet_01v8 ad=0.1197 pd=1.41 as=0.1197 ps=1.41 w=0.42 l=0.15
X71 a_576_13620.t0 a_623_13716.t3 VSS.t17 VSS.t3 sky130_fd_pr__nfet_01v8 ad=0.3591 pd=3.09 as=0.3591 ps=3.09 w=1.26 l=0.15
X72 a_576_10020.t1 a_623_10116.t4 VDD.t27 VDD.t26 sky130_fd_pr__pfet_01v8 ad=0.1197 pd=1.41 as=0.1197 ps=1.41 w=0.42 l=0.15
X73 a_576_37020.t0 a_623_37116.t3 VSS.t73 VSS.t3 sky130_fd_pr__nfet_01v8 ad=0.3591 pd=3.09 as=0.3591 ps=3.09 w=1.26 l=0.15
X74 a_576_33420.t1 a_623_33516.t4 VDD.t124 VDD.t123 sky130_fd_pr__pfet_01v8 ad=0.1197 pd=1.41 as=0.1197 ps=1.41 w=0.42 l=0.15
X75 BL.t6 WLOFF.t31 a_623_28116.t2 VSS.t60 sky130_fd_pr__nfet_01v8 ad=0.171 pd=1.77 as=0.171 ps=1.77 w=0.6 l=0.15
X76 a_623_51516.t0 a_576_51420.t4 VDD.t75 VDD.t74 sky130_fd_pr__pfet_01v8 ad=0.1197 pd=1.41 as=0.1197 ps=1.41 w=0.42 l=0.15
X77 a_576_56820.t1 a_623_56916.t4 VDD.t91 VDD.t90 sky130_fd_pr__pfet_01v8 ad=0.1197 pd=1.41 as=0.1197 ps=1.41 w=0.42 l=0.15
X78 BLB.t19 WLOFF.t44 a_576_40620.t2 VSS.t61 sky130_fd_pr__nfet_01v8 ad=0.171 pd=1.77 as=0.171 ps=1.77 w=0.6 l=0.15
X79 a_576_13620.t1 a_623_13716.t4 VDD.t65 VDD.t64 sky130_fd_pr__pfet_01v8 ad=0.1197 pd=1.41 as=0.1197 ps=1.41 w=0.42 l=0.15
X80 a_623_31716.t1 a_576_31620.t4 VDD.t121 VDD.t120 sky130_fd_pr__pfet_01v8 ad=0.1197 pd=1.41 as=0.1197 ps=1.41 w=0.42 l=0.15
X81 BLB.t0 WLOFF.t8 a_576_8220.t2 VSS.t61 sky130_fd_pr__nfet_01v8 ad=0.171 pd=1.77 as=0.171 ps=1.77 w=0.6 l=0.15
X82 a_623_42516.t1 a_576_42420.t3 VSS.t29 VSS.t1 sky130_fd_pr__nfet_01v8 ad=0.3591 pd=3.09 as=0.3591 ps=3.09 w=1.26 l=0.15
X83 BLB.t5 WLOFF.t22 a_576_20820.t2 VSS.t61 sky130_fd_pr__nfet_01v8 ad=0.171 pd=1.77 as=0.171 ps=1.77 w=0.6 l=0.15
X84 a_623_11916.t0 a_576_11820.t4 VDD.t49 VDD.t48 sky130_fd_pr__pfet_01v8 ad=0.1197 pd=1.41 as=0.1197 ps=1.41 w=0.42 l=0.15
X85 a_576_8220.t0 a_623_8316.t3 VSS.t66 VSS.t3 sky130_fd_pr__nfet_01v8 ad=0.3591 pd=3.09 as=0.3591 ps=3.09 w=1.26 l=0.15
X86 a_576_17220.t0 a_623_17316.t3 VSS.t38 VSS.t3 sky130_fd_pr__nfet_01v8 ad=0.3591 pd=3.09 as=0.3591 ps=3.09 w=1.26 l=0.15
X87 a_623_22716.t0 a_576_22620.t3 VSS.t19 VSS.t1 sky130_fd_pr__nfet_01v8 ad=0.3591 pd=3.09 as=0.3591 ps=3.09 w=1.26 l=0.15
X88 a_576_37020.t1 a_623_37116.t4 VDD.t37 VDD.t36 sky130_fd_pr__pfet_01v8 ad=0.1197 pd=1.41 as=0.1197 ps=1.41 w=0.42 l=0.15
X89 a_623_55116.t0 a_576_55020.t4 VDD.t89 VDD.t88 sky130_fd_pr__pfet_01v8 ad=0.1197 pd=1.41 as=0.1197 ps=1.41 w=0.42 l=0.15
X90 BLB.t25 WLOFF.t48 a_576_44220.t2 VSS.t61 sky130_fd_pr__nfet_01v8 ad=0.171 pd=1.77 as=0.171 ps=1.77 w=0.6 l=0.15
X91 VDD.t130 a_677_n8854.t3 a_1477_n9274.t1 VDD.t129 sky130_fd_pr__pfet_01v8 ad=1.4616 pd=10.66 as=1.4616 ps=10.66 w=5.04 l=0.15
X92 a_576_17220.t1 a_623_17316.t4 VDD.t23 VDD.t22 sky130_fd_pr__pfet_01v8 ad=0.1197 pd=1.41 as=0.1197 ps=1.41 w=0.42 l=0.15
X93 a_623_35316.t0 a_576_35220.t4 VDD.t35 VDD.t34 sky130_fd_pr__pfet_01v8 ad=0.1197 pd=1.41 as=0.1197 ps=1.41 w=0.42 l=0.15
X94 a_623_46116.t2 a_576_46020.t3 VSS.t68 VSS.t1 sky130_fd_pr__nfet_01v8 ad=0.3591 pd=3.09 as=0.3591 ps=3.09 w=1.26 l=0.15
X95 BLB.t30 WLOFF.t26 a_576_24420.t2 VSS.t61 sky130_fd_pr__nfet_01v8 ad=0.171 pd=1.77 as=0.171 ps=1.77 w=0.6 l=0.15
X96 BL.t14 WLOFF.t59 a_623_53316.t2 VSS.t60 sky130_fd_pr__nfet_01v8 ad=0.171 pd=1.77 as=0.171 ps=1.77 w=0.6 l=0.15
X97 VSS.t77 WE.t1 a_1865_n13274.t1 VSS.t76 sky130_fd_pr__nfet_01v8 ad=1.4616 pd=10.66 as=1.4616 ps=10.66 w=5.04 l=0.15
X98 BLB.t11 WLOFF.t52 a_576_47820.t2 VSS.t61 sky130_fd_pr__nfet_01v8 ad=0.171 pd=1.77 as=0.171 ps=1.77 w=0.6 l=0.15
X99 a_623_15516.t1 a_576_15420.t4 VDD.t107 VDD.t106 sky130_fd_pr__pfet_01v8 ad=0.1197 pd=1.41 as=0.1197 ps=1.41 w=0.42 l=0.15
X100 a_623_26316.t0 a_576_26220.t3 VSS.t23 VSS.t1 sky130_fd_pr__nfet_01v8 ad=0.3591 pd=3.09 as=0.3591 ps=3.09 w=1.26 l=0.15
X101 a_576_42420.t0 a_623_42516.t3 VSS.t28 VSS.t3 sky130_fd_pr__nfet_01v8 ad=0.3591 pd=3.09 as=0.3591 ps=3.09 w=1.26 l=0.15
X102 a_623_38916.t1 a_576_38820.t4 VDD.t61 VDD.t60 sky130_fd_pr__pfet_01v8 ad=0.1197 pd=1.41 as=0.1197 ps=1.41 w=0.42 l=0.15
X103 a_623_49716.t0 a_576_49620.t3 VSS.t45 VSS.t1 sky130_fd_pr__nfet_01v8 ad=0.3591 pd=3.09 as=0.3591 ps=3.09 w=1.26 l=0.15
X104 BL.t32 WLOFF.t37 a_623_33516.t1 VSS.t60 sky130_fd_pr__nfet_01v8 ad=0.171 pd=1.77 as=0.171 ps=1.77 w=0.6 l=0.15
X105 BLB.t2 WLOFF.t30 a_576_28020.t2 VSS.t61 sky130_fd_pr__nfet_01v8 ad=0.171 pd=1.77 as=0.171 ps=1.77 w=0.6 l=0.15
X106 BL.t1 WLOFF.t63 a_623_56916.t2 VSS.t60 sky130_fd_pr__nfet_01v8 ad=0.171 pd=1.77 as=0.171 ps=1.77 w=0.6 l=0.15
X107 a_576_22620.t0 a_623_22716.t3 VSS.t11 VSS.t3 sky130_fd_pr__nfet_01v8 ad=0.3591 pd=3.09 as=0.3591 ps=3.09 w=1.26 l=0.15
X108 BL.t19 WLOFF.t15 a_623_13716.t2 VSS.t60 sky130_fd_pr__nfet_01v8 ad=0.171 pd=1.77 as=0.171 ps=1.77 w=0.6 l=0.15
X109 a_576_46020.t0 a_623_46116.t3 VSS.t44 VSS.t3 sky130_fd_pr__nfet_01v8 ad=0.3591 pd=3.09 as=0.3591 ps=3.09 w=1.26 l=0.15
X110 a_623_29916.t0 a_576_29820.t3 VSS.t49 VSS.t1 sky130_fd_pr__nfet_01v8 ad=0.3591 pd=3.09 as=0.3591 ps=3.09 w=1.26 l=0.15
X111 a_576_42420.t1 a_623_42516.t4 VDD.t21 VDD.t20 sky130_fd_pr__pfet_01v8 ad=0.1197 pd=1.41 as=0.1197 ps=1.41 w=0.42 l=0.15
X112 BL.t33 WLOFF.t41 a_623_37116.t2 VSS.t60 sky130_fd_pr__nfet_01v8 ad=0.171 pd=1.77 as=0.171 ps=1.77 w=0.6 l=0.15
X113 VDD.t128 sense_amp_scale1p5_flat_0.SA_OUTB.t4 sense_amp_scale1p5_flat_0.SA_OUT.t2 VDD.t127 sky130_fd_pr__pfet_01v8 ad=0.5481 pd=4.36 as=0.5481 ps=4.36 w=1.89 l=0.15
X114 a_576_22620.t1 a_623_22716.t4 VDD.t67 VDD.t66 sky130_fd_pr__pfet_01v8 ad=0.1197 pd=1.41 as=0.1197 ps=1.41 w=0.42 l=0.15
X115 a_623_40716.t1 a_576_40620.t4 VDD.t111 VDD.t110 sky130_fd_pr__pfet_01v8 ad=0.1197 pd=1.41 as=0.1197 ps=1.41 w=0.42 l=0.15
X116 BL.t16 WLOFF.t5 a_623_4716.t2 VSS.t60 sky130_fd_pr__nfet_01v8 ad=0.171 pd=1.77 as=0.171 ps=1.77 w=0.6 l=0.15
X117 a_623_19116.t0 a_576_19020.t4 VDD.t9 VDD.t8 sky130_fd_pr__pfet_01v8 ad=0.1197 pd=1.41 as=0.1197 ps=1.41 w=0.42 l=0.15
X118 a_623_51516.t2 a_576_51420.t3 VSS.t65 VSS.t1 sky130_fd_pr__nfet_01v8 ad=0.3591 pd=3.09 as=0.3591 ps=3.09 w=1.26 l=0.15
X119 a_576_2820.t2 a_623_2916.t4 VDD.t43 VDD.t42 sky130_fd_pr__pfet_01v8 ad=0.1197 pd=1.41 as=0.1197 ps=1.41 w=0.42 l=0.15
X120 a_623_20916.t1 a_576_20820.t4 VDD.t83 VDD.t82 sky130_fd_pr__pfet_01v8 ad=0.1197 pd=1.41 as=0.1197 ps=1.41 w=0.42 l=0.15
X121 a_623_31716.t0 a_576_31620.t3 VSS.t52 VSS.t1 sky130_fd_pr__nfet_01v8 ad=0.3591 pd=3.09 as=0.3591 ps=3.09 w=1.26 l=0.15
X122 a_576_26220.t0 a_623_26316.t3 VSS.t25 VSS.t3 sky130_fd_pr__nfet_01v8 ad=0.3591 pd=3.09 as=0.3591 ps=3.09 w=1.26 l=0.15
X123 a_1477_n9274.t0 DATA_B.t1 BL.t30 VDD.t122 sky130_fd_pr__pfet_01v8 ad=1.4616 pd=10.66 as=1.4616 ps=10.66 w=5.04 l=0.15
X124 a_576_1020.t0 a_623_1116.t3 VSS.t4 VSS.t3 sky130_fd_pr__nfet_01v8 ad=0.3591 pd=3.09 as=0.3591 ps=3.09 w=1.26 l=0.15
X125 a_623_1116.t1 a_576_1020.t3 VSS.t43 VSS.t1 sky130_fd_pr__nfet_01v8 ad=0.3591 pd=3.09 as=0.3591 ps=3.09 w=1.26 l=0.15
X126 BL.t11 WLOFF.t19 a_623_17316.t2 VSS.t60 sky130_fd_pr__nfet_01v8 ad=0.171 pd=1.77 as=0.171 ps=1.77 w=0.6 l=0.15
X127 a_576_49620.t0 a_623_49716.t3 VSS.t20 VSS.t3 sky130_fd_pr__nfet_01v8 ad=0.3591 pd=3.09 as=0.3591 ps=3.09 w=1.26 l=0.15
X128 VDD.t3 sense_amp_scale1p5_flat_0.SA_OUT.t4 sense_amp_scale1p5_flat_0.SA_OUTB.t1 VDD.t2 sky130_fd_pr__pfet_01v8 ad=0.5481 pd=4.36 as=0.5481 ps=4.36 w=1.89 l=0.15
X129 a_576_46020.t1 a_623_46116.t4 VDD.t113 VDD.t112 sky130_fd_pr__pfet_01v8 ad=0.1197 pd=1.41 as=0.1197 ps=1.41 w=0.42 l=0.15
X130 a_623_11916.t2 a_576_11820.t3 VSS.t67 VSS.t1 sky130_fd_pr__nfet_01v8 ad=0.3591 pd=3.09 as=0.3591 ps=3.09 w=1.26 l=0.15
X131 BLB.t29 WLOFF.t58 a_576_53220.t2 VSS.t61 sky130_fd_pr__nfet_01v8 ad=0.171 pd=1.77 as=0.171 ps=1.77 w=0.6 l=0.15
X132 a_576_29820.t0 a_623_29916.t3 VSS.t54 VSS.t3 sky130_fd_pr__nfet_01v8 ad=0.3591 pd=3.09 as=0.3591 ps=3.09 w=1.26 l=0.15
X133 a_576_26220.t1 a_623_26316.t4 VDD.t95 VDD.t94 sky130_fd_pr__pfet_01v8 ad=0.1197 pd=1.41 as=0.1197 ps=1.41 w=0.42 l=0.15
X134 a_623_4716.t1 a_576_4620.t3 VSS.t36 VSS.t1 sky130_fd_pr__nfet_01v8 ad=0.3591 pd=3.09 as=0.3591 ps=3.09 w=1.26 l=0.15
X135 BL.t26 WLOFF.t9 a_623_8316.t2 VSS.t60 sky130_fd_pr__nfet_01v8 ad=0.171 pd=1.77 as=0.171 ps=1.77 w=0.6 l=0.15
X136 a_623_44316.t1 a_576_44220.t4 VDD.t19 VDD.t18 sky130_fd_pr__pfet_01v8 ad=0.1197 pd=1.41 as=0.1197 ps=1.41 w=0.42 l=0.15
X137 a_623_2916.t2 a_576_2820.t4 VDD.t136 VDD.t135 sky130_fd_pr__pfet_01v8 ad=0.1197 pd=1.41 as=0.1197 ps=1.41 w=0.42 l=0.15
X138 a_576_49620.t1 a_623_49716.t4 VDD.t69 VDD.t68 sky130_fd_pr__pfet_01v8 ad=0.1197 pd=1.41 as=0.1197 ps=1.41 w=0.42 l=0.15
X139 a_623_55116.t1 a_576_55020.t3 VSS.t55 VSS.t1 sky130_fd_pr__nfet_01v8 ad=0.3591 pd=3.09 as=0.3591 ps=3.09 w=1.26 l=0.15
X140 BLB.t8 WLOFF.t36 a_576_33420.t2 VSS.t61 sky130_fd_pr__nfet_01v8 ad=0.171 pd=1.77 as=0.171 ps=1.77 w=0.6 l=0.15
X141 a_623_24516.t0 a_576_24420.t4 VDD.t17 VDD.t16 sky130_fd_pr__pfet_01v8 ad=0.1197 pd=1.41 as=0.1197 ps=1.41 w=0.42 l=0.15
X142 BLB.t13 WLOFF.t62 a_576_56820.t2 VSS.t61 sky130_fd_pr__nfet_01v8 ad=0.171 pd=1.77 as=0.171 ps=1.77 w=0.6 l=0.15
X143 a_576_29820.t1 a_623_29916.t4 VDD.t103 VDD.t102 sky130_fd_pr__pfet_01v8 ad=0.1197 pd=1.41 as=0.1197 ps=1.41 w=0.42 l=0.15
X144 a_576_6420.t1 a_623_6516.t4 VDD.t1 VDD.t0 sky130_fd_pr__pfet_01v8 ad=0.1197 pd=1.41 as=0.1197 ps=1.41 w=0.42 l=0.15
X145 a_576_51420.t0 a_623_51516.t3 VSS.t21 VSS.t3 sky130_fd_pr__nfet_01v8 ad=0.3591 pd=3.09 as=0.3591 ps=3.09 w=1.26 l=0.15
X146 a_623_47916.t1 a_576_47820.t4 VDD.t71 VDD.t70 sky130_fd_pr__pfet_01v8 ad=0.1197 pd=1.41 as=0.1197 ps=1.41 w=0.42 l=0.15
X147 a_623_35316.t2 a_576_35220.t3 VSS.t72 VSS.t1 sky130_fd_pr__nfet_01v8 ad=0.3591 pd=3.09 as=0.3591 ps=3.09 w=1.26 l=0.15
X148 BLB.t6 WLOFF.t14 a_576_13620.t2 VSS.t61 sky130_fd_pr__nfet_01v8 ad=0.171 pd=1.77 as=0.171 ps=1.77 w=0.6 l=0.15
X149 BL.t8 WLOFF.t47 a_623_42516.t2 VSS.t60 sky130_fd_pr__nfet_01v8 ad=0.171 pd=1.77 as=0.171 ps=1.77 w=0.6 l=0.15
X150 BLB.t9 WLOFF.t40 a_576_37020.t2 VSS.t61 sky130_fd_pr__nfet_01v8 ad=0.171 pd=1.77 as=0.171 ps=1.77 w=0.6 l=0.15
X151 a_3465_n13274.t0 DATA.t0 BLB.t34 VSS.t71 sky130_fd_pr__nfet_01v8 ad=1.4616 pd=10.66 as=1.4616 ps=10.66 w=5.04 l=0.15
X152 BLB.t20 WLOFF.t2 a_576_2820.t0 VSS.t61 sky130_fd_pr__nfet_01v8 ad=0.171 pd=1.77 as=0.171 ps=1.77 w=0.6 l=0.15
X153 a_623_15516.t0 a_576_15420.t3 VSS.t7 VSS.t1 sky130_fd_pr__nfet_01v8 ad=0.3591 pd=3.09 as=0.3591 ps=3.09 w=1.26 l=0.15
X154 a_576_31620.t0 a_623_31716.t3 VSS.t47 VSS.t3 sky130_fd_pr__nfet_01v8 ad=0.3591 pd=3.09 as=0.3591 ps=3.09 w=1.26 l=0.15
X155 BL.t18 WLOFF.t25 a_623_22716.t2 VSS.t60 sky130_fd_pr__nfet_01v8 ad=0.171 pd=1.77 as=0.171 ps=1.77 w=0.6 l=0.15
X156 a_623_38916.t0 a_576_38820.t3 VSS.t31 VSS.t1 sky130_fd_pr__nfet_01v8 ad=0.3591 pd=3.09 as=0.3591 ps=3.09 w=1.26 l=0.15
X157 a_576_55020.t0 a_623_55116.t3 VSS.t40 VSS.t3 sky130_fd_pr__nfet_01v8 ad=0.3591 pd=3.09 as=0.3591 ps=3.09 w=1.26 l=0.15
X158 a_576_51420.t1 a_623_51516.t4 VDD.t73 VDD.t72 sky130_fd_pr__pfet_01v8 ad=0.1197 pd=1.41 as=0.1197 ps=1.41 w=0.42 l=0.15
X159 BL.t9 WLOFF.t51 a_623_46116.t1 VSS.t60 sky130_fd_pr__nfet_01v8 ad=0.171 pd=1.77 as=0.171 ps=1.77 w=0.6 l=0.15
X160 a_576_2820.t1 a_623_2916.t3 VSS.t15 VSS.t3 sky130_fd_pr__nfet_01v8 ad=0.3591 pd=3.09 as=0.3591 ps=3.09 w=1.26 l=0.15
X161 a_623_8316.t0 a_576_8220.t3 VSS.t2 VSS.t1 sky130_fd_pr__nfet_01v8 ad=0.3591 pd=3.09 as=0.3591 ps=3.09 w=1.26 l=0.15
X162 a_623_6516.t1 a_576_6420.t4 VDD.t45 VDD.t44 sky130_fd_pr__pfet_01v8 ad=0.1197 pd=1.41 as=0.1197 ps=1.41 w=0.42 l=0.15
X163 a_576_11820.t0 a_623_11916.t3 VSS.t50 VSS.t3 sky130_fd_pr__nfet_01v8 ad=0.3591 pd=3.09 as=0.3591 ps=3.09 w=1.26 l=0.15
X164 VDD.t132 a_677_n8854.t2 a_3077_n9274.t0 VDD.t131 sky130_fd_pr__pfet_01v8 ad=1.4616 pd=10.66 as=1.4616 ps=10.66 w=5.04 l=0.15
X165 a_576_31620.t1 a_623_31716.t4 VDD.t119 VDD.t118 sky130_fd_pr__pfet_01v8 ad=0.1197 pd=1.41 as=0.1197 ps=1.41 w=0.42 l=0.15
X166 a_623_28116.t1 a_576_28020.t4 VDD.t115 VDD.t114 sky130_fd_pr__pfet_01v8 ad=0.1197 pd=1.41 as=0.1197 ps=1.41 w=0.42 l=0.15
X167 BLB.t31 WLOFF.t18 a_576_17220.t2 VSS.t61 sky130_fd_pr__nfet_01v8 ad=0.171 pd=1.77 as=0.171 ps=1.77 w=0.6 l=0.15
X168 a_576_11820.t1 a_623_11916.t4 VDD.t47 VDD.t46 sky130_fd_pr__pfet_01v8 ad=0.1197 pd=1.41 as=0.1197 ps=1.41 w=0.42 l=0.15
X169 BLB.t22 WLOFF.t6 a_576_6420.t2 VSS.t61 sky130_fd_pr__nfet_01v8 ad=0.171 pd=1.77 as=0.171 ps=1.77 w=0.6 l=0.15
X170 a_623_40716.t0 a_576_40620.t3 VSS.t41 VSS.t1 sky130_fd_pr__nfet_01v8 ad=0.3591 pd=3.09 as=0.3591 ps=3.09 w=1.26 l=0.15
X171 sense_amp_scale1p5_flat_0.SA_OUT.t1 SCLK.t2 BL.t31 VDD.t125 sky130_fd_pr__pfet_01v8 ad=0.58 pd=4.58 as=0.58 ps=4.58 w=2 l=0.15
X172 a_623_19116.t1 a_576_19020.t3 VSS.t30 VSS.t1 sky130_fd_pr__nfet_01v8 ad=0.3591 pd=3.09 as=0.3591 ps=3.09 w=1.26 l=0.15
X173 a_576_35220.t0 a_623_35316.t3 VSS.t59 VSS.t3 sky130_fd_pr__nfet_01v8 ad=0.3591 pd=3.09 as=0.3591 ps=3.09 w=1.26 l=0.15
X174 BL.t25 WLOFF.t29 a_623_26316.t2 VSS.t60 sky130_fd_pr__nfet_01v8 ad=0.171 pd=1.77 as=0.171 ps=1.77 w=0.6 l=0.15
X175 a_576_55020.t1 a_623_55116.t4 VDD.t87 VDD.t86 sky130_fd_pr__pfet_01v8 ad=0.1197 pd=1.41 as=0.1197 ps=1.41 w=0.42 l=0.15
X176 BL.t3 WLOFF.t55 a_623_49716.t2 VSS.t60 sky130_fd_pr__nfet_01v8 ad=0.171 pd=1.77 as=0.171 ps=1.77 w=0.6 l=0.15
X177 a_576_6420.t0 a_623_6516.t3 VSS.t12 VSS.t3 sky130_fd_pr__nfet_01v8 ad=0.3591 pd=3.09 as=0.3591 ps=3.09 w=1.26 l=0.15
X178 BLB.t18 WLOFF.t10 a_576_10020.t2 VSS.t61 sky130_fd_pr__nfet_01v8 ad=0.171 pd=1.77 as=0.171 ps=1.77 w=0.6 l=0.15
X179 a_576_15420.t0 a_623_15516.t3 VSS.t37 VSS.t3 sky130_fd_pr__nfet_01v8 ad=0.3591 pd=3.09 as=0.3591 ps=3.09 w=1.26 l=0.15
X180 a_623_20916.t0 a_576_20820.t3 VSS.t9 VSS.t1 sky130_fd_pr__nfet_01v8 ad=0.3591 pd=3.09 as=0.3591 ps=3.09 w=1.26 l=0.15
X181 a_576_38820.t0 a_623_38916.t3 VSS.t53 VSS.t3 sky130_fd_pr__nfet_01v8 ad=0.3591 pd=3.09 as=0.3591 ps=3.09 w=1.26 l=0.15
X182 a_576_35220.t1 a_623_35316.t4 VDD.t25 VDD.t24 sky130_fd_pr__pfet_01v8 ad=0.1197 pd=1.41 as=0.1197 ps=1.41 w=0.42 l=0.15
X183 a_1065_n6268.t0 sense_amp_scale1p5_flat_0.SA_OUTB.t3 sense_amp_scale1p5_flat_0.SA_OUT.t0 VSS.t0 sky130_fd_pr__nfet_01v8 ad=0.2842 pd=2.54 as=0.2842 ps=2.54 w=0.98 l=0.15
X184 a_623_53316.t1 a_576_53220.t4 VDD.t85 VDD.t84 sky130_fd_pr__pfet_01v8 ad=0.1197 pd=1.41 as=0.1197 ps=1.41 w=0.42 l=0.15
X185 BL.t0 WLOFF.t33 a_623_29916.t2 VSS.t60 sky130_fd_pr__nfet_01v8 ad=0.171 pd=1.77 as=0.171 ps=1.77 w=0.6 l=0.15
X186 BLB.t17 WLOFF.t46 a_576_42420.t2 VSS.t61 sky130_fd_pr__nfet_01v8 ad=0.171 pd=1.77 as=0.171 ps=1.77 w=0.6 l=0.15
X187 a_576_10020.t0 a_623_10116.t3 VSS.t14 VSS.t3 sky130_fd_pr__nfet_01v8 ad=0.3591 pd=3.09 as=0.3591 ps=3.09 w=1.26 l=0.15
X188 a_623_10116.t0 a_576_10020.t4 VDD.t51 VDD.t50 sky130_fd_pr__pfet_01v8 ad=0.1197 pd=1.41 as=0.1197 ps=1.41 w=0.42 l=0.15
X189 a_576_19020.t0 a_623_19116.t3 VSS.t51 VSS.t3 sky130_fd_pr__nfet_01v8 ad=0.3591 pd=3.09 as=0.3591 ps=3.09 w=1.26 l=0.15
X190 a_576_15420.t1 a_623_15516.t4 VDD.t11 VDD.t10 sky130_fd_pr__pfet_01v8 ad=0.1197 pd=1.41 as=0.1197 ps=1.41 w=0.42 l=0.15
X191 a_623_33516.t2 a_576_33420.t4 VDD.t139 VDD.t138 sky130_fd_pr__pfet_01v8 ad=0.1197 pd=1.41 as=0.1197 ps=1.41 w=0.42 l=0.15
X192 a_623_44316.t0 a_576_44220.t3 VSS.t8 VSS.t1 sky130_fd_pr__nfet_01v8 ad=0.3591 pd=3.09 as=0.3591 ps=3.09 w=1.26 l=0.15
X193 a_576_38820.t1 a_623_38916.t4 VDD.t99 VDD.t98 sky130_fd_pr__pfet_01v8 ad=0.1197 pd=1.41 as=0.1197 ps=1.41 w=0.42 l=0.15
X194 BLB.t1 WLOFF.t24 a_576_22620.t2 VSS.t61 sky130_fd_pr__nfet_01v8 ad=0.171 pd=1.77 as=0.171 ps=1.77 w=0.6 l=0.15
X195 a_623_56916.t0 a_576_56820.t4 VDD.t93 VDD.t92 sky130_fd_pr__pfet_01v8 ad=0.1197 pd=1.41 as=0.1197 ps=1.41 w=0.42 l=0.15
X196 BL.t4 WLOFF.t57 a_623_51516.t1 VSS.t60 sky130_fd_pr__nfet_01v8 ad=0.171 pd=1.77 as=0.171 ps=1.77 w=0.6 l=0.15
X197 BLB.t12 WLOFF.t50 a_576_46020.t2 VSS.t61 sky130_fd_pr__nfet_01v8 ad=0.171 pd=1.77 as=0.171 ps=1.77 w=0.6 l=0.15
X198 a_623_13716.t1 a_576_13620.t4 VDD.t53 VDD.t52 sky130_fd_pr__pfet_01v8 ad=0.1197 pd=1.41 as=0.1197 ps=1.41 w=0.42 l=0.15
X199 a_576_40620.t0 a_623_40716.t3 VSS.t32 VSS.t3 sky130_fd_pr__nfet_01v8 ad=0.3591 pd=3.09 as=0.3591 ps=3.09 w=1.26 l=0.15
X200 a_623_24516.t1 a_576_24420.t3 VSS.t13 VSS.t1 sky130_fd_pr__nfet_01v8 ad=0.3591 pd=3.09 as=0.3591 ps=3.09 w=1.26 l=0.15
X201 BL.t13 WLOFF.t35 a_623_31716.t2 VSS.t60 sky130_fd_pr__nfet_01v8 ad=0.171 pd=1.77 as=0.171 ps=1.77 w=0.6 l=0.15
X202 a_623_47916.t0 a_576_47820.t3 VSS.t26 VSS.t1 sky130_fd_pr__nfet_01v8 ad=0.3591 pd=3.09 as=0.3591 ps=3.09 w=1.26 l=0.15
X203 VDD.t145 PRECH.t2 BL.t35 VDD.t144 sky130_fd_pr__pfet_01v8 ad=0.7308 pd=5.62 as=0.7308 ps=5.62 w=2.52 l=0.15
X204 BL.t34 WLOFF.t61 a_623_55116.t2 VSS.t60 sky130_fd_pr__nfet_01v8 ad=0.171 pd=1.77 as=0.171 ps=1.77 w=0.6 l=0.15
X205 VSS.t79 WE.t0 a_3465_n13274.t1 VSS.t78 sky130_fd_pr__nfet_01v8 ad=1.4616 pd=10.66 as=1.4616 ps=10.66 w=5.04 l=0.15
X206 a_576_20820.t0 a_623_20916.t3 VSS.t18 VSS.t3 sky130_fd_pr__nfet_01v8 ad=0.3591 pd=3.09 as=0.3591 ps=3.09 w=1.26 l=0.15
X207 BLB.t27 SCLK.t1 sense_amp_scale1p5_flat_0.SA_OUTB.t2 VDD.t126 sky130_fd_pr__pfet_01v8 ad=0.58 pd=4.58 as=0.58 ps=4.58 w=2 l=0.15
X208 BL.t17 WLOFF.t13 a_623_11916.t1 VSS.t60 sky130_fd_pr__nfet_01v8 ad=0.171 pd=1.77 as=0.171 ps=1.77 w=0.6 l=0.15
X209 a_576_40620.t1 a_623_40716.t4 VDD.t63 VDD.t62 sky130_fd_pr__pfet_01v8 ad=0.1197 pd=1.41 as=0.1197 ps=1.41 w=0.42 l=0.15
X210 a_576_19020.t1 a_623_19116.t4 VDD.t55 VDD.t54 sky130_fd_pr__pfet_01v8 ad=0.1197 pd=1.41 as=0.1197 ps=1.41 w=0.42 l=0.15
X211 a_623_37116.t0 a_576_37020.t4 VDD.t57 VDD.t56 sky130_fd_pr__pfet_01v8 ad=0.1197 pd=1.41 as=0.1197 ps=1.41 w=0.42 l=0.15
C0 sense_amp_scale1p5_flat_0.SA_OUTB BL 0.00731f
C1 WE BLB 0.36364f
C2 VDD BL 7.9432f
C3 DATA_B WE 0.18688f
C4 WLOFF BL 70.9547f
C5 BLB BL 83.0447f
C6 DATA_B BL 1.80824f
C7 DATA WE 0.1964f
C8 DATA BL 2.29132f
C9 PRECH BL 0.4032f
C10 SCLK sense_amp_scale1p5_flat_0.SA_OUT 1.26593f
C11 sense_amp_scale1p5_flat_0.SA_OUTB VDD 1.35564f
C12 BLB sense_amp_scale1p5_flat_0.SA_OUTB 0.4007f
C13 WLOFF VDD 19.7337f
C14 BLB VDD 57.2982f
C15 DATA_B VDD 0.44601f
C16 SCLK BL 0.31989f
C17 sense_amp_scale1p5_flat_0.SA_OUT BL 0.33336f
C18 WLOFF BLB 13.857f
C19 DATA_B BLB 0.13653f
C20 DATA VDD 0.41574f
C21 WE BL 0.4088f
C22 DATA BLB 1.80944f
C23 DATA_B DATA 2.23983f
C24 PRECH VDD 2.59971f
C25 WLOFF PRECH 0
C26 PRECH BLB 0.16904f
C27 SCLK sense_amp_scale1p5_flat_0.SA_OUTB 1.37996f
C28 sense_amp_scale1p5_flat_0.SA_OUTB sense_amp_scale1p5_flat_0.SA_OUT 1.9559f
C29 SCLK VDD 0.65568f
C30 sense_amp_scale1p5_flat_0.SA_OUT VDD 1.365f
C31 SCLK BLB 0.35612f
C32 BLB sense_amp_scale1p5_flat_0.SA_OUT 0.1867f
C33 WE VDD 1.02587f
R0 DATA.n0 DATA.t1 1056.85
R1 DATA.n0 DATA.t0 1043.19
R2 DATA.n1 DATA 3.42812
R3 DATA DATA.n1 1.56325
R4 DATA.n1 DATA.n0 0.971833
R5 DATA_B.n0 DATA_B.t1 1056.45
R6 DATA_B.n1 DATA_B.t0 1043.5
R7 DATA_B.n0 DATA_B 3.42812
R8 DATA_B DATA_B.n1 1.29692
R9 DATA_B.n1 DATA_B.n0 0.071
R10 WE.n0 WE.t0 1045.38
R11 WE.n0 WE.t1 1044.13
R12 WE.n3 WE.t3 379.844
R13 WE.n2 WE.t2 370.202
R14 WE.n1 WE 3.42812
R15 WE.n1 WE.n0 0.736833
R16 WE.n2 WE.n1 0.501833
R17 WE WE.n3 0.43525
R18 WE.n3 WE.n2 0.2355
R19 SCLK.n0 SCLK.t1 568.048
R20 SCLK.n1 SCLK.t2 567.812
R21 SCLK.n0 SCLK.t0 387.146
R22 SCLK.n2 SCLK 3.42812
R23 SCLK SCLK.n2 1.17158
R24 SCLK.n2 SCLK.n1 0.501833
R25 SCLK.n1 SCLK.n0 0.392167
R26 PRECH.n0 PRECH.t0 648.881
R27 PRECH.n2 PRECH.t2 648.38
R28 PRECH.n1 PRECH.t1 648.38
R29 PRECH.n0 PRECH 3.42812
R30 PRECH.n2 PRECH.n1 0.627167
R31 PRECH PRECH.n2 0.43525
R32 PRECH.n1 PRECH.n0 0.110167
R33 BLB.n1 BLB.t13 233.649
R34 BLB.n3 BLB.t24 233.649
R35 BLB.n5 BLB.t29 233.649
R36 BLB.n7 BLB.t14 233.649
R37 BLB.n9 BLB.t15 233.649
R38 BLB.n11 BLB.t11 233.649
R39 BLB.n13 BLB.t12 233.649
R40 BLB.n15 BLB.t25 233.649
R41 BLB.n17 BLB.t17 233.649
R42 BLB.n19 BLB.t19 233.649
R43 BLB.n21 BLB.t10 233.649
R44 BLB.n23 BLB.t9 233.649
R45 BLB.n25 BLB.t26 233.649
R46 BLB.n27 BLB.t8 233.649
R47 BLB.n29 BLB.t4 233.649
R48 BLB.n31 BLB.t3 233.649
R49 BLB.n33 BLB.t2 233.649
R50 BLB.n35 BLB.t32 233.649
R51 BLB.n37 BLB.t30 233.649
R52 BLB.n39 BLB.t1 233.649
R53 BLB.n41 BLB.t5 233.649
R54 BLB.n43 BLB.t21 233.649
R55 BLB.n45 BLB.t31 233.649
R56 BLB.n47 BLB.t7 233.649
R57 BLB.n49 BLB.t6 233.649
R58 BLB.n51 BLB.t23 233.649
R59 BLB.n53 BLB.t18 233.649
R60 BLB.n55 BLB.t0 233.649
R61 BLB.n57 BLB.t22 233.649
R62 BLB.n59 BLB.t16 233.649
R63 BLB.n61 BLB.t20 233.649
R64 BLB.n63 BLB.t28 233.649
R65 BLB.n68 BLB.t27 124.585
R66 BLB.n65 BLB.t36 106.474
R67 BLB.n65 BLB.t35 105.653
R68 BLB.n0 BLB.t33 59.5904
R69 BLB.n0 BLB.t34 30.7037
R70 BLB.n70 BLB.n69 7.1705
R71 BLB.n69 BLB.n68 3.4105
R72 BLB.n67 BLB.n66 3.4105
R73 BLB.n64 BLB.n63 3.4105
R74 BLB.n62 BLB.n61 3.4105
R75 BLB.n60 BLB.n59 3.4105
R76 BLB.n58 BLB.n57 3.4105
R77 BLB.n56 BLB.n55 3.4105
R78 BLB.n54 BLB.n53 3.4105
R79 BLB.n52 BLB.n51 3.4105
R80 BLB.n50 BLB.n49 3.4105
R81 BLB.n48 BLB.n47 3.4105
R82 BLB.n46 BLB.n45 3.4105
R83 BLB.n44 BLB.n43 3.4105
R84 BLB.n42 BLB.n41 3.4105
R85 BLB.n40 BLB.n39 3.4105
R86 BLB.n38 BLB.n37 3.4105
R87 BLB.n36 BLB.n35 3.4105
R88 BLB.n34 BLB.n33 3.4105
R89 BLB.n32 BLB.n31 3.4105
R90 BLB.n30 BLB.n29 3.4105
R91 BLB.n28 BLB.n27 3.4105
R92 BLB.n26 BLB.n25 3.4105
R93 BLB.n24 BLB.n23 3.4105
R94 BLB.n22 BLB.n21 3.4105
R95 BLB.n20 BLB.n19 3.4105
R96 BLB.n18 BLB.n17 3.4105
R97 BLB.n16 BLB.n15 3.4105
R98 BLB.n14 BLB.n13 3.4105
R99 BLB.n12 BLB.n11 3.4105
R100 BLB.n10 BLB.n9 3.4105
R101 BLB.n8 BLB.n7 3.4105
R102 BLB.n6 BLB.n5 3.4105
R103 BLB.n4 BLB.n3 3.4105
R104 BLB.n2 BLB.n1 3.4105
R105 BLB.n70 BLB.n0 2.1907
R106 BLB.n67 BLB.n64 1.25775
R107 BLB.n4 BLB.n2 1.058
R108 BLB.n6 BLB.n4 1.058
R109 BLB.n8 BLB.n6 1.058
R110 BLB.n10 BLB.n8 1.058
R111 BLB.n12 BLB.n10 1.058
R112 BLB.n14 BLB.n12 1.058
R113 BLB.n16 BLB.n14 1.058
R114 BLB.n18 BLB.n16 1.058
R115 BLB.n20 BLB.n18 1.058
R116 BLB.n22 BLB.n20 1.058
R117 BLB.n24 BLB.n22 1.058
R118 BLB.n26 BLB.n24 1.058
R119 BLB.n28 BLB.n26 1.058
R120 BLB.n30 BLB.n28 1.058
R121 BLB.n32 BLB.n30 1.058
R122 BLB.n34 BLB.n32 1.058
R123 BLB.n36 BLB.n34 1.058
R124 BLB.n38 BLB.n36 1.058
R125 BLB.n40 BLB.n38 1.058
R126 BLB.n42 BLB.n40 1.058
R127 BLB.n44 BLB.n42 1.058
R128 BLB.n46 BLB.n44 1.058
R129 BLB.n48 BLB.n46 1.058
R130 BLB.n50 BLB.n48 1.058
R131 BLB.n52 BLB.n50 1.058
R132 BLB.n54 BLB.n52 1.058
R133 BLB.n56 BLB.n54 1.058
R134 BLB.n58 BLB.n56 1.058
R135 BLB.n60 BLB.n58 1.058
R136 BLB.n62 BLB.n60 1.058
R137 BLB.n64 BLB.n62 1.058
R138 BLB.n69 BLB.n67 1.05213
R139 BLB.n2 BLB 1.04625
R140 BLB.n66 BLB.n65 0.702367
R141 BLB.n1 BLB 0.24725
R142 BLB.n3 BLB 0.24725
R143 BLB.n5 BLB 0.24725
R144 BLB.n7 BLB 0.24725
R145 BLB.n9 BLB 0.24725
R146 BLB.n11 BLB 0.24725
R147 BLB.n13 BLB 0.24725
R148 BLB.n15 BLB 0.24725
R149 BLB.n17 BLB 0.24725
R150 BLB.n19 BLB 0.24725
R151 BLB.n21 BLB 0.24725
R152 BLB.n23 BLB 0.24725
R153 BLB.n25 BLB 0.24725
R154 BLB.n27 BLB 0.24725
R155 BLB.n29 BLB 0.24725
R156 BLB.n31 BLB 0.24725
R157 BLB.n33 BLB 0.24725
R158 BLB.n35 BLB 0.24725
R159 BLB.n37 BLB 0.24725
R160 BLB.n39 BLB 0.24725
R161 BLB.n41 BLB 0.24725
R162 BLB.n43 BLB 0.24725
R163 BLB.n45 BLB 0.24725
R164 BLB.n47 BLB 0.24725
R165 BLB.n49 BLB 0.24725
R166 BLB.n51 BLB 0.24725
R167 BLB.n53 BLB 0.24725
R168 BLB.n55 BLB 0.24725
R169 BLB.n57 BLB 0.24725
R170 BLB.n59 BLB 0.24725
R171 BLB.n61 BLB 0.24725
R172 BLB.n63 BLB 0.24725
R173 BLB.n66 BLB 0.24725
R174 BLB.n68 BLB 0.24725
R175 BLB BLB.n70 0.24725
R176 BL.n1 BL.t1 233.452
R177 BL.n3 BL.t34 233.452
R178 BL.n5 BL.t14 233.452
R179 BL.n7 BL.t4 233.452
R180 BL.n9 BL.t3 233.452
R181 BL.n11 BL.t12 233.452
R182 BL.n13 BL.t9 233.452
R183 BL.n15 BL.t10 233.452
R184 BL.n17 BL.t8 233.452
R185 BL.n19 BL.t27 233.452
R186 BL.n21 BL.t5 233.452
R187 BL.n23 BL.t33 233.452
R188 BL.n25 BL.t7 233.452
R189 BL.n27 BL.t32 233.452
R190 BL.n29 BL.t13 233.452
R191 BL.n31 BL.t0 233.452
R192 BL.n33 BL.t6 233.452
R193 BL.n35 BL.t25 233.452
R194 BL.n37 BL.t21 233.452
R195 BL.n39 BL.t18 233.452
R196 BL.n41 BL.t2 233.452
R197 BL.n43 BL.t15 233.452
R198 BL.n45 BL.t11 233.452
R199 BL.n47 BL.t24 233.452
R200 BL.n49 BL.t19 233.452
R201 BL.n51 BL.t17 233.452
R202 BL.n53 BL.t22 233.452
R203 BL.n55 BL.t26 233.452
R204 BL.n57 BL.t28 233.452
R205 BL.n59 BL.t16 233.452
R206 BL.n61 BL.t20 233.452
R207 BL.n63 BL.t23 233.452
R208 BL.n68 BL.t31 124.312
R209 BL.n65 BL.t36 106.594
R210 BL.n65 BL.t35 105.341
R211 BL.n0 BL.t30 59.2779
R212 BL.n0 BL.t29 31.0162
R213 BL.n70 BL.n69 7.1705
R214 BL.n69 BL.n68 3.4105
R215 BL.n67 BL.n66 3.4105
R216 BL.n64 BL.n63 3.4105
R217 BL.n62 BL.n61 3.4105
R218 BL.n60 BL.n59 3.4105
R219 BL.n58 BL.n57 3.4105
R220 BL.n56 BL.n55 3.4105
R221 BL.n54 BL.n53 3.4105
R222 BL.n52 BL.n51 3.4105
R223 BL.n50 BL.n49 3.4105
R224 BL.n48 BL.n47 3.4105
R225 BL.n46 BL.n45 3.4105
R226 BL.n44 BL.n43 3.4105
R227 BL.n42 BL.n41 3.4105
R228 BL.n40 BL.n39 3.4105
R229 BL.n38 BL.n37 3.4105
R230 BL.n36 BL.n35 3.4105
R231 BL.n34 BL.n33 3.4105
R232 BL.n32 BL.n31 3.4105
R233 BL.n30 BL.n29 3.4105
R234 BL.n28 BL.n27 3.4105
R235 BL.n26 BL.n25 3.4105
R236 BL.n24 BL.n23 3.4105
R237 BL.n22 BL.n21 3.4105
R238 BL.n20 BL.n19 3.4105
R239 BL.n18 BL.n17 3.4105
R240 BL.n16 BL.n15 3.4105
R241 BL.n14 BL.n13 3.4105
R242 BL.n12 BL.n11 3.4105
R243 BL.n10 BL.n9 3.4105
R244 BL.n8 BL.n7 3.4105
R245 BL.n6 BL.n5 3.4105
R246 BL.n4 BL.n3 3.4105
R247 BL.n2 BL.n1 3.4105
R248 BL.n67 BL.n64 1.24012
R249 BL.n70 BL.n0 1.17237
R250 BL.n4 BL.n2 1.058
R251 BL.n6 BL.n4 1.058
R252 BL.n8 BL.n6 1.058
R253 BL.n10 BL.n8 1.058
R254 BL.n12 BL.n10 1.058
R255 BL.n14 BL.n12 1.058
R256 BL.n16 BL.n14 1.058
R257 BL.n18 BL.n16 1.058
R258 BL.n20 BL.n18 1.058
R259 BL.n22 BL.n20 1.058
R260 BL.n24 BL.n22 1.058
R261 BL.n26 BL.n24 1.058
R262 BL.n28 BL.n26 1.058
R263 BL.n30 BL.n28 1.058
R264 BL.n32 BL.n30 1.058
R265 BL.n34 BL.n32 1.058
R266 BL.n36 BL.n34 1.058
R267 BL.n38 BL.n36 1.058
R268 BL.n40 BL.n38 1.058
R269 BL.n42 BL.n40 1.058
R270 BL.n44 BL.n42 1.058
R271 BL.n46 BL.n44 1.058
R272 BL.n48 BL.n46 1.058
R273 BL.n50 BL.n48 1.058
R274 BL.n52 BL.n50 1.058
R275 BL.n54 BL.n52 1.058
R276 BL.n56 BL.n54 1.058
R277 BL.n58 BL.n56 1.058
R278 BL.n60 BL.n58 1.058
R279 BL.n62 BL.n60 1.058
R280 BL.n64 BL.n62 1.058
R281 BL.n69 BL.n67 1.05213
R282 BL.n2 BL 0.97575
R283 BL.n66 BL.n65 0.3107
R284 BL.n1 BL 0.0151875
R285 BL.n3 BL 0.0151875
R286 BL.n5 BL 0.0151875
R287 BL.n7 BL 0.0151875
R288 BL.n9 BL 0.0151875
R289 BL.n11 BL 0.0151875
R290 BL.n13 BL 0.0151875
R291 BL.n15 BL 0.0151875
R292 BL.n17 BL 0.0151875
R293 BL.n19 BL 0.0151875
R294 BL.n21 BL 0.0151875
R295 BL.n23 BL 0.0151875
R296 BL.n25 BL 0.0151875
R297 BL.n27 BL 0.0151875
R298 BL.n29 BL 0.0151875
R299 BL.n31 BL 0.0151875
R300 BL.n33 BL 0.0151875
R301 BL.n35 BL 0.0151875
R302 BL.n37 BL 0.0151875
R303 BL.n39 BL 0.0151875
R304 BL.n41 BL 0.0151875
R305 BL.n43 BL 0.0151875
R306 BL.n45 BL 0.0151875
R307 BL.n47 BL 0.0151875
R308 BL.n49 BL 0.0151875
R309 BL.n51 BL 0.0151875
R310 BL.n53 BL 0.0151875
R311 BL.n55 BL 0.0151875
R312 BL.n57 BL 0.0151875
R313 BL.n59 BL 0.0151875
R314 BL.n61 BL 0.0151875
R315 BL.n63 BL 0.0151875
R316 BL.n66 BL 0.0151875
R317 BL.n68 BL 0.0151875
R318 BL BL.n70 0.0151875
R319 WLOFF.n1 WLOFF.t62 330.012
R320 WLOFF.n4 WLOFF.t60 330.012
R321 WLOFF.n7 WLOFF.t58 330.012
R322 WLOFF.n10 WLOFF.t56 330.012
R323 WLOFF.n13 WLOFF.t54 330.012
R324 WLOFF.n16 WLOFF.t52 330.012
R325 WLOFF.n19 WLOFF.t50 330.012
R326 WLOFF.n22 WLOFF.t48 330.012
R327 WLOFF.n25 WLOFF.t46 330.012
R328 WLOFF.n28 WLOFF.t44 330.012
R329 WLOFF.n31 WLOFF.t42 330.012
R330 WLOFF.n34 WLOFF.t40 330.012
R331 WLOFF.n37 WLOFF.t38 330.012
R332 WLOFF.n40 WLOFF.t36 330.012
R333 WLOFF.n43 WLOFF.t34 330.012
R334 WLOFF.n46 WLOFF.t32 330.012
R335 WLOFF.n49 WLOFF.t30 330.012
R336 WLOFF.n52 WLOFF.t28 330.012
R337 WLOFF.n55 WLOFF.t26 330.012
R338 WLOFF.n58 WLOFF.t24 330.012
R339 WLOFF.n61 WLOFF.t22 330.012
R340 WLOFF.n64 WLOFF.t20 330.012
R341 WLOFF.n67 WLOFF.t18 330.012
R342 WLOFF.n70 WLOFF.t16 330.012
R343 WLOFF.n73 WLOFF.t14 330.012
R344 WLOFF.n76 WLOFF.t12 330.012
R345 WLOFF.n79 WLOFF.t10 330.012
R346 WLOFF.n82 WLOFF.t8 330.012
R347 WLOFF.n85 WLOFF.t6 330.012
R348 WLOFF.n88 WLOFF.t4 330.012
R349 WLOFF.n91 WLOFF.t2 330.012
R350 WLOFF.n0 WLOFF.t0 330.012
R351 WLOFF.n1 WLOFF.t63 329.848
R352 WLOFF.n4 WLOFF.t61 329.848
R353 WLOFF.n7 WLOFF.t59 329.848
R354 WLOFF.n10 WLOFF.t57 329.848
R355 WLOFF.n13 WLOFF.t55 329.848
R356 WLOFF.n16 WLOFF.t53 329.848
R357 WLOFF.n19 WLOFF.t51 329.848
R358 WLOFF.n22 WLOFF.t49 329.848
R359 WLOFF.n25 WLOFF.t47 329.848
R360 WLOFF.n28 WLOFF.t45 329.848
R361 WLOFF.n31 WLOFF.t43 329.848
R362 WLOFF.n34 WLOFF.t41 329.848
R363 WLOFF.n37 WLOFF.t39 329.848
R364 WLOFF.n40 WLOFF.t37 329.848
R365 WLOFF.n43 WLOFF.t35 329.848
R366 WLOFF.n46 WLOFF.t33 329.848
R367 WLOFF.n49 WLOFF.t31 329.848
R368 WLOFF.n52 WLOFF.t29 329.848
R369 WLOFF.n55 WLOFF.t27 329.848
R370 WLOFF.n58 WLOFF.t25 329.848
R371 WLOFF.n61 WLOFF.t23 329.848
R372 WLOFF.n64 WLOFF.t21 329.848
R373 WLOFF.n67 WLOFF.t19 329.848
R374 WLOFF.n70 WLOFF.t17 329.848
R375 WLOFF.n73 WLOFF.t15 329.848
R376 WLOFF.n76 WLOFF.t13 329.848
R377 WLOFF.n79 WLOFF.t11 329.848
R378 WLOFF.n82 WLOFF.t9 329.848
R379 WLOFF.n85 WLOFF.t7 329.848
R380 WLOFF.n88 WLOFF.t5 329.848
R381 WLOFF.n91 WLOFF.t3 329.848
R382 WLOFF.n0 WLOFF.t1 329.848
R383 WLOFF.n94 WLOFF.n93 4.468
R384 WLOFF.n93 WLOFF.n92 3.4105
R385 WLOFF.n90 WLOFF.n89 3.4105
R386 WLOFF.n87 WLOFF.n86 3.4105
R387 WLOFF.n84 WLOFF.n83 3.4105
R388 WLOFF.n81 WLOFF.n80 3.4105
R389 WLOFF.n78 WLOFF.n77 3.4105
R390 WLOFF.n75 WLOFF.n74 3.4105
R391 WLOFF.n72 WLOFF.n71 3.4105
R392 WLOFF.n69 WLOFF.n68 3.4105
R393 WLOFF.n66 WLOFF.n65 3.4105
R394 WLOFF.n63 WLOFF.n62 3.4105
R395 WLOFF.n60 WLOFF.n59 3.4105
R396 WLOFF.n57 WLOFF.n56 3.4105
R397 WLOFF.n54 WLOFF.n53 3.4105
R398 WLOFF.n51 WLOFF.n50 3.4105
R399 WLOFF.n48 WLOFF.n47 3.4105
R400 WLOFF.n45 WLOFF.n44 3.4105
R401 WLOFF.n42 WLOFF.n41 3.4105
R402 WLOFF.n39 WLOFF.n38 3.4105
R403 WLOFF.n36 WLOFF.n35 3.4105
R404 WLOFF.n33 WLOFF.n32 3.4105
R405 WLOFF.n30 WLOFF.n29 3.4105
R406 WLOFF.n27 WLOFF.n26 3.4105
R407 WLOFF.n24 WLOFF.n23 3.4105
R408 WLOFF.n21 WLOFF.n20 3.4105
R409 WLOFF.n18 WLOFF.n17 3.4105
R410 WLOFF.n15 WLOFF.n14 3.4105
R411 WLOFF.n12 WLOFF.n11 3.4105
R412 WLOFF.n9 WLOFF.n8 3.4105
R413 WLOFF.n6 WLOFF.n5 3.4105
R414 WLOFF.n3 WLOFF.n2 3.4105
R415 WLOFF.n6 WLOFF.n3 1.058
R416 WLOFF.n9 WLOFF.n6 1.058
R417 WLOFF.n12 WLOFF.n9 1.058
R418 WLOFF.n15 WLOFF.n12 1.058
R419 WLOFF.n18 WLOFF.n15 1.058
R420 WLOFF.n21 WLOFF.n18 1.058
R421 WLOFF.n24 WLOFF.n21 1.058
R422 WLOFF.n27 WLOFF.n24 1.058
R423 WLOFF.n30 WLOFF.n27 1.058
R424 WLOFF.n33 WLOFF.n30 1.058
R425 WLOFF.n36 WLOFF.n33 1.058
R426 WLOFF.n39 WLOFF.n36 1.058
R427 WLOFF.n42 WLOFF.n39 1.058
R428 WLOFF.n45 WLOFF.n42 1.058
R429 WLOFF.n48 WLOFF.n45 1.058
R430 WLOFF.n51 WLOFF.n48 1.058
R431 WLOFF.n54 WLOFF.n51 1.058
R432 WLOFF.n57 WLOFF.n54 1.058
R433 WLOFF.n60 WLOFF.n57 1.058
R434 WLOFF.n63 WLOFF.n60 1.058
R435 WLOFF.n66 WLOFF.n63 1.058
R436 WLOFF.n69 WLOFF.n66 1.058
R437 WLOFF.n72 WLOFF.n69 1.058
R438 WLOFF.n75 WLOFF.n72 1.058
R439 WLOFF.n78 WLOFF.n75 1.058
R440 WLOFF.n81 WLOFF.n78 1.058
R441 WLOFF.n84 WLOFF.n81 1.058
R442 WLOFF.n87 WLOFF.n84 1.058
R443 WLOFF.n90 WLOFF.n87 1.058
R444 WLOFF.n93 WLOFF.n90 1.058
R445 WLOFF.n2 WLOFF 0.95225
R446 WLOFF.n5 WLOFF 0.95225
R447 WLOFF.n8 WLOFF 0.95225
R448 WLOFF.n11 WLOFF 0.95225
R449 WLOFF.n14 WLOFF 0.95225
R450 WLOFF.n17 WLOFF 0.95225
R451 WLOFF.n20 WLOFF 0.95225
R452 WLOFF.n23 WLOFF 0.95225
R453 WLOFF.n26 WLOFF 0.95225
R454 WLOFF.n29 WLOFF 0.95225
R455 WLOFF.n32 WLOFF 0.95225
R456 WLOFF.n35 WLOFF 0.95225
R457 WLOFF.n38 WLOFF 0.95225
R458 WLOFF.n41 WLOFF 0.95225
R459 WLOFF.n44 WLOFF 0.95225
R460 WLOFF.n47 WLOFF 0.95225
R461 WLOFF.n50 WLOFF 0.95225
R462 WLOFF.n53 WLOFF 0.95225
R463 WLOFF.n56 WLOFF 0.95225
R464 WLOFF.n59 WLOFF 0.95225
R465 WLOFF.n62 WLOFF 0.95225
R466 WLOFF.n65 WLOFF 0.95225
R467 WLOFF.n68 WLOFF 0.95225
R468 WLOFF.n71 WLOFF 0.95225
R469 WLOFF.n74 WLOFF 0.95225
R470 WLOFF.n77 WLOFF 0.95225
R471 WLOFF.n80 WLOFF 0.95225
R472 WLOFF.n83 WLOFF 0.95225
R473 WLOFF.n86 WLOFF 0.95225
R474 WLOFF.n89 WLOFF 0.95225
R475 WLOFF.n92 WLOFF 0.95225
R476 WLOFF WLOFF.n94 0.95225
R477 WLOFF.n3 WLOFF 0.90525
R478 WLOFF.n2 WLOFF.n1 0.5175
R479 WLOFF.n5 WLOFF.n4 0.5175
R480 WLOFF.n8 WLOFF.n7 0.5175
R481 WLOFF.n11 WLOFF.n10 0.5175
R482 WLOFF.n14 WLOFF.n13 0.5175
R483 WLOFF.n17 WLOFF.n16 0.5175
R484 WLOFF.n20 WLOFF.n19 0.5175
R485 WLOFF.n23 WLOFF.n22 0.5175
R486 WLOFF.n26 WLOFF.n25 0.5175
R487 WLOFF.n29 WLOFF.n28 0.5175
R488 WLOFF.n32 WLOFF.n31 0.5175
R489 WLOFF.n35 WLOFF.n34 0.5175
R490 WLOFF.n38 WLOFF.n37 0.5175
R491 WLOFF.n41 WLOFF.n40 0.5175
R492 WLOFF.n44 WLOFF.n43 0.5175
R493 WLOFF.n47 WLOFF.n46 0.5175
R494 WLOFF.n50 WLOFF.n49 0.5175
R495 WLOFF.n53 WLOFF.n52 0.5175
R496 WLOFF.n56 WLOFF.n55 0.5175
R497 WLOFF.n59 WLOFF.n58 0.5175
R498 WLOFF.n62 WLOFF.n61 0.5175
R499 WLOFF.n65 WLOFF.n64 0.5175
R500 WLOFF.n68 WLOFF.n67 0.5175
R501 WLOFF.n71 WLOFF.n70 0.5175
R502 WLOFF.n74 WLOFF.n73 0.5175
R503 WLOFF.n77 WLOFF.n76 0.5175
R504 WLOFF.n80 WLOFF.n79 0.5175
R505 WLOFF.n83 WLOFF.n82 0.5175
R506 WLOFF.n86 WLOFF.n85 0.5175
R507 WLOFF.n89 WLOFF.n88 0.5175
R508 WLOFF.n92 WLOFF.n91 0.5175
R509 WLOFF.n94 WLOFF.n0 0.5175
R510 VDD.n44 VDD.n43 2862.35
R511 VDD.n41 VDD.n39 2862.35
R512 VDD.n32 VDD.n31 2862.35
R513 VDD.n29 VDD.n27 2862.35
R514 VDD.n19 VDD.n18 2862.35
R515 VDD.n16 VDD.n14 2862.35
R516 VDD.n8 VDD.n7 2862.35
R517 VDD.n5 VDD.n3 2862.35
R518 VDD.n818 VDD.n812 1972.94
R519 VDD.n815 VDD.n813 1972.94
R520 VDD.n804 VDD.n798 1972.94
R521 VDD.n801 VDD.n799 1972.94
R522 VDD.n793 VDD.n787 1972.94
R523 VDD.n790 VDD.n788 1972.94
R524 VDD.n843 VDD.n842 1789.41
R525 VDD.n840 VDD.n838 1789.41
R526 VDD.n832 VDD.n831 1789.41
R527 VDD.n829 VDD.n827 1789.41
R528 VDD.n869 VDD.n868 1750.59
R529 VDD.n866 VDD.n864 1750.59
R530 VDD.n855 VDD.n854 1750.59
R531 VDD.n852 VDD.n850 1750.59
R532 VDD.n884 VDD.n883 1380
R533 VDD.n881 VDD.n879 1380
R534 VDD.n60 VDD.n52 1224.71
R535 VDD.n56 VDD.n53 1224.71
R536 VDD.n60 VDD.n53 1224.71
R537 VDD.n67 VDD.n49 1224.71
R538 VDD.n67 VDD.n50 1224.71
R539 VDD.n63 VDD.n50 1224.71
R540 VDD.n63 VDD.n49 1224.71
R541 VDD.n83 VDD.n75 1224.71
R542 VDD.n79 VDD.n76 1224.71
R543 VDD.n83 VDD.n76 1224.71
R544 VDD.n90 VDD.n72 1224.71
R545 VDD.n90 VDD.n73 1224.71
R546 VDD.n86 VDD.n73 1224.71
R547 VDD.n86 VDD.n72 1224.71
R548 VDD.n106 VDD.n98 1224.71
R549 VDD.n102 VDD.n99 1224.71
R550 VDD.n106 VDD.n99 1224.71
R551 VDD.n113 VDD.n95 1224.71
R552 VDD.n113 VDD.n96 1224.71
R553 VDD.n109 VDD.n96 1224.71
R554 VDD.n109 VDD.n95 1224.71
R555 VDD.n129 VDD.n121 1224.71
R556 VDD.n125 VDD.n122 1224.71
R557 VDD.n129 VDD.n122 1224.71
R558 VDD.n136 VDD.n118 1224.71
R559 VDD.n136 VDD.n119 1224.71
R560 VDD.n132 VDD.n119 1224.71
R561 VDD.n132 VDD.n118 1224.71
R562 VDD.n152 VDD.n144 1224.71
R563 VDD.n148 VDD.n145 1224.71
R564 VDD.n152 VDD.n145 1224.71
R565 VDD.n159 VDD.n141 1224.71
R566 VDD.n159 VDD.n142 1224.71
R567 VDD.n155 VDD.n142 1224.71
R568 VDD.n155 VDD.n141 1224.71
R569 VDD.n175 VDD.n167 1224.71
R570 VDD.n171 VDD.n168 1224.71
R571 VDD.n175 VDD.n168 1224.71
R572 VDD.n182 VDD.n164 1224.71
R573 VDD.n182 VDD.n165 1224.71
R574 VDD.n178 VDD.n165 1224.71
R575 VDD.n178 VDD.n164 1224.71
R576 VDD.n198 VDD.n190 1224.71
R577 VDD.n194 VDD.n191 1224.71
R578 VDD.n198 VDD.n191 1224.71
R579 VDD.n205 VDD.n187 1224.71
R580 VDD.n205 VDD.n188 1224.71
R581 VDD.n201 VDD.n188 1224.71
R582 VDD.n201 VDD.n187 1224.71
R583 VDD.n221 VDD.n213 1224.71
R584 VDD.n217 VDD.n214 1224.71
R585 VDD.n221 VDD.n214 1224.71
R586 VDD.n228 VDD.n210 1224.71
R587 VDD.n228 VDD.n211 1224.71
R588 VDD.n224 VDD.n211 1224.71
R589 VDD.n224 VDD.n210 1224.71
R590 VDD.n244 VDD.n236 1224.71
R591 VDD.n240 VDD.n237 1224.71
R592 VDD.n244 VDD.n237 1224.71
R593 VDD.n251 VDD.n233 1224.71
R594 VDD.n251 VDD.n234 1224.71
R595 VDD.n247 VDD.n234 1224.71
R596 VDD.n247 VDD.n233 1224.71
R597 VDD.n267 VDD.n259 1224.71
R598 VDD.n263 VDD.n260 1224.71
R599 VDD.n267 VDD.n260 1224.71
R600 VDD.n274 VDD.n256 1224.71
R601 VDD.n274 VDD.n257 1224.71
R602 VDD.n270 VDD.n257 1224.71
R603 VDD.n270 VDD.n256 1224.71
R604 VDD.n290 VDD.n282 1224.71
R605 VDD.n286 VDD.n283 1224.71
R606 VDD.n290 VDD.n283 1224.71
R607 VDD.n297 VDD.n279 1224.71
R608 VDD.n297 VDD.n280 1224.71
R609 VDD.n293 VDD.n280 1224.71
R610 VDD.n293 VDD.n279 1224.71
R611 VDD.n313 VDD.n305 1224.71
R612 VDD.n309 VDD.n306 1224.71
R613 VDD.n313 VDD.n306 1224.71
R614 VDD.n320 VDD.n302 1224.71
R615 VDD.n320 VDD.n303 1224.71
R616 VDD.n316 VDD.n303 1224.71
R617 VDD.n316 VDD.n302 1224.71
R618 VDD.n336 VDD.n328 1224.71
R619 VDD.n332 VDD.n329 1224.71
R620 VDD.n336 VDD.n329 1224.71
R621 VDD.n343 VDD.n325 1224.71
R622 VDD.n343 VDD.n326 1224.71
R623 VDD.n339 VDD.n326 1224.71
R624 VDD.n339 VDD.n325 1224.71
R625 VDD.n359 VDD.n351 1224.71
R626 VDD.n355 VDD.n352 1224.71
R627 VDD.n359 VDD.n352 1224.71
R628 VDD.n366 VDD.n348 1224.71
R629 VDD.n366 VDD.n349 1224.71
R630 VDD.n362 VDD.n349 1224.71
R631 VDD.n362 VDD.n348 1224.71
R632 VDD.n382 VDD.n374 1224.71
R633 VDD.n378 VDD.n375 1224.71
R634 VDD.n382 VDD.n375 1224.71
R635 VDD.n389 VDD.n371 1224.71
R636 VDD.n389 VDD.n372 1224.71
R637 VDD.n385 VDD.n372 1224.71
R638 VDD.n385 VDD.n371 1224.71
R639 VDD.n405 VDD.n397 1224.71
R640 VDD.n401 VDD.n398 1224.71
R641 VDD.n405 VDD.n398 1224.71
R642 VDD.n412 VDD.n394 1224.71
R643 VDD.n412 VDD.n395 1224.71
R644 VDD.n408 VDD.n395 1224.71
R645 VDD.n408 VDD.n394 1224.71
R646 VDD.n428 VDD.n420 1224.71
R647 VDD.n424 VDD.n421 1224.71
R648 VDD.n428 VDD.n421 1224.71
R649 VDD.n435 VDD.n417 1224.71
R650 VDD.n435 VDD.n418 1224.71
R651 VDD.n431 VDD.n418 1224.71
R652 VDD.n431 VDD.n417 1224.71
R653 VDD.n451 VDD.n443 1224.71
R654 VDD.n447 VDD.n444 1224.71
R655 VDD.n451 VDD.n444 1224.71
R656 VDD.n458 VDD.n440 1224.71
R657 VDD.n458 VDD.n441 1224.71
R658 VDD.n454 VDD.n441 1224.71
R659 VDD.n454 VDD.n440 1224.71
R660 VDD.n474 VDD.n466 1224.71
R661 VDD.n470 VDD.n467 1224.71
R662 VDD.n474 VDD.n467 1224.71
R663 VDD.n481 VDD.n463 1224.71
R664 VDD.n481 VDD.n464 1224.71
R665 VDD.n477 VDD.n464 1224.71
R666 VDD.n477 VDD.n463 1224.71
R667 VDD.n497 VDD.n489 1224.71
R668 VDD.n493 VDD.n490 1224.71
R669 VDD.n497 VDD.n490 1224.71
R670 VDD.n504 VDD.n486 1224.71
R671 VDD.n504 VDD.n487 1224.71
R672 VDD.n500 VDD.n487 1224.71
R673 VDD.n500 VDD.n486 1224.71
R674 VDD.n520 VDD.n512 1224.71
R675 VDD.n516 VDD.n513 1224.71
R676 VDD.n520 VDD.n513 1224.71
R677 VDD.n527 VDD.n509 1224.71
R678 VDD.n527 VDD.n510 1224.71
R679 VDD.n523 VDD.n510 1224.71
R680 VDD.n523 VDD.n509 1224.71
R681 VDD.n543 VDD.n535 1224.71
R682 VDD.n539 VDD.n536 1224.71
R683 VDD.n543 VDD.n536 1224.71
R684 VDD.n550 VDD.n532 1224.71
R685 VDD.n550 VDD.n533 1224.71
R686 VDD.n546 VDD.n533 1224.71
R687 VDD.n546 VDD.n532 1224.71
R688 VDD.n566 VDD.n558 1224.71
R689 VDD.n562 VDD.n559 1224.71
R690 VDD.n566 VDD.n559 1224.71
R691 VDD.n573 VDD.n555 1224.71
R692 VDD.n573 VDD.n556 1224.71
R693 VDD.n569 VDD.n556 1224.71
R694 VDD.n569 VDD.n555 1224.71
R695 VDD.n589 VDD.n581 1224.71
R696 VDD.n585 VDD.n582 1224.71
R697 VDD.n589 VDD.n582 1224.71
R698 VDD.n596 VDD.n578 1224.71
R699 VDD.n596 VDD.n579 1224.71
R700 VDD.n592 VDD.n579 1224.71
R701 VDD.n592 VDD.n578 1224.71
R702 VDD.n612 VDD.n604 1224.71
R703 VDD.n608 VDD.n605 1224.71
R704 VDD.n612 VDD.n605 1224.71
R705 VDD.n619 VDD.n601 1224.71
R706 VDD.n619 VDD.n602 1224.71
R707 VDD.n615 VDD.n602 1224.71
R708 VDD.n615 VDD.n601 1224.71
R709 VDD.n635 VDD.n627 1224.71
R710 VDD.n631 VDD.n628 1224.71
R711 VDD.n635 VDD.n628 1224.71
R712 VDD.n642 VDD.n624 1224.71
R713 VDD.n642 VDD.n625 1224.71
R714 VDD.n638 VDD.n625 1224.71
R715 VDD.n638 VDD.n624 1224.71
R716 VDD.n658 VDD.n650 1224.71
R717 VDD.n654 VDD.n651 1224.71
R718 VDD.n658 VDD.n651 1224.71
R719 VDD.n665 VDD.n647 1224.71
R720 VDD.n665 VDD.n648 1224.71
R721 VDD.n661 VDD.n648 1224.71
R722 VDD.n661 VDD.n647 1224.71
R723 VDD.n681 VDD.n673 1224.71
R724 VDD.n677 VDD.n674 1224.71
R725 VDD.n681 VDD.n674 1224.71
R726 VDD.n688 VDD.n670 1224.71
R727 VDD.n688 VDD.n671 1224.71
R728 VDD.n684 VDD.n671 1224.71
R729 VDD.n684 VDD.n670 1224.71
R730 VDD.n704 VDD.n696 1224.71
R731 VDD.n700 VDD.n697 1224.71
R732 VDD.n704 VDD.n697 1224.71
R733 VDD.n711 VDD.n693 1224.71
R734 VDD.n711 VDD.n694 1224.71
R735 VDD.n707 VDD.n694 1224.71
R736 VDD.n707 VDD.n693 1224.71
R737 VDD.n727 VDD.n719 1224.71
R738 VDD.n723 VDD.n720 1224.71
R739 VDD.n727 VDD.n720 1224.71
R740 VDD.n734 VDD.n716 1224.71
R741 VDD.n734 VDD.n717 1224.71
R742 VDD.n730 VDD.n717 1224.71
R743 VDD.n730 VDD.n716 1224.71
R744 VDD.n750 VDD.n742 1224.71
R745 VDD.n746 VDD.n743 1224.71
R746 VDD.n750 VDD.n743 1224.71
R747 VDD.n757 VDD.n739 1224.71
R748 VDD.n757 VDD.n740 1224.71
R749 VDD.n753 VDD.n740 1224.71
R750 VDD.n753 VDD.n739 1224.71
R751 VDD.n773 VDD.n765 1224.71
R752 VDD.n769 VDD.n766 1224.71
R753 VDD.n773 VDD.n766 1224.71
R754 VDD.n780 VDD.n762 1224.71
R755 VDD.n780 VDD.n763 1224.71
R756 VDD.n776 VDD.n763 1224.71
R757 VDD.n776 VDD.n762 1224.71
R758 VDD.n70 VDD.t91 669.436
R759 VDD.n93 VDD.t87 669.436
R760 VDD.n116 VDD.t79 669.436
R761 VDD.n139 VDD.t73 669.436
R762 VDD.n162 VDD.t69 669.436
R763 VDD.n185 VDD.t39 669.436
R764 VDD.n208 VDD.t113 669.436
R765 VDD.n231 VDD.t134 669.436
R766 VDD.n254 VDD.t21 669.436
R767 VDD.n277 VDD.t63 669.436
R768 VDD.n300 VDD.t99 669.436
R769 VDD.n323 VDD.t37 669.436
R770 VDD.n346 VDD.t25 669.436
R771 VDD.n369 VDD.t124 669.436
R772 VDD.n392 VDD.t119 669.436
R773 VDD.n415 VDD.t103 669.436
R774 VDD.n438 VDD.t105 669.436
R775 VDD.n461 VDD.t95 669.436
R776 VDD.n484 VDD.t33 669.436
R777 VDD.n507 VDD.t67 669.436
R778 VDD.n530 VDD.t15 669.436
R779 VDD.n553 VDD.t55 669.436
R780 VDD.n576 VDD.t23 669.436
R781 VDD.n599 VDD.t11 669.436
R782 VDD.n622 VDD.t65 669.436
R783 VDD.n645 VDD.t47 669.436
R784 VDD.n668 VDD.t27 669.436
R785 VDD.n691 VDD.t13 669.436
R786 VDD.n714 VDD.t1 669.436
R787 VDD.n737 VDD.t81 669.436
R788 VDD.n760 VDD.t43 669.436
R789 VDD.n783 VDD.t5 669.436
R790 VDD.n69 VDD.t93 669.297
R791 VDD.n92 VDD.t89 669.297
R792 VDD.n115 VDD.t85 669.297
R793 VDD.n138 VDD.t75 669.297
R794 VDD.n161 VDD.t101 669.297
R795 VDD.n184 VDD.t71 669.297
R796 VDD.n207 VDD.t59 669.297
R797 VDD.n230 VDD.t19 669.297
R798 VDD.n253 VDD.t31 669.297
R799 VDD.n276 VDD.t111 669.297
R800 VDD.n299 VDD.t61 669.297
R801 VDD.n322 VDD.t57 669.297
R802 VDD.n345 VDD.t35 669.297
R803 VDD.n368 VDD.t139 669.297
R804 VDD.n391 VDD.t121 669.297
R805 VDD.n414 VDD.t117 669.297
R806 VDD.n437 VDD.t115 669.297
R807 VDD.n460 VDD.t109 669.297
R808 VDD.n483 VDD.t17 669.297
R809 VDD.n506 VDD.t29 669.297
R810 VDD.n529 VDD.t83 669.297
R811 VDD.n552 VDD.t9 669.297
R812 VDD.n575 VDD.t77 669.297
R813 VDD.n598 VDD.t107 669.297
R814 VDD.n621 VDD.t53 669.297
R815 VDD.n644 VDD.t49 669.297
R816 VDD.n667 VDD.t51 669.297
R817 VDD.n690 VDD.t97 669.297
R818 VDD.n713 VDD.t45 669.297
R819 VDD.n736 VDD.t7 669.297
R820 VDD.n759 VDD.t136 669.297
R821 VDD.n782 VDD.t41 669.297
R822 VDD VDD.n68 615.634
R823 VDD VDD.n91 615.634
R824 VDD VDD.n114 615.634
R825 VDD VDD.n137 615.634
R826 VDD VDD.n160 615.634
R827 VDD VDD.n183 615.634
R828 VDD VDD.n206 615.634
R829 VDD VDD.n229 615.634
R830 VDD VDD.n252 615.634
R831 VDD VDD.n275 615.634
R832 VDD VDD.n298 615.634
R833 VDD VDD.n321 615.634
R834 VDD VDD.n344 615.634
R835 VDD VDD.n367 615.634
R836 VDD VDD.n390 615.634
R837 VDD VDD.n413 615.634
R838 VDD VDD.n436 615.634
R839 VDD VDD.n459 615.634
R840 VDD VDD.n482 615.634
R841 VDD VDD.n505 615.634
R842 VDD VDD.n528 615.634
R843 VDD VDD.n551 615.634
R844 VDD VDD.n574 615.634
R845 VDD VDD.n597 615.634
R846 VDD VDD.n620 615.634
R847 VDD VDD.n643 615.634
R848 VDD VDD.n666 615.634
R849 VDD VDD.n689 615.634
R850 VDD VDD.n712 615.634
R851 VDD VDD.n735 615.634
R852 VDD VDD.n758 615.634
R853 VDD VDD.n781 615.634
R854 VDD.n888 VDD.t141 340.688
R855 VDD.n61 VDD.t90 319.38
R856 VDD.n62 VDD.t92 319.38
R857 VDD.n68 VDD.t92 319.38
R858 VDD.n84 VDD.t86 319.38
R859 VDD.n85 VDD.t88 319.38
R860 VDD.n91 VDD.t88 319.38
R861 VDD.n107 VDD.t78 319.38
R862 VDD.n108 VDD.t84 319.38
R863 VDD.n114 VDD.t84 319.38
R864 VDD.n130 VDD.t72 319.38
R865 VDD.n131 VDD.t74 319.38
R866 VDD.n137 VDD.t74 319.38
R867 VDD.n153 VDD.t68 319.38
R868 VDD.n154 VDD.t100 319.38
R869 VDD.n160 VDD.t100 319.38
R870 VDD.n176 VDD.t38 319.38
R871 VDD.n177 VDD.t70 319.38
R872 VDD.n183 VDD.t70 319.38
R873 VDD.n199 VDD.t112 319.38
R874 VDD.n200 VDD.t58 319.38
R875 VDD.n206 VDD.t58 319.38
R876 VDD.n222 VDD.t133 319.38
R877 VDD.n223 VDD.t18 319.38
R878 VDD.n229 VDD.t18 319.38
R879 VDD.n245 VDD.t20 319.38
R880 VDD.n246 VDD.t30 319.38
R881 VDD.n252 VDD.t30 319.38
R882 VDD.n268 VDD.t62 319.38
R883 VDD.n269 VDD.t110 319.38
R884 VDD.n275 VDD.t110 319.38
R885 VDD.n291 VDD.t98 319.38
R886 VDD.n292 VDD.t60 319.38
R887 VDD.n298 VDD.t60 319.38
R888 VDD.n314 VDD.t36 319.38
R889 VDD.n315 VDD.t56 319.38
R890 VDD.n321 VDD.t56 319.38
R891 VDD.n337 VDD.t24 319.38
R892 VDD.n338 VDD.t34 319.38
R893 VDD.n344 VDD.t34 319.38
R894 VDD.n360 VDD.t123 319.38
R895 VDD.n361 VDD.t138 319.38
R896 VDD.n367 VDD.t138 319.38
R897 VDD.n383 VDD.t118 319.38
R898 VDD.n384 VDD.t120 319.38
R899 VDD.n390 VDD.t120 319.38
R900 VDD.n406 VDD.t102 319.38
R901 VDD.n407 VDD.t116 319.38
R902 VDD.n413 VDD.t116 319.38
R903 VDD.n429 VDD.t104 319.38
R904 VDD.n430 VDD.t114 319.38
R905 VDD.n436 VDD.t114 319.38
R906 VDD.n452 VDD.t94 319.38
R907 VDD.n453 VDD.t108 319.38
R908 VDD.n459 VDD.t108 319.38
R909 VDD.n475 VDD.t32 319.38
R910 VDD.n476 VDD.t16 319.38
R911 VDD.n482 VDD.t16 319.38
R912 VDD.n498 VDD.t66 319.38
R913 VDD.n499 VDD.t28 319.38
R914 VDD.n505 VDD.t28 319.38
R915 VDD.n521 VDD.t14 319.38
R916 VDD.n522 VDD.t82 319.38
R917 VDD.n528 VDD.t82 319.38
R918 VDD.n544 VDD.t54 319.38
R919 VDD.n545 VDD.t8 319.38
R920 VDD.n551 VDD.t8 319.38
R921 VDD.n567 VDD.t22 319.38
R922 VDD.n568 VDD.t76 319.38
R923 VDD.n574 VDD.t76 319.38
R924 VDD.n590 VDD.t10 319.38
R925 VDD.n591 VDD.t106 319.38
R926 VDD.n597 VDD.t106 319.38
R927 VDD.n613 VDD.t64 319.38
R928 VDD.n614 VDD.t52 319.38
R929 VDD.n620 VDD.t52 319.38
R930 VDD.n636 VDD.t46 319.38
R931 VDD.n637 VDD.t48 319.38
R932 VDD.n643 VDD.t48 319.38
R933 VDD.n659 VDD.t26 319.38
R934 VDD.n660 VDD.t50 319.38
R935 VDD.n666 VDD.t50 319.38
R936 VDD.n682 VDD.t12 319.38
R937 VDD.n683 VDD.t96 319.38
R938 VDD.n689 VDD.t96 319.38
R939 VDD.n705 VDD.t0 319.38
R940 VDD.n706 VDD.t44 319.38
R941 VDD.n712 VDD.t44 319.38
R942 VDD.n728 VDD.t80 319.38
R943 VDD.n729 VDD.t6 319.38
R944 VDD.n735 VDD.t6 319.38
R945 VDD.n751 VDD.t42 319.38
R946 VDD.n752 VDD.t135 319.38
R947 VDD.n758 VDD.t135 319.38
R948 VDD.n774 VDD.t4 319.38
R949 VDD.n775 VDD.t40 319.38
R950 VDD.n781 VDD.t40 319.38
R951 VDD.n40 VDD.n37 305.318
R952 VDD.n40 VDD.n36 305.318
R953 VDD.n28 VDD.n25 305.318
R954 VDD.n28 VDD.n24 305.318
R955 VDD.n15 VDD.n12 305.318
R956 VDD.n15 VDD.n11 305.318
R957 VDD.n4 VDD.n1 305.318
R958 VDD.n4 VDD.n0 305.318
R959 VDD.n45 VDD.n37 304.188
R960 VDD.n33 VDD.n25 304.188
R961 VDD.n20 VDD.n12 304.188
R962 VDD.n9 VDD.n1 304.188
R963 VDD.n56 VDD.n55 266.092
R964 VDD.n79 VDD.n78 266.092
R965 VDD.n102 VDD.n101 266.092
R966 VDD.n125 VDD.n124 266.092
R967 VDD.n148 VDD.n147 266.092
R968 VDD.n171 VDD.n170 266.092
R969 VDD.n194 VDD.n193 266.092
R970 VDD.n217 VDD.n216 266.092
R971 VDD.n240 VDD.n239 266.092
R972 VDD.n263 VDD.n262 266.092
R973 VDD.n286 VDD.n285 266.092
R974 VDD.n309 VDD.n308 266.092
R975 VDD.n332 VDD.n331 266.092
R976 VDD.n355 VDD.n354 266.092
R977 VDD.n378 VDD.n377 266.092
R978 VDD.n401 VDD.n400 266.092
R979 VDD.n424 VDD.n423 266.092
R980 VDD.n447 VDD.n446 266.092
R981 VDD.n470 VDD.n469 266.092
R982 VDD.n493 VDD.n492 266.092
R983 VDD.n516 VDD.n515 266.092
R984 VDD.n539 VDD.n538 266.092
R985 VDD.n562 VDD.n561 266.092
R986 VDD.n585 VDD.n584 266.092
R987 VDD.n608 VDD.n607 266.092
R988 VDD.n631 VDD.n630 266.092
R989 VDD.n654 VDD.n653 266.092
R990 VDD.n677 VDD.n676 266.092
R991 VDD.n700 VDD.n699 266.092
R992 VDD.n723 VDD.n722 266.092
R993 VDD.n746 VDD.n745 266.092
R994 VDD.n769 VDD.n768 266.092
R995 VDD.n46 VDD.n36 244.707
R996 VDD.n34 VDD.n24 244.707
R997 VDD.n21 VDD.n11 244.707
R998 VDD.n10 VDD.n0 244.707
R999 VDD.n879 VDD.n878 223.581
R1000 VDD.n883 VDD.n882 223.581
R1001 VDD.n819 VDD.n811 210.447
R1002 VDD.n814 VDD.n811 210.447
R1003 VDD.n814 VDD.n810 210.447
R1004 VDD.n805 VDD.n797 210.447
R1005 VDD.n800 VDD.n797 210.447
R1006 VDD.n800 VDD.n796 210.447
R1007 VDD.n794 VDD.n786 210.447
R1008 VDD.n789 VDD.n786 210.447
R1009 VDD.n789 VDD.n785 210.447
R1010 VDD.n839 VDD.n836 190.871
R1011 VDD.n839 VDD.n835 190.871
R1012 VDD.n828 VDD.n825 190.871
R1013 VDD.n828 VDD.n824 190.871
R1014 VDD.n844 VDD.n836 189.742
R1015 VDD.n833 VDD.n825 189.742
R1016 VDD.n865 VDD.n862 186.73
R1017 VDD.n865 VDD.n861 186.73
R1018 VDD.n851 VDD.n848 186.73
R1019 VDD.n851 VDD.n847 186.73
R1020 VDD.n870 VDD.n862 185.601
R1021 VDD.n856 VDD.n848 185.601
R1022 VDD.n864 VDD.n863 176.815
R1023 VDD.n868 VDD.n867 176.815
R1024 VDD.n850 VDD.n849 176.815
R1025 VDD.n854 VDD.n853 176.815
R1026 VDD.n838 VDD.n837 173.642
R1027 VDD.n842 VDD.n841 173.642
R1028 VDD.n827 VDD.n826 173.642
R1029 VDD.n831 VDD.n830 173.642
R1030 VDD.n816 VDD.n815 156.411
R1031 VDD.n818 VDD.n817 156.411
R1032 VDD.n802 VDD.n801 156.411
R1033 VDD.n804 VDD.n803 156.411
R1034 VDD.n791 VDD.n790 156.411
R1035 VDD.n793 VDD.n792 156.411
R1036 VDD.n880 VDD.n877 147.201
R1037 VDD.n880 VDD.n876 147.201
R1038 VDD.n885 VDD.n877 146.071
R1039 VDD.n860 VDD.t128 143.498
R1040 VDD.n859 VDD.t3 143.498
R1041 VDD.n820 VDD.n819 134.024
R1042 VDD.n806 VDD.n805 134.024
R1043 VDD.n795 VDD.n794 134.024
R1044 VDD.n57 VDD.n54 130.636
R1045 VDD.n59 VDD.n54 130.636
R1046 VDD.n58 VDD.n57 130.636
R1047 VDD.n59 VDD.n58 130.636
R1048 VDD.n66 VDD.n51 130.636
R1049 VDD.n66 VDD.n65 130.636
R1050 VDD.n65 VDD.n64 130.636
R1051 VDD.n64 VDD.n51 130.636
R1052 VDD.n80 VDD.n77 130.636
R1053 VDD.n82 VDD.n77 130.636
R1054 VDD.n81 VDD.n80 130.636
R1055 VDD.n82 VDD.n81 130.636
R1056 VDD.n89 VDD.n74 130.636
R1057 VDD.n89 VDD.n88 130.636
R1058 VDD.n88 VDD.n87 130.636
R1059 VDD.n87 VDD.n74 130.636
R1060 VDD.n103 VDD.n100 130.636
R1061 VDD.n105 VDD.n100 130.636
R1062 VDD.n104 VDD.n103 130.636
R1063 VDD.n105 VDD.n104 130.636
R1064 VDD.n112 VDD.n97 130.636
R1065 VDD.n112 VDD.n111 130.636
R1066 VDD.n111 VDD.n110 130.636
R1067 VDD.n110 VDD.n97 130.636
R1068 VDD.n126 VDD.n123 130.636
R1069 VDD.n128 VDD.n123 130.636
R1070 VDD.n127 VDD.n126 130.636
R1071 VDD.n128 VDD.n127 130.636
R1072 VDD.n135 VDD.n120 130.636
R1073 VDD.n135 VDD.n134 130.636
R1074 VDD.n134 VDD.n133 130.636
R1075 VDD.n133 VDD.n120 130.636
R1076 VDD.n149 VDD.n146 130.636
R1077 VDD.n151 VDD.n146 130.636
R1078 VDD.n150 VDD.n149 130.636
R1079 VDD.n151 VDD.n150 130.636
R1080 VDD.n158 VDD.n143 130.636
R1081 VDD.n158 VDD.n157 130.636
R1082 VDD.n157 VDD.n156 130.636
R1083 VDD.n156 VDD.n143 130.636
R1084 VDD.n172 VDD.n169 130.636
R1085 VDD.n174 VDD.n169 130.636
R1086 VDD.n173 VDD.n172 130.636
R1087 VDD.n174 VDD.n173 130.636
R1088 VDD.n181 VDD.n166 130.636
R1089 VDD.n181 VDD.n180 130.636
R1090 VDD.n180 VDD.n179 130.636
R1091 VDD.n179 VDD.n166 130.636
R1092 VDD.n195 VDD.n192 130.636
R1093 VDD.n197 VDD.n192 130.636
R1094 VDD.n196 VDD.n195 130.636
R1095 VDD.n197 VDD.n196 130.636
R1096 VDD.n204 VDD.n189 130.636
R1097 VDD.n204 VDD.n203 130.636
R1098 VDD.n203 VDD.n202 130.636
R1099 VDD.n202 VDD.n189 130.636
R1100 VDD.n218 VDD.n215 130.636
R1101 VDD.n220 VDD.n215 130.636
R1102 VDD.n219 VDD.n218 130.636
R1103 VDD.n220 VDD.n219 130.636
R1104 VDD.n227 VDD.n212 130.636
R1105 VDD.n227 VDD.n226 130.636
R1106 VDD.n226 VDD.n225 130.636
R1107 VDD.n225 VDD.n212 130.636
R1108 VDD.n241 VDD.n238 130.636
R1109 VDD.n243 VDD.n238 130.636
R1110 VDD.n242 VDD.n241 130.636
R1111 VDD.n243 VDD.n242 130.636
R1112 VDD.n250 VDD.n235 130.636
R1113 VDD.n250 VDD.n249 130.636
R1114 VDD.n249 VDD.n248 130.636
R1115 VDD.n248 VDD.n235 130.636
R1116 VDD.n264 VDD.n261 130.636
R1117 VDD.n266 VDD.n261 130.636
R1118 VDD.n265 VDD.n264 130.636
R1119 VDD.n266 VDD.n265 130.636
R1120 VDD.n273 VDD.n258 130.636
R1121 VDD.n273 VDD.n272 130.636
R1122 VDD.n272 VDD.n271 130.636
R1123 VDD.n271 VDD.n258 130.636
R1124 VDD.n287 VDD.n284 130.636
R1125 VDD.n289 VDD.n284 130.636
R1126 VDD.n288 VDD.n287 130.636
R1127 VDD.n289 VDD.n288 130.636
R1128 VDD.n296 VDD.n281 130.636
R1129 VDD.n296 VDD.n295 130.636
R1130 VDD.n295 VDD.n294 130.636
R1131 VDD.n294 VDD.n281 130.636
R1132 VDD.n310 VDD.n307 130.636
R1133 VDD.n312 VDD.n307 130.636
R1134 VDD.n311 VDD.n310 130.636
R1135 VDD.n312 VDD.n311 130.636
R1136 VDD.n319 VDD.n304 130.636
R1137 VDD.n319 VDD.n318 130.636
R1138 VDD.n318 VDD.n317 130.636
R1139 VDD.n317 VDD.n304 130.636
R1140 VDD.n333 VDD.n330 130.636
R1141 VDD.n335 VDD.n330 130.636
R1142 VDD.n334 VDD.n333 130.636
R1143 VDD.n335 VDD.n334 130.636
R1144 VDD.n342 VDD.n327 130.636
R1145 VDD.n342 VDD.n341 130.636
R1146 VDD.n341 VDD.n340 130.636
R1147 VDD.n340 VDD.n327 130.636
R1148 VDD.n356 VDD.n353 130.636
R1149 VDD.n358 VDD.n353 130.636
R1150 VDD.n357 VDD.n356 130.636
R1151 VDD.n358 VDD.n357 130.636
R1152 VDD.n365 VDD.n350 130.636
R1153 VDD.n365 VDD.n364 130.636
R1154 VDD.n364 VDD.n363 130.636
R1155 VDD.n363 VDD.n350 130.636
R1156 VDD.n379 VDD.n376 130.636
R1157 VDD.n381 VDD.n376 130.636
R1158 VDD.n380 VDD.n379 130.636
R1159 VDD.n381 VDD.n380 130.636
R1160 VDD.n388 VDD.n373 130.636
R1161 VDD.n388 VDD.n387 130.636
R1162 VDD.n387 VDD.n386 130.636
R1163 VDD.n386 VDD.n373 130.636
R1164 VDD.n402 VDD.n399 130.636
R1165 VDD.n404 VDD.n399 130.636
R1166 VDD.n403 VDD.n402 130.636
R1167 VDD.n404 VDD.n403 130.636
R1168 VDD.n411 VDD.n396 130.636
R1169 VDD.n411 VDD.n410 130.636
R1170 VDD.n410 VDD.n409 130.636
R1171 VDD.n409 VDD.n396 130.636
R1172 VDD.n425 VDD.n422 130.636
R1173 VDD.n427 VDD.n422 130.636
R1174 VDD.n426 VDD.n425 130.636
R1175 VDD.n427 VDD.n426 130.636
R1176 VDD.n434 VDD.n419 130.636
R1177 VDD.n434 VDD.n433 130.636
R1178 VDD.n433 VDD.n432 130.636
R1179 VDD.n432 VDD.n419 130.636
R1180 VDD.n448 VDD.n445 130.636
R1181 VDD.n450 VDD.n445 130.636
R1182 VDD.n449 VDD.n448 130.636
R1183 VDD.n450 VDD.n449 130.636
R1184 VDD.n457 VDD.n442 130.636
R1185 VDD.n457 VDD.n456 130.636
R1186 VDD.n456 VDD.n455 130.636
R1187 VDD.n455 VDD.n442 130.636
R1188 VDD.n471 VDD.n468 130.636
R1189 VDD.n473 VDD.n468 130.636
R1190 VDD.n472 VDD.n471 130.636
R1191 VDD.n473 VDD.n472 130.636
R1192 VDD.n480 VDD.n465 130.636
R1193 VDD.n480 VDD.n479 130.636
R1194 VDD.n479 VDD.n478 130.636
R1195 VDD.n478 VDD.n465 130.636
R1196 VDD.n494 VDD.n491 130.636
R1197 VDD.n496 VDD.n491 130.636
R1198 VDD.n495 VDD.n494 130.636
R1199 VDD.n496 VDD.n495 130.636
R1200 VDD.n503 VDD.n488 130.636
R1201 VDD.n503 VDD.n502 130.636
R1202 VDD.n502 VDD.n501 130.636
R1203 VDD.n501 VDD.n488 130.636
R1204 VDD.n517 VDD.n514 130.636
R1205 VDD.n519 VDD.n514 130.636
R1206 VDD.n518 VDD.n517 130.636
R1207 VDD.n519 VDD.n518 130.636
R1208 VDD.n526 VDD.n511 130.636
R1209 VDD.n526 VDD.n525 130.636
R1210 VDD.n525 VDD.n524 130.636
R1211 VDD.n524 VDD.n511 130.636
R1212 VDD.n540 VDD.n537 130.636
R1213 VDD.n542 VDD.n537 130.636
R1214 VDD.n541 VDD.n540 130.636
R1215 VDD.n542 VDD.n541 130.636
R1216 VDD.n549 VDD.n534 130.636
R1217 VDD.n549 VDD.n548 130.636
R1218 VDD.n548 VDD.n547 130.636
R1219 VDD.n547 VDD.n534 130.636
R1220 VDD.n563 VDD.n560 130.636
R1221 VDD.n565 VDD.n560 130.636
R1222 VDD.n564 VDD.n563 130.636
R1223 VDD.n565 VDD.n564 130.636
R1224 VDD.n572 VDD.n557 130.636
R1225 VDD.n572 VDD.n571 130.636
R1226 VDD.n571 VDD.n570 130.636
R1227 VDD.n570 VDD.n557 130.636
R1228 VDD.n586 VDD.n583 130.636
R1229 VDD.n588 VDD.n583 130.636
R1230 VDD.n587 VDD.n586 130.636
R1231 VDD.n588 VDD.n587 130.636
R1232 VDD.n595 VDD.n580 130.636
R1233 VDD.n595 VDD.n594 130.636
R1234 VDD.n594 VDD.n593 130.636
R1235 VDD.n593 VDD.n580 130.636
R1236 VDD.n609 VDD.n606 130.636
R1237 VDD.n611 VDD.n606 130.636
R1238 VDD.n610 VDD.n609 130.636
R1239 VDD.n611 VDD.n610 130.636
R1240 VDD.n618 VDD.n603 130.636
R1241 VDD.n618 VDD.n617 130.636
R1242 VDD.n617 VDD.n616 130.636
R1243 VDD.n616 VDD.n603 130.636
R1244 VDD.n632 VDD.n629 130.636
R1245 VDD.n634 VDD.n629 130.636
R1246 VDD.n633 VDD.n632 130.636
R1247 VDD.n634 VDD.n633 130.636
R1248 VDD.n641 VDD.n626 130.636
R1249 VDD.n641 VDD.n640 130.636
R1250 VDD.n640 VDD.n639 130.636
R1251 VDD.n639 VDD.n626 130.636
R1252 VDD.n655 VDD.n652 130.636
R1253 VDD.n657 VDD.n652 130.636
R1254 VDD.n656 VDD.n655 130.636
R1255 VDD.n657 VDD.n656 130.636
R1256 VDD.n664 VDD.n649 130.636
R1257 VDD.n664 VDD.n663 130.636
R1258 VDD.n663 VDD.n662 130.636
R1259 VDD.n662 VDD.n649 130.636
R1260 VDD.n678 VDD.n675 130.636
R1261 VDD.n680 VDD.n675 130.636
R1262 VDD.n679 VDD.n678 130.636
R1263 VDD.n680 VDD.n679 130.636
R1264 VDD.n687 VDD.n672 130.636
R1265 VDD.n687 VDD.n686 130.636
R1266 VDD.n686 VDD.n685 130.636
R1267 VDD.n685 VDD.n672 130.636
R1268 VDD.n701 VDD.n698 130.636
R1269 VDD.n703 VDD.n698 130.636
R1270 VDD.n702 VDD.n701 130.636
R1271 VDD.n703 VDD.n702 130.636
R1272 VDD.n710 VDD.n695 130.636
R1273 VDD.n710 VDD.n709 130.636
R1274 VDD.n709 VDD.n708 130.636
R1275 VDD.n708 VDD.n695 130.636
R1276 VDD.n724 VDD.n721 130.636
R1277 VDD.n726 VDD.n721 130.636
R1278 VDD.n725 VDD.n724 130.636
R1279 VDD.n726 VDD.n725 130.636
R1280 VDD.n733 VDD.n718 130.636
R1281 VDD.n733 VDD.n732 130.636
R1282 VDD.n732 VDD.n731 130.636
R1283 VDD.n731 VDD.n718 130.636
R1284 VDD.n747 VDD.n744 130.636
R1285 VDD.n749 VDD.n744 130.636
R1286 VDD.n748 VDD.n747 130.636
R1287 VDD.n749 VDD.n748 130.636
R1288 VDD.n756 VDD.n741 130.636
R1289 VDD.n756 VDD.n755 130.636
R1290 VDD.n755 VDD.n754 130.636
R1291 VDD.n754 VDD.n741 130.636
R1292 VDD.n770 VDD.n767 130.636
R1293 VDD.n772 VDD.n767 130.636
R1294 VDD.n771 VDD.n770 130.636
R1295 VDD.n772 VDD.n771 130.636
R1296 VDD.n779 VDD.n764 130.636
R1297 VDD.n779 VDD.n778 130.636
R1298 VDD.n778 VDD.n777 130.636
R1299 VDD.n777 VDD.n764 130.636
R1300 VDD.n845 VDD.n835 130.26
R1301 VDD.n834 VDD.n824 130.26
R1302 VDD.n871 VDD.n861 126.118
R1303 VDD.n857 VDD.n847 126.118
R1304 VDD.n62 VDD.n61 111.885
R1305 VDD.n85 VDD.n84 111.885
R1306 VDD.n108 VDD.n107 111.885
R1307 VDD.n131 VDD.n130 111.885
R1308 VDD.n154 VDD.n153 111.885
R1309 VDD.n177 VDD.n176 111.885
R1310 VDD.n200 VDD.n199 111.885
R1311 VDD.n223 VDD.n222 111.885
R1312 VDD.n246 VDD.n245 111.885
R1313 VDD.n269 VDD.n268 111.885
R1314 VDD.n292 VDD.n291 111.885
R1315 VDD.n315 VDD.n314 111.885
R1316 VDD.n338 VDD.n337 111.885
R1317 VDD.n361 VDD.n360 111.885
R1318 VDD.n384 VDD.n383 111.885
R1319 VDD.n407 VDD.n406 111.885
R1320 VDD.n430 VDD.n429 111.885
R1321 VDD.n453 VDD.n452 111.885
R1322 VDD.n476 VDD.n475 111.885
R1323 VDD.n499 VDD.n498 111.885
R1324 VDD.n522 VDD.n521 111.885
R1325 VDD.n545 VDD.n544 111.885
R1326 VDD.n568 VDD.n567 111.885
R1327 VDD.n591 VDD.n590 111.885
R1328 VDD.n614 VDD.n613 111.885
R1329 VDD.n637 VDD.n636 111.885
R1330 VDD.n660 VDD.n659 111.885
R1331 VDD.n683 VDD.n682 111.885
R1332 VDD.n706 VDD.n705 111.885
R1333 VDD.n729 VDD.n728 111.885
R1334 VDD.n752 VDD.n751 111.885
R1335 VDD.n775 VDD.n774 111.885
R1336 VDD.n39 VDD.n38 106.945
R1337 VDD.n43 VDD.n42 106.945
R1338 VDD.n27 VDD.n26 106.945
R1339 VDD.n31 VDD.n30 106.945
R1340 VDD.n14 VDD.n13 106.945
R1341 VDD.n18 VDD.n17 106.945
R1342 VDD.n3 VDD.n2 106.945
R1343 VDD.n7 VDD.n6 106.945
R1344 VDD.n809 VDD.t145 105.757
R1345 VDD.n808 VDD.t143 105.757
R1346 VDD.n51 VDD.n49 92.5005
R1347 VDD.n49 VDD.t92 92.5005
R1348 VDD.n58 VDD.n53 92.5005
R1349 VDD.n53 VDD.t90 92.5005
R1350 VDD.n54 VDD.n52 92.5005
R1351 VDD.n65 VDD.n50 92.5005
R1352 VDD.n50 VDD.t92 92.5005
R1353 VDD.n74 VDD.n72 92.5005
R1354 VDD.n72 VDD.t88 92.5005
R1355 VDD.n81 VDD.n76 92.5005
R1356 VDD.n76 VDD.t86 92.5005
R1357 VDD.n77 VDD.n75 92.5005
R1358 VDD.n88 VDD.n73 92.5005
R1359 VDD.n73 VDD.t88 92.5005
R1360 VDD.n97 VDD.n95 92.5005
R1361 VDD.n95 VDD.t84 92.5005
R1362 VDD.n104 VDD.n99 92.5005
R1363 VDD.n99 VDD.t78 92.5005
R1364 VDD.n100 VDD.n98 92.5005
R1365 VDD.n111 VDD.n96 92.5005
R1366 VDD.n96 VDD.t84 92.5005
R1367 VDD.n120 VDD.n118 92.5005
R1368 VDD.n118 VDD.t74 92.5005
R1369 VDD.n127 VDD.n122 92.5005
R1370 VDD.n122 VDD.t72 92.5005
R1371 VDD.n123 VDD.n121 92.5005
R1372 VDD.n134 VDD.n119 92.5005
R1373 VDD.n119 VDD.t74 92.5005
R1374 VDD.n143 VDD.n141 92.5005
R1375 VDD.n141 VDD.t100 92.5005
R1376 VDD.n150 VDD.n145 92.5005
R1377 VDD.n145 VDD.t68 92.5005
R1378 VDD.n146 VDD.n144 92.5005
R1379 VDD.n157 VDD.n142 92.5005
R1380 VDD.n142 VDD.t100 92.5005
R1381 VDD.n166 VDD.n164 92.5005
R1382 VDD.n164 VDD.t70 92.5005
R1383 VDD.n173 VDD.n168 92.5005
R1384 VDD.n168 VDD.t38 92.5005
R1385 VDD.n169 VDD.n167 92.5005
R1386 VDD.n180 VDD.n165 92.5005
R1387 VDD.n165 VDD.t70 92.5005
R1388 VDD.n189 VDD.n187 92.5005
R1389 VDD.n187 VDD.t58 92.5005
R1390 VDD.n196 VDD.n191 92.5005
R1391 VDD.n191 VDD.t112 92.5005
R1392 VDD.n192 VDD.n190 92.5005
R1393 VDD.n203 VDD.n188 92.5005
R1394 VDD.n188 VDD.t58 92.5005
R1395 VDD.n212 VDD.n210 92.5005
R1396 VDD.n210 VDD.t18 92.5005
R1397 VDD.n219 VDD.n214 92.5005
R1398 VDD.n214 VDD.t133 92.5005
R1399 VDD.n215 VDD.n213 92.5005
R1400 VDD.n226 VDD.n211 92.5005
R1401 VDD.n211 VDD.t18 92.5005
R1402 VDD.n235 VDD.n233 92.5005
R1403 VDD.n233 VDD.t30 92.5005
R1404 VDD.n242 VDD.n237 92.5005
R1405 VDD.n237 VDD.t20 92.5005
R1406 VDD.n238 VDD.n236 92.5005
R1407 VDD.n249 VDD.n234 92.5005
R1408 VDD.n234 VDD.t30 92.5005
R1409 VDD.n258 VDD.n256 92.5005
R1410 VDD.n256 VDD.t110 92.5005
R1411 VDD.n265 VDD.n260 92.5005
R1412 VDD.n260 VDD.t62 92.5005
R1413 VDD.n261 VDD.n259 92.5005
R1414 VDD.n272 VDD.n257 92.5005
R1415 VDD.n257 VDD.t110 92.5005
R1416 VDD.n281 VDD.n279 92.5005
R1417 VDD.n279 VDD.t60 92.5005
R1418 VDD.n288 VDD.n283 92.5005
R1419 VDD.n283 VDD.t98 92.5005
R1420 VDD.n284 VDD.n282 92.5005
R1421 VDD.n295 VDD.n280 92.5005
R1422 VDD.n280 VDD.t60 92.5005
R1423 VDD.n304 VDD.n302 92.5005
R1424 VDD.n302 VDD.t56 92.5005
R1425 VDD.n311 VDD.n306 92.5005
R1426 VDD.n306 VDD.t36 92.5005
R1427 VDD.n307 VDD.n305 92.5005
R1428 VDD.n318 VDD.n303 92.5005
R1429 VDD.n303 VDD.t56 92.5005
R1430 VDD.n327 VDD.n325 92.5005
R1431 VDD.n325 VDD.t34 92.5005
R1432 VDD.n334 VDD.n329 92.5005
R1433 VDD.n329 VDD.t24 92.5005
R1434 VDD.n330 VDD.n328 92.5005
R1435 VDD.n341 VDD.n326 92.5005
R1436 VDD.n326 VDD.t34 92.5005
R1437 VDD.n350 VDD.n348 92.5005
R1438 VDD.n348 VDD.t138 92.5005
R1439 VDD.n357 VDD.n352 92.5005
R1440 VDD.n352 VDD.t123 92.5005
R1441 VDD.n353 VDD.n351 92.5005
R1442 VDD.n364 VDD.n349 92.5005
R1443 VDD.n349 VDD.t138 92.5005
R1444 VDD.n373 VDD.n371 92.5005
R1445 VDD.n371 VDD.t120 92.5005
R1446 VDD.n380 VDD.n375 92.5005
R1447 VDD.n375 VDD.t118 92.5005
R1448 VDD.n376 VDD.n374 92.5005
R1449 VDD.n387 VDD.n372 92.5005
R1450 VDD.n372 VDD.t120 92.5005
R1451 VDD.n396 VDD.n394 92.5005
R1452 VDD.n394 VDD.t116 92.5005
R1453 VDD.n403 VDD.n398 92.5005
R1454 VDD.n398 VDD.t102 92.5005
R1455 VDD.n399 VDD.n397 92.5005
R1456 VDD.n410 VDD.n395 92.5005
R1457 VDD.n395 VDD.t116 92.5005
R1458 VDD.n419 VDD.n417 92.5005
R1459 VDD.n417 VDD.t114 92.5005
R1460 VDD.n426 VDD.n421 92.5005
R1461 VDD.n421 VDD.t104 92.5005
R1462 VDD.n422 VDD.n420 92.5005
R1463 VDD.n433 VDD.n418 92.5005
R1464 VDD.n418 VDD.t114 92.5005
R1465 VDD.n442 VDD.n440 92.5005
R1466 VDD.n440 VDD.t108 92.5005
R1467 VDD.n449 VDD.n444 92.5005
R1468 VDD.n444 VDD.t94 92.5005
R1469 VDD.n445 VDD.n443 92.5005
R1470 VDD.n456 VDD.n441 92.5005
R1471 VDD.n441 VDD.t108 92.5005
R1472 VDD.n465 VDD.n463 92.5005
R1473 VDD.n463 VDD.t16 92.5005
R1474 VDD.n472 VDD.n467 92.5005
R1475 VDD.n467 VDD.t32 92.5005
R1476 VDD.n468 VDD.n466 92.5005
R1477 VDD.n479 VDD.n464 92.5005
R1478 VDD.n464 VDD.t16 92.5005
R1479 VDD.n488 VDD.n486 92.5005
R1480 VDD.n486 VDD.t28 92.5005
R1481 VDD.n495 VDD.n490 92.5005
R1482 VDD.n490 VDD.t66 92.5005
R1483 VDD.n491 VDD.n489 92.5005
R1484 VDD.n502 VDD.n487 92.5005
R1485 VDD.n487 VDD.t28 92.5005
R1486 VDD.n511 VDD.n509 92.5005
R1487 VDD.n509 VDD.t82 92.5005
R1488 VDD.n518 VDD.n513 92.5005
R1489 VDD.n513 VDD.t14 92.5005
R1490 VDD.n514 VDD.n512 92.5005
R1491 VDD.n525 VDD.n510 92.5005
R1492 VDD.n510 VDD.t82 92.5005
R1493 VDD.n534 VDD.n532 92.5005
R1494 VDD.n532 VDD.t8 92.5005
R1495 VDD.n541 VDD.n536 92.5005
R1496 VDD.n536 VDD.t54 92.5005
R1497 VDD.n537 VDD.n535 92.5005
R1498 VDD.n548 VDD.n533 92.5005
R1499 VDD.n533 VDD.t8 92.5005
R1500 VDD.n557 VDD.n555 92.5005
R1501 VDD.n555 VDD.t76 92.5005
R1502 VDD.n564 VDD.n559 92.5005
R1503 VDD.n559 VDD.t22 92.5005
R1504 VDD.n560 VDD.n558 92.5005
R1505 VDD.n571 VDD.n556 92.5005
R1506 VDD.n556 VDD.t76 92.5005
R1507 VDD.n580 VDD.n578 92.5005
R1508 VDD.n578 VDD.t106 92.5005
R1509 VDD.n587 VDD.n582 92.5005
R1510 VDD.n582 VDD.t10 92.5005
R1511 VDD.n583 VDD.n581 92.5005
R1512 VDD.n594 VDD.n579 92.5005
R1513 VDD.n579 VDD.t106 92.5005
R1514 VDD.n603 VDD.n601 92.5005
R1515 VDD.n601 VDD.t52 92.5005
R1516 VDD.n610 VDD.n605 92.5005
R1517 VDD.n605 VDD.t64 92.5005
R1518 VDD.n606 VDD.n604 92.5005
R1519 VDD.n617 VDD.n602 92.5005
R1520 VDD.n602 VDD.t52 92.5005
R1521 VDD.n626 VDD.n624 92.5005
R1522 VDD.n624 VDD.t48 92.5005
R1523 VDD.n633 VDD.n628 92.5005
R1524 VDD.n628 VDD.t46 92.5005
R1525 VDD.n629 VDD.n627 92.5005
R1526 VDD.n640 VDD.n625 92.5005
R1527 VDD.n625 VDD.t48 92.5005
R1528 VDD.n649 VDD.n647 92.5005
R1529 VDD.n647 VDD.t50 92.5005
R1530 VDD.n656 VDD.n651 92.5005
R1531 VDD.n651 VDD.t26 92.5005
R1532 VDD.n652 VDD.n650 92.5005
R1533 VDD.n663 VDD.n648 92.5005
R1534 VDD.n648 VDD.t50 92.5005
R1535 VDD.n672 VDD.n670 92.5005
R1536 VDD.n670 VDD.t96 92.5005
R1537 VDD.n679 VDD.n674 92.5005
R1538 VDD.n674 VDD.t12 92.5005
R1539 VDD.n675 VDD.n673 92.5005
R1540 VDD.n686 VDD.n671 92.5005
R1541 VDD.n671 VDD.t96 92.5005
R1542 VDD.n695 VDD.n693 92.5005
R1543 VDD.n693 VDD.t44 92.5005
R1544 VDD.n702 VDD.n697 92.5005
R1545 VDD.n697 VDD.t0 92.5005
R1546 VDD.n698 VDD.n696 92.5005
R1547 VDD.n709 VDD.n694 92.5005
R1548 VDD.n694 VDD.t44 92.5005
R1549 VDD.n718 VDD.n716 92.5005
R1550 VDD.n716 VDD.t6 92.5005
R1551 VDD.n725 VDD.n720 92.5005
R1552 VDD.n720 VDD.t80 92.5005
R1553 VDD.n721 VDD.n719 92.5005
R1554 VDD.n732 VDD.n717 92.5005
R1555 VDD.n717 VDD.t6 92.5005
R1556 VDD.n741 VDD.n739 92.5005
R1557 VDD.n739 VDD.t135 92.5005
R1558 VDD.n748 VDD.n743 92.5005
R1559 VDD.n743 VDD.t42 92.5005
R1560 VDD.n744 VDD.n742 92.5005
R1561 VDD.n755 VDD.n740 92.5005
R1562 VDD.n740 VDD.t135 92.5005
R1563 VDD.n764 VDD.n762 92.5005
R1564 VDD.n762 VDD.t40 92.5005
R1565 VDD.n771 VDD.n766 92.5005
R1566 VDD.n766 VDD.t4 92.5005
R1567 VDD.n767 VDD.n765 92.5005
R1568 VDD.n778 VDD.n763 92.5005
R1569 VDD.n763 VDD.t40 92.5005
R1570 VDD.n813 VDD.n811 92.5005
R1571 VDD.n812 VDD.n810 92.5005
R1572 VDD.n799 VDD.n797 92.5005
R1573 VDD.n798 VDD.n796 92.5005
R1574 VDD.n788 VDD.n786 92.5005
R1575 VDD.n787 VDD.n785 92.5005
R1576 VDD.n866 VDD.n865 92.5005
R1577 VDD.n870 VDD.n869 92.5005
R1578 VDD.n852 VDD.n851 92.5005
R1579 VDD.n856 VDD.n855 92.5005
R1580 VDD.n840 VDD.n839 92.5005
R1581 VDD.n844 VDD.n843 92.5005
R1582 VDD.n829 VDD.n828 92.5005
R1583 VDD.n833 VDD.n832 92.5005
R1584 VDD.n881 VDD.n880 92.5005
R1585 VDD.n885 VDD.n884 92.5005
R1586 VDD.n41 VDD.n40 92.5005
R1587 VDD.n45 VDD.n44 92.5005
R1588 VDD.n29 VDD.n28 92.5005
R1589 VDD.n33 VDD.n32 92.5005
R1590 VDD.n16 VDD.n15 92.5005
R1591 VDD.n20 VDD.n19 92.5005
R1592 VDD.n5 VDD.n4 92.5005
R1593 VDD.n9 VDD.n8 92.5005
R1594 VDD.n886 VDD.n876 86.5887
R1595 VDD.n44 VDD.n38 86.2575
R1596 VDD.n42 VDD.n41 86.2575
R1597 VDD.n32 VDD.n26 86.2575
R1598 VDD.n30 VDD.n29 86.2575
R1599 VDD.n19 VDD.n13 86.2575
R1600 VDD.n17 VDD.n16 86.2575
R1601 VDD.n8 VDD.n2 86.2575
R1602 VDD.n6 VDD.n5 86.2575
R1603 VDD.n816 VDD.n812 81.3537
R1604 VDD.n817 VDD.n813 81.3537
R1605 VDD.n802 VDD.n798 81.3537
R1606 VDD.n803 VDD.n799 81.3537
R1607 VDD.n791 VDD.n787 81.3537
R1608 VDD.n792 VDD.n788 81.3537
R1609 VDD.n843 VDD.n837 79.4196
R1610 VDD.n841 VDD.n840 79.4196
R1611 VDD.n832 VDD.n826 79.4196
R1612 VDD.n830 VDD.n829 79.4196
R1613 VDD.n869 VDD.n863 78.9848
R1614 VDD.n867 VDD.n866 78.9848
R1615 VDD.n855 VDD.n849 78.9848
R1616 VDD.n853 VDD.n852 78.9848
R1617 VDD.n884 VDD.n878 72.6454
R1618 VDD.n882 VDD.n881 72.6454
R1619 VDD.n55 VDD.n52 67.3191
R1620 VDD.n78 VDD.n75 67.3191
R1621 VDD.n101 VDD.n98 67.3191
R1622 VDD.n124 VDD.n121 67.3191
R1623 VDD.n147 VDD.n144 67.3191
R1624 VDD.n170 VDD.n167 67.3191
R1625 VDD.n193 VDD.n190 67.3191
R1626 VDD.n216 VDD.n213 67.3191
R1627 VDD.n239 VDD.n236 67.3191
R1628 VDD.n262 VDD.n259 67.3191
R1629 VDD.n285 VDD.n282 67.3191
R1630 VDD.n308 VDD.n305 67.3191
R1631 VDD.n331 VDD.n328 67.3191
R1632 VDD.n354 VDD.n351 67.3191
R1633 VDD.n377 VDD.n374 67.3191
R1634 VDD.n400 VDD.n397 67.3191
R1635 VDD.n423 VDD.n420 67.3191
R1636 VDD.n446 VDD.n443 67.3191
R1637 VDD.n469 VDD.n466 67.3191
R1638 VDD.n492 VDD.n489 67.3191
R1639 VDD.n515 VDD.n512 67.3191
R1640 VDD.n538 VDD.n535 67.3191
R1641 VDD.n561 VDD.n558 67.3191
R1642 VDD.n584 VDD.n581 67.3191
R1643 VDD.n607 VDD.n604 67.3191
R1644 VDD.n630 VDD.n627 67.3191
R1645 VDD.n653 VDD.n650 67.3191
R1646 VDD.n676 VDD.n673 67.3191
R1647 VDD.n699 VDD.n696 67.3191
R1648 VDD.n722 VDD.n719 67.3191
R1649 VDD.n745 VDD.n742 67.3191
R1650 VDD.n768 VDD.n765 67.3191
R1651 VDD.n820 VDD.n810 61.3652
R1652 VDD.n806 VDD.n796 61.3652
R1653 VDD.n795 VDD.n785 61.3652
R1654 VDD.n48 VDD.t130 57.6362
R1655 VDD.n23 VDD.t132 57.6362
R1656 VDD.n871 VDD.n870 50.5605
R1657 VDD.n857 VDD.n856 50.5605
R1658 VDD.n845 VDD.n844 50.5605
R1659 VDD.n834 VDD.n833 50.5605
R1660 VDD.n886 VDD.n885 50.5605
R1661 VDD.n46 VDD.n45 50.5605
R1662 VDD.n34 VDD.n33 50.5605
R1663 VDD.n21 VDD.n20 50.5605
R1664 VDD.n10 VDD.n9 50.5605
R1665 VDD.n807 VDD.n795 48.0772
R1666 VDD.n872 VDD.n871 47.4734
R1667 VDD.n858 VDD.n857 47.4734
R1668 VDD.n821 VDD.n820 47.4505
R1669 VDD.n807 VDD.n806 47.4505
R1670 VDD.n846 VDD.n845 47.4505
R1671 VDD.n60 VDD.n59 46.2505
R1672 VDD.n61 VDD.n60 46.2505
R1673 VDD.n57 VDD.n56 46.2505
R1674 VDD.n67 VDD.n66 46.2505
R1675 VDD.n68 VDD.n67 46.2505
R1676 VDD.n64 VDD.n63 46.2505
R1677 VDD.n63 VDD.n62 46.2505
R1678 VDD.n83 VDD.n82 46.2505
R1679 VDD.n84 VDD.n83 46.2505
R1680 VDD.n80 VDD.n79 46.2505
R1681 VDD.n90 VDD.n89 46.2505
R1682 VDD.n91 VDD.n90 46.2505
R1683 VDD.n87 VDD.n86 46.2505
R1684 VDD.n86 VDD.n85 46.2505
R1685 VDD.n106 VDD.n105 46.2505
R1686 VDD.n107 VDD.n106 46.2505
R1687 VDD.n103 VDD.n102 46.2505
R1688 VDD.n113 VDD.n112 46.2505
R1689 VDD.n114 VDD.n113 46.2505
R1690 VDD.n110 VDD.n109 46.2505
R1691 VDD.n109 VDD.n108 46.2505
R1692 VDD.n129 VDD.n128 46.2505
R1693 VDD.n130 VDD.n129 46.2505
R1694 VDD.n126 VDD.n125 46.2505
R1695 VDD.n136 VDD.n135 46.2505
R1696 VDD.n137 VDD.n136 46.2505
R1697 VDD.n133 VDD.n132 46.2505
R1698 VDD.n132 VDD.n131 46.2505
R1699 VDD.n152 VDD.n151 46.2505
R1700 VDD.n153 VDD.n152 46.2505
R1701 VDD.n149 VDD.n148 46.2505
R1702 VDD.n159 VDD.n158 46.2505
R1703 VDD.n160 VDD.n159 46.2505
R1704 VDD.n156 VDD.n155 46.2505
R1705 VDD.n155 VDD.n154 46.2505
R1706 VDD.n175 VDD.n174 46.2505
R1707 VDD.n176 VDD.n175 46.2505
R1708 VDD.n172 VDD.n171 46.2505
R1709 VDD.n182 VDD.n181 46.2505
R1710 VDD.n183 VDD.n182 46.2505
R1711 VDD.n179 VDD.n178 46.2505
R1712 VDD.n178 VDD.n177 46.2505
R1713 VDD.n198 VDD.n197 46.2505
R1714 VDD.n199 VDD.n198 46.2505
R1715 VDD.n195 VDD.n194 46.2505
R1716 VDD.n205 VDD.n204 46.2505
R1717 VDD.n206 VDD.n205 46.2505
R1718 VDD.n202 VDD.n201 46.2505
R1719 VDD.n201 VDD.n200 46.2505
R1720 VDD.n221 VDD.n220 46.2505
R1721 VDD.n222 VDD.n221 46.2505
R1722 VDD.n218 VDD.n217 46.2505
R1723 VDD.n228 VDD.n227 46.2505
R1724 VDD.n229 VDD.n228 46.2505
R1725 VDD.n225 VDD.n224 46.2505
R1726 VDD.n224 VDD.n223 46.2505
R1727 VDD.n244 VDD.n243 46.2505
R1728 VDD.n245 VDD.n244 46.2505
R1729 VDD.n241 VDD.n240 46.2505
R1730 VDD.n251 VDD.n250 46.2505
R1731 VDD.n252 VDD.n251 46.2505
R1732 VDD.n248 VDD.n247 46.2505
R1733 VDD.n247 VDD.n246 46.2505
R1734 VDD.n267 VDD.n266 46.2505
R1735 VDD.n268 VDD.n267 46.2505
R1736 VDD.n264 VDD.n263 46.2505
R1737 VDD.n274 VDD.n273 46.2505
R1738 VDD.n275 VDD.n274 46.2505
R1739 VDD.n271 VDD.n270 46.2505
R1740 VDD.n270 VDD.n269 46.2505
R1741 VDD.n290 VDD.n289 46.2505
R1742 VDD.n291 VDD.n290 46.2505
R1743 VDD.n287 VDD.n286 46.2505
R1744 VDD.n297 VDD.n296 46.2505
R1745 VDD.n298 VDD.n297 46.2505
R1746 VDD.n294 VDD.n293 46.2505
R1747 VDD.n293 VDD.n292 46.2505
R1748 VDD.n313 VDD.n312 46.2505
R1749 VDD.n314 VDD.n313 46.2505
R1750 VDD.n310 VDD.n309 46.2505
R1751 VDD.n320 VDD.n319 46.2505
R1752 VDD.n321 VDD.n320 46.2505
R1753 VDD.n317 VDD.n316 46.2505
R1754 VDD.n316 VDD.n315 46.2505
R1755 VDD.n336 VDD.n335 46.2505
R1756 VDD.n337 VDD.n336 46.2505
R1757 VDD.n333 VDD.n332 46.2505
R1758 VDD.n343 VDD.n342 46.2505
R1759 VDD.n344 VDD.n343 46.2505
R1760 VDD.n340 VDD.n339 46.2505
R1761 VDD.n339 VDD.n338 46.2505
R1762 VDD.n359 VDD.n358 46.2505
R1763 VDD.n360 VDD.n359 46.2505
R1764 VDD.n356 VDD.n355 46.2505
R1765 VDD.n366 VDD.n365 46.2505
R1766 VDD.n367 VDD.n366 46.2505
R1767 VDD.n363 VDD.n362 46.2505
R1768 VDD.n362 VDD.n361 46.2505
R1769 VDD.n382 VDD.n381 46.2505
R1770 VDD.n383 VDD.n382 46.2505
R1771 VDD.n379 VDD.n378 46.2505
R1772 VDD.n389 VDD.n388 46.2505
R1773 VDD.n390 VDD.n389 46.2505
R1774 VDD.n386 VDD.n385 46.2505
R1775 VDD.n385 VDD.n384 46.2505
R1776 VDD.n405 VDD.n404 46.2505
R1777 VDD.n406 VDD.n405 46.2505
R1778 VDD.n402 VDD.n401 46.2505
R1779 VDD.n412 VDD.n411 46.2505
R1780 VDD.n413 VDD.n412 46.2505
R1781 VDD.n409 VDD.n408 46.2505
R1782 VDD.n408 VDD.n407 46.2505
R1783 VDD.n428 VDD.n427 46.2505
R1784 VDD.n429 VDD.n428 46.2505
R1785 VDD.n425 VDD.n424 46.2505
R1786 VDD.n435 VDD.n434 46.2505
R1787 VDD.n436 VDD.n435 46.2505
R1788 VDD.n432 VDD.n431 46.2505
R1789 VDD.n431 VDD.n430 46.2505
R1790 VDD.n451 VDD.n450 46.2505
R1791 VDD.n452 VDD.n451 46.2505
R1792 VDD.n448 VDD.n447 46.2505
R1793 VDD.n458 VDD.n457 46.2505
R1794 VDD.n459 VDD.n458 46.2505
R1795 VDD.n455 VDD.n454 46.2505
R1796 VDD.n454 VDD.n453 46.2505
R1797 VDD.n474 VDD.n473 46.2505
R1798 VDD.n475 VDD.n474 46.2505
R1799 VDD.n471 VDD.n470 46.2505
R1800 VDD.n481 VDD.n480 46.2505
R1801 VDD.n482 VDD.n481 46.2505
R1802 VDD.n478 VDD.n477 46.2505
R1803 VDD.n477 VDD.n476 46.2505
R1804 VDD.n497 VDD.n496 46.2505
R1805 VDD.n498 VDD.n497 46.2505
R1806 VDD.n494 VDD.n493 46.2505
R1807 VDD.n504 VDD.n503 46.2505
R1808 VDD.n505 VDD.n504 46.2505
R1809 VDD.n501 VDD.n500 46.2505
R1810 VDD.n500 VDD.n499 46.2505
R1811 VDD.n520 VDD.n519 46.2505
R1812 VDD.n521 VDD.n520 46.2505
R1813 VDD.n517 VDD.n516 46.2505
R1814 VDD.n527 VDD.n526 46.2505
R1815 VDD.n528 VDD.n527 46.2505
R1816 VDD.n524 VDD.n523 46.2505
R1817 VDD.n523 VDD.n522 46.2505
R1818 VDD.n543 VDD.n542 46.2505
R1819 VDD.n544 VDD.n543 46.2505
R1820 VDD.n540 VDD.n539 46.2505
R1821 VDD.n550 VDD.n549 46.2505
R1822 VDD.n551 VDD.n550 46.2505
R1823 VDD.n547 VDD.n546 46.2505
R1824 VDD.n546 VDD.n545 46.2505
R1825 VDD.n566 VDD.n565 46.2505
R1826 VDD.n567 VDD.n566 46.2505
R1827 VDD.n563 VDD.n562 46.2505
R1828 VDD.n573 VDD.n572 46.2505
R1829 VDD.n574 VDD.n573 46.2505
R1830 VDD.n570 VDD.n569 46.2505
R1831 VDD.n569 VDD.n568 46.2505
R1832 VDD.n589 VDD.n588 46.2505
R1833 VDD.n590 VDD.n589 46.2505
R1834 VDD.n586 VDD.n585 46.2505
R1835 VDD.n596 VDD.n595 46.2505
R1836 VDD.n597 VDD.n596 46.2505
R1837 VDD.n593 VDD.n592 46.2505
R1838 VDD.n592 VDD.n591 46.2505
R1839 VDD.n612 VDD.n611 46.2505
R1840 VDD.n613 VDD.n612 46.2505
R1841 VDD.n609 VDD.n608 46.2505
R1842 VDD.n619 VDD.n618 46.2505
R1843 VDD.n620 VDD.n619 46.2505
R1844 VDD.n616 VDD.n615 46.2505
R1845 VDD.n615 VDD.n614 46.2505
R1846 VDD.n635 VDD.n634 46.2505
R1847 VDD.n636 VDD.n635 46.2505
R1848 VDD.n632 VDD.n631 46.2505
R1849 VDD.n642 VDD.n641 46.2505
R1850 VDD.n643 VDD.n642 46.2505
R1851 VDD.n639 VDD.n638 46.2505
R1852 VDD.n638 VDD.n637 46.2505
R1853 VDD.n658 VDD.n657 46.2505
R1854 VDD.n659 VDD.n658 46.2505
R1855 VDD.n655 VDD.n654 46.2505
R1856 VDD.n665 VDD.n664 46.2505
R1857 VDD.n666 VDD.n665 46.2505
R1858 VDD.n662 VDD.n661 46.2505
R1859 VDD.n661 VDD.n660 46.2505
R1860 VDD.n681 VDD.n680 46.2505
R1861 VDD.n682 VDD.n681 46.2505
R1862 VDD.n678 VDD.n677 46.2505
R1863 VDD.n688 VDD.n687 46.2505
R1864 VDD.n689 VDD.n688 46.2505
R1865 VDD.n685 VDD.n684 46.2505
R1866 VDD.n684 VDD.n683 46.2505
R1867 VDD.n704 VDD.n703 46.2505
R1868 VDD.n705 VDD.n704 46.2505
R1869 VDD.n701 VDD.n700 46.2505
R1870 VDD.n711 VDD.n710 46.2505
R1871 VDD.n712 VDD.n711 46.2505
R1872 VDD.n708 VDD.n707 46.2505
R1873 VDD.n707 VDD.n706 46.2505
R1874 VDD.n727 VDD.n726 46.2505
R1875 VDD.n728 VDD.n727 46.2505
R1876 VDD.n724 VDD.n723 46.2505
R1877 VDD.n734 VDD.n733 46.2505
R1878 VDD.n735 VDD.n734 46.2505
R1879 VDD.n731 VDD.n730 46.2505
R1880 VDD.n730 VDD.n729 46.2505
R1881 VDD.n750 VDD.n749 46.2505
R1882 VDD.n751 VDD.n750 46.2505
R1883 VDD.n747 VDD.n746 46.2505
R1884 VDD.n757 VDD.n756 46.2505
R1885 VDD.n758 VDD.n757 46.2505
R1886 VDD.n754 VDD.n753 46.2505
R1887 VDD.n753 VDD.n752 46.2505
R1888 VDD.n773 VDD.n772 46.2505
R1889 VDD.n774 VDD.n773 46.2505
R1890 VDD.n770 VDD.n769 46.2505
R1891 VDD.n780 VDD.n779 46.2505
R1892 VDD.n781 VDD.n780 46.2505
R1893 VDD.n777 VDD.n776 46.2505
R1894 VDD.n776 VDD.n775 46.2505
R1895 VDD.n883 VDD.n877 37.0005
R1896 VDD.n879 VDD.n876 37.0005
R1897 VDD.n887 VDD.n886 34.8922
R1898 VDD.n22 VDD.n10 32.9206
R1899 VDD.n47 VDD.n46 32.293
R1900 VDD.n35 VDD.n34 32.293
R1901 VDD.n22 VDD.n21 32.293
R1902 VDD.n846 VDD.n834 32.038
R1903 VDD.n868 VDD.n862 23.1255
R1904 VDD.n864 VDD.n861 23.1255
R1905 VDD.n854 VDD.n848 23.1255
R1906 VDD.n850 VDD.n847 23.1255
R1907 VDD.n842 VDD.n836 23.1255
R1908 VDD.n838 VDD.n835 23.1255
R1909 VDD.n831 VDD.n825 23.1255
R1910 VDD.n827 VDD.n824 23.1255
R1911 VDD.n55 VDD.t90 20.0984
R1912 VDD.n78 VDD.t86 20.0984
R1913 VDD.n101 VDD.t78 20.0984
R1914 VDD.n124 VDD.t72 20.0984
R1915 VDD.n147 VDD.t68 20.0984
R1916 VDD.n170 VDD.t38 20.0984
R1917 VDD.n193 VDD.t112 20.0984
R1918 VDD.n216 VDD.t133 20.0984
R1919 VDD.n239 VDD.t20 20.0984
R1920 VDD.n262 VDD.t62 20.0984
R1921 VDD.n285 VDD.t98 20.0984
R1922 VDD.n308 VDD.t36 20.0984
R1923 VDD.n331 VDD.t24 20.0984
R1924 VDD.n354 VDD.t123 20.0984
R1925 VDD.n377 VDD.t118 20.0984
R1926 VDD.n400 VDD.t102 20.0984
R1927 VDD.n423 VDD.t104 20.0984
R1928 VDD.n446 VDD.t94 20.0984
R1929 VDD.n469 VDD.t32 20.0984
R1930 VDD.n492 VDD.t66 20.0984
R1931 VDD.n515 VDD.t14 20.0984
R1932 VDD.n538 VDD.t54 20.0984
R1933 VDD.n561 VDD.t22 20.0984
R1934 VDD.n584 VDD.t10 20.0984
R1935 VDD.n607 VDD.t64 20.0984
R1936 VDD.n630 VDD.t46 20.0984
R1937 VDD.n653 VDD.t26 20.0984
R1938 VDD.n676 VDD.t12 20.0984
R1939 VDD.n699 VDD.t0 20.0984
R1940 VDD.n722 VDD.t80 20.0984
R1941 VDD.n745 VDD.t42 20.0984
R1942 VDD.n768 VDD.t4 20.0984
R1943 VDD.n815 VDD.n814 18.5005
R1944 VDD.n819 VDD.n818 18.5005
R1945 VDD.n801 VDD.n800 18.5005
R1946 VDD.n805 VDD.n804 18.5005
R1947 VDD.n790 VDD.n789 18.5005
R1948 VDD.n794 VDD.n793 18.5005
R1949 VDD.n882 VDD.t140 14.9873
R1950 VDD.t140 VDD.n878 14.9873
R1951 VDD.n43 VDD.n37 10.8829
R1952 VDD.n39 VDD.n36 10.8829
R1953 VDD.n31 VDD.n25 10.8829
R1954 VDD.n27 VDD.n24 10.8829
R1955 VDD.n18 VDD.n12 10.8829
R1956 VDD.n14 VDD.n11 10.8829
R1957 VDD.n7 VDD.n1 10.8829
R1958 VDD.n3 VDD.n0 10.8829
R1959 VDD.n867 VDD.t127 9.34373
R1960 VDD.t127 VDD.n863 9.34373
R1961 VDD.n853 VDD.t2 9.34373
R1962 VDD.t2 VDD.n849 9.34373
R1963 VDD.n841 VDD.t125 8.97701
R1964 VDD.t125 VDD.n837 8.97701
R1965 VDD.n830 VDD.t126 8.97701
R1966 VDD.t126 VDD.n826 8.97701
R1967 VDD.n817 VDD.t144 7.33417
R1968 VDD.t144 VDD.n816 7.33417
R1969 VDD.n803 VDD.t142 7.33417
R1970 VDD.t142 VDD.n802 7.33417
R1971 VDD.n792 VDD.t146 7.33417
R1972 VDD.t146 VDD.n791 7.33417
R1973 VDD.n875 VDD.n874 6.113
R1974 VDD.n71 VDD.n70 3.5985
R1975 VDD.n94 VDD.n93 3.5985
R1976 VDD.n117 VDD.n116 3.5985
R1977 VDD.n140 VDD.n139 3.5985
R1978 VDD.n163 VDD.n162 3.5985
R1979 VDD.n186 VDD.n185 3.5985
R1980 VDD.n209 VDD.n208 3.5985
R1981 VDD.n232 VDD.n231 3.5985
R1982 VDD.n255 VDD.n254 3.5985
R1983 VDD.n278 VDD.n277 3.5985
R1984 VDD.n301 VDD.n300 3.5985
R1985 VDD.n324 VDD.n323 3.5985
R1986 VDD.n347 VDD.n346 3.5985
R1987 VDD.n370 VDD.n369 3.5985
R1988 VDD.n393 VDD.n392 3.5985
R1989 VDD.n416 VDD.n415 3.5985
R1990 VDD.n439 VDD.n438 3.5985
R1991 VDD.n462 VDD.n461 3.5985
R1992 VDD.n485 VDD.n484 3.5985
R1993 VDD.n508 VDD.n507 3.5985
R1994 VDD.n531 VDD.n530 3.5985
R1995 VDD.n554 VDD.n553 3.5985
R1996 VDD.n577 VDD.n576 3.5985
R1997 VDD.n600 VDD.n599 3.5985
R1998 VDD.n623 VDD.n622 3.5985
R1999 VDD.n646 VDD.n645 3.5985
R2000 VDD.n669 VDD.n668 3.5985
R2001 VDD.n692 VDD.n691 3.5985
R2002 VDD.n715 VDD.n714 3.5985
R2003 VDD.n738 VDD.n737 3.5985
R2004 VDD.n761 VDD.n760 3.5985
R2005 VDD.n784 VDD.n783 3.5985
R2006 VDD.n42 VDD.t129 3.45704
R2007 VDD.t129 VDD.n38 3.45704
R2008 VDD.n30 VDD.t122 3.45704
R2009 VDD.t122 VDD.n26 3.45704
R2010 VDD.n17 VDD.t131 3.45704
R2011 VDD.t131 VDD.n13 3.45704
R2012 VDD.n6 VDD.t137 3.45704
R2013 VDD.t137 VDD.n2 3.45704
R2014 VDD.n874 VDD.n873 3.4105
R2015 VDD.n823 VDD.n822 3.4105
R2016 VDD.n874 VDD.n823 1.63962
R2017 VDD.n823 VDD.n784 1.45163
R2018 VDD.n94 VDD.n71 1.058
R2019 VDD.n117 VDD.n94 1.058
R2020 VDD.n140 VDD.n117 1.058
R2021 VDD.n163 VDD.n140 1.058
R2022 VDD.n186 VDD.n163 1.058
R2023 VDD.n209 VDD.n186 1.058
R2024 VDD.n232 VDD.n209 1.058
R2025 VDD.n255 VDD.n232 1.058
R2026 VDD.n278 VDD.n255 1.058
R2027 VDD.n301 VDD.n278 1.058
R2028 VDD.n324 VDD.n301 1.058
R2029 VDD.n347 VDD.n324 1.058
R2030 VDD.n370 VDD.n347 1.058
R2031 VDD.n393 VDD.n370 1.058
R2032 VDD.n416 VDD.n393 1.058
R2033 VDD.n439 VDD.n416 1.058
R2034 VDD.n462 VDD.n439 1.058
R2035 VDD.n485 VDD.n462 1.058
R2036 VDD.n508 VDD.n485 1.058
R2037 VDD.n531 VDD.n508 1.058
R2038 VDD.n554 VDD.n531 1.058
R2039 VDD.n577 VDD.n554 1.058
R2040 VDD.n600 VDD.n577 1.058
R2041 VDD.n623 VDD.n600 1.058
R2042 VDD.n646 VDD.n623 1.058
R2043 VDD.n669 VDD.n646 1.058
R2044 VDD.n692 VDD.n669 1.058
R2045 VDD.n715 VDD.n692 1.058
R2046 VDD.n738 VDD.n715 1.058
R2047 VDD.n761 VDD.n738 1.058
R2048 VDD.n784 VDD.n761 1.058
R2049 VDD.n47 VDD.n35 0.628131
R2050 VDD.n858 VDD.n846 0.627167
R2051 VDD.n809 VDD 0.532383
R2052 VDD.n860 VDD 0.532383
R2053 VDD VDD.n888 0.532383
R2054 VDD.n35 VDD.n23 0.52902
R2055 VDD.n822 VDD.n808 0.426633
R2056 VDD.n873 VDD.n859 0.426633
R2057 VDD.n875 VDD.n48 0.426633
R2058 VDD.n70 VDD.n69 0.2825
R2059 VDD.n93 VDD.n92 0.2825
R2060 VDD.n116 VDD.n115 0.2825
R2061 VDD.n139 VDD.n138 0.2825
R2062 VDD.n162 VDD.n161 0.2825
R2063 VDD.n185 VDD.n184 0.2825
R2064 VDD.n208 VDD.n207 0.2825
R2065 VDD.n231 VDD.n230 0.2825
R2066 VDD.n254 VDD.n253 0.2825
R2067 VDD.n277 VDD.n276 0.2825
R2068 VDD.n300 VDD.n299 0.2825
R2069 VDD.n323 VDD.n322 0.2825
R2070 VDD.n346 VDD.n345 0.2825
R2071 VDD.n369 VDD.n368 0.2825
R2072 VDD.n392 VDD.n391 0.2825
R2073 VDD.n415 VDD.n414 0.2825
R2074 VDD.n438 VDD.n437 0.2825
R2075 VDD.n461 VDD.n460 0.2825
R2076 VDD.n484 VDD.n483 0.2825
R2077 VDD.n507 VDD.n506 0.2825
R2078 VDD.n530 VDD.n529 0.2825
R2079 VDD.n553 VDD.n552 0.2825
R2080 VDD.n576 VDD.n575 0.2825
R2081 VDD.n599 VDD.n598 0.2825
R2082 VDD.n622 VDD.n621 0.2825
R2083 VDD.n645 VDD.n644 0.2825
R2084 VDD.n668 VDD.n667 0.2825
R2085 VDD.n691 VDD.n690 0.2825
R2086 VDD.n714 VDD.n713 0.2825
R2087 VDD.n737 VDD.n736 0.2825
R2088 VDD.n760 VDD.n759 0.2825
R2089 VDD.n783 VDD.n782 0.2825
R2090 VDD.n69 VDD 0.24725
R2091 VDD.n92 VDD 0.24725
R2092 VDD.n115 VDD 0.24725
R2093 VDD.n138 VDD 0.24725
R2094 VDD.n161 VDD 0.24725
R2095 VDD.n184 VDD 0.24725
R2096 VDD.n207 VDD 0.24725
R2097 VDD.n230 VDD 0.24725
R2098 VDD.n253 VDD 0.24725
R2099 VDD.n276 VDD 0.24725
R2100 VDD.n299 VDD 0.24725
R2101 VDD.n322 VDD 0.24725
R2102 VDD.n345 VDD 0.24725
R2103 VDD.n368 VDD 0.24725
R2104 VDD.n391 VDD 0.24725
R2105 VDD.n414 VDD 0.24725
R2106 VDD.n437 VDD 0.24725
R2107 VDD.n460 VDD 0.24725
R2108 VDD.n483 VDD 0.24725
R2109 VDD.n506 VDD 0.24725
R2110 VDD.n529 VDD 0.24725
R2111 VDD.n552 VDD 0.24725
R2112 VDD.n575 VDD 0.24725
R2113 VDD.n598 VDD 0.24725
R2114 VDD.n621 VDD 0.24725
R2115 VDD.n644 VDD 0.24725
R2116 VDD.n667 VDD 0.24725
R2117 VDD.n690 VDD 0.24725
R2118 VDD.n713 VDD 0.24725
R2119 VDD.n736 VDD 0.24725
R2120 VDD.n759 VDD 0.24725
R2121 VDD.n782 VDD 0.24725
R2122 VDD.n821 VDD.n809 0.154033
R2123 VDD.n808 VDD.n807 0.154033
R2124 VDD.n872 VDD.n860 0.138367
R2125 VDD.n859 VDD.n858 0.138367
R2126 VDD.n888 VDD.n887 0.107033
R2127 VDD.n23 VDD.n22 0.0996112
R2128 VDD.n48 VDD.n47 0.0996112
R2129 VDD.n887 VDD.n875 0.0788333
R2130 VDD.n71 VDD 0.05925
R2131 VDD.n873 VDD.n872 0.0475
R2132 VDD.n822 VDD.n821 0.0318333
R2133 VSS.n1339 VSS.n1327 38902.9
R2134 VSS.n817 VSS.n41 26071.8
R2135 VSS.n1397 VSS.t5 16831.7
R2136 VSS.n1389 VSS.n1328 16831.7
R2137 VSS.n1433 VSS.n1330 16831.7
R2138 VSS.n1435 VSS.n1328 9754.5
R2139 VSS.n1434 VSS.n1329 8731.1
R2140 VSS.n1412 VSS.n1411 8020.04
R2141 VSS.n1327 VSS.n1326 5154.8
R2142 VSS.n1399 VSS.n1352 4646.88
R2143 VSS.n1403 VSS.n1352 4646.88
R2144 VSS.n1399 VSS.n1353 4646.88
R2145 VSS.n1403 VSS.n1353 4646.88
R2146 VSS.n1391 VSS.n1356 4646.88
R2147 VSS.n1395 VSS.n1356 4646.88
R2148 VSS.n1391 VSS.n1357 4646.88
R2149 VSS.n1395 VSS.n1357 4646.88
R2150 VSS.n1383 VSS.n1360 4646.88
R2151 VSS.n1387 VSS.n1360 4646.88
R2152 VSS.n1383 VSS.n1361 4646.88
R2153 VSS.n1387 VSS.n1361 4646.88
R2154 VSS.n1376 VSS.n1364 4646.88
R2155 VSS.n1380 VSS.n1364 4646.88
R2156 VSS.n1376 VSS.n1365 4646.88
R2157 VSS.n1380 VSS.n1365 4646.88
R2158 VSS.n1437 VSS.n1326 2801.34
R2159 VSS.n810 VSS.n804 2450.91
R2160 VSS.n810 VSS.n805 2450.91
R2161 VSS.n804 VSS.n803 2450.91
R2162 VSS.n805 VSS.n803 2450.91
R2163 VSS.n556 VSS.n77 2450.91
R2164 VSS.n560 VSS.n77 2450.91
R2165 VSS.n556 VSS.n78 2450.91
R2166 VSS.n560 VSS.n78 2450.91
R2167 VSS.n564 VSS.n563 2450.91
R2168 VSS.n565 VSS.n563 2450.91
R2169 VSS.n570 VSS.n564 2450.91
R2170 VSS.n570 VSS.n565 2450.91
R2171 VSS.n344 VSS.n338 2450.91
R2172 VSS.n338 VSS.n46 2450.91
R2173 VSS.n344 VSS.n339 2450.91
R2174 VSS.n339 VSS.n46 2450.91
R2175 VSS.n802 VSS.n796 2450.91
R2176 VSS.n802 VSS.n797 2450.91
R2177 VSS.n796 VSS.n795 2450.91
R2178 VSS.n797 VSS.n795 2450.91
R2179 VSS.n554 VSS.n548 2450.91
R2180 VSS.n548 VSS.n76 2450.91
R2181 VSS.n554 VSS.n549 2450.91
R2182 VSS.n549 VSS.n76 2450.91
R2183 VSS.n572 VSS.n571 2450.91
R2184 VSS.n573 VSS.n571 2450.91
R2185 VSS.n578 VSS.n572 2450.91
R2186 VSS.n578 VSS.n573 2450.91
R2187 VSS.n351 VSS.n345 2450.91
R2188 VSS.n345 VSS.n47 2450.91
R2189 VSS.n351 VSS.n346 2450.91
R2190 VSS.n346 VSS.n47 2450.91
R2191 VSS.n794 VSS.n788 2450.91
R2192 VSS.n794 VSS.n789 2450.91
R2193 VSS.n788 VSS.n787 2450.91
R2194 VSS.n789 VSS.n787 2450.91
R2195 VSS.n547 VSS.n541 2450.91
R2196 VSS.n541 VSS.n75 2450.91
R2197 VSS.n547 VSS.n542 2450.91
R2198 VSS.n542 VSS.n75 2450.91
R2199 VSS.n580 VSS.n579 2450.91
R2200 VSS.n581 VSS.n579 2450.91
R2201 VSS.n586 VSS.n580 2450.91
R2202 VSS.n586 VSS.n581 2450.91
R2203 VSS.n358 VSS.n352 2450.91
R2204 VSS.n352 VSS.n48 2450.91
R2205 VSS.n358 VSS.n353 2450.91
R2206 VSS.n353 VSS.n48 2450.91
R2207 VSS.n786 VSS.n780 2450.91
R2208 VSS.n786 VSS.n781 2450.91
R2209 VSS.n780 VSS.n779 2450.91
R2210 VSS.n781 VSS.n779 2450.91
R2211 VSS.n540 VSS.n534 2450.91
R2212 VSS.n534 VSS.n74 2450.91
R2213 VSS.n540 VSS.n535 2450.91
R2214 VSS.n535 VSS.n74 2450.91
R2215 VSS.n588 VSS.n587 2450.91
R2216 VSS.n589 VSS.n587 2450.91
R2217 VSS.n594 VSS.n588 2450.91
R2218 VSS.n594 VSS.n589 2450.91
R2219 VSS.n365 VSS.n359 2450.91
R2220 VSS.n359 VSS.n49 2450.91
R2221 VSS.n365 VSS.n360 2450.91
R2222 VSS.n360 VSS.n49 2450.91
R2223 VSS.n778 VSS.n772 2450.91
R2224 VSS.n778 VSS.n773 2450.91
R2225 VSS.n772 VSS.n771 2450.91
R2226 VSS.n773 VSS.n771 2450.91
R2227 VSS.n533 VSS.n527 2450.91
R2228 VSS.n527 VSS.n73 2450.91
R2229 VSS.n533 VSS.n528 2450.91
R2230 VSS.n528 VSS.n73 2450.91
R2231 VSS.n596 VSS.n595 2450.91
R2232 VSS.n597 VSS.n595 2450.91
R2233 VSS.n602 VSS.n596 2450.91
R2234 VSS.n602 VSS.n597 2450.91
R2235 VSS.n372 VSS.n366 2450.91
R2236 VSS.n366 VSS.n50 2450.91
R2237 VSS.n372 VSS.n367 2450.91
R2238 VSS.n367 VSS.n50 2450.91
R2239 VSS.n770 VSS.n764 2450.91
R2240 VSS.n770 VSS.n765 2450.91
R2241 VSS.n764 VSS.n763 2450.91
R2242 VSS.n765 VSS.n763 2450.91
R2243 VSS.n526 VSS.n520 2450.91
R2244 VSS.n520 VSS.n72 2450.91
R2245 VSS.n526 VSS.n521 2450.91
R2246 VSS.n521 VSS.n72 2450.91
R2247 VSS.n604 VSS.n603 2450.91
R2248 VSS.n605 VSS.n603 2450.91
R2249 VSS.n610 VSS.n604 2450.91
R2250 VSS.n610 VSS.n605 2450.91
R2251 VSS.n379 VSS.n373 2450.91
R2252 VSS.n373 VSS.n51 2450.91
R2253 VSS.n379 VSS.n374 2450.91
R2254 VSS.n374 VSS.n51 2450.91
R2255 VSS.n762 VSS.n756 2450.91
R2256 VSS.n762 VSS.n757 2450.91
R2257 VSS.n756 VSS.n755 2450.91
R2258 VSS.n757 VSS.n755 2450.91
R2259 VSS.n519 VSS.n513 2450.91
R2260 VSS.n513 VSS.n71 2450.91
R2261 VSS.n519 VSS.n514 2450.91
R2262 VSS.n514 VSS.n71 2450.91
R2263 VSS.n612 VSS.n611 2450.91
R2264 VSS.n613 VSS.n611 2450.91
R2265 VSS.n618 VSS.n612 2450.91
R2266 VSS.n618 VSS.n613 2450.91
R2267 VSS.n386 VSS.n380 2450.91
R2268 VSS.n380 VSS.n52 2450.91
R2269 VSS.n386 VSS.n381 2450.91
R2270 VSS.n381 VSS.n52 2450.91
R2271 VSS.n754 VSS.n748 2450.91
R2272 VSS.n754 VSS.n749 2450.91
R2273 VSS.n748 VSS.n747 2450.91
R2274 VSS.n749 VSS.n747 2450.91
R2275 VSS.n512 VSS.n506 2450.91
R2276 VSS.n506 VSS.n70 2450.91
R2277 VSS.n512 VSS.n507 2450.91
R2278 VSS.n507 VSS.n70 2450.91
R2279 VSS.n620 VSS.n619 2450.91
R2280 VSS.n621 VSS.n619 2450.91
R2281 VSS.n626 VSS.n620 2450.91
R2282 VSS.n626 VSS.n621 2450.91
R2283 VSS.n393 VSS.n387 2450.91
R2284 VSS.n387 VSS.n53 2450.91
R2285 VSS.n393 VSS.n388 2450.91
R2286 VSS.n388 VSS.n53 2450.91
R2287 VSS.n746 VSS.n740 2450.91
R2288 VSS.n746 VSS.n741 2450.91
R2289 VSS.n740 VSS.n739 2450.91
R2290 VSS.n741 VSS.n739 2450.91
R2291 VSS.n505 VSS.n499 2450.91
R2292 VSS.n499 VSS.n69 2450.91
R2293 VSS.n505 VSS.n500 2450.91
R2294 VSS.n500 VSS.n69 2450.91
R2295 VSS.n628 VSS.n627 2450.91
R2296 VSS.n629 VSS.n627 2450.91
R2297 VSS.n634 VSS.n628 2450.91
R2298 VSS.n634 VSS.n629 2450.91
R2299 VSS.n400 VSS.n394 2450.91
R2300 VSS.n394 VSS.n54 2450.91
R2301 VSS.n400 VSS.n395 2450.91
R2302 VSS.n395 VSS.n54 2450.91
R2303 VSS.n738 VSS.n732 2450.91
R2304 VSS.n738 VSS.n733 2450.91
R2305 VSS.n732 VSS.n731 2450.91
R2306 VSS.n733 VSS.n731 2450.91
R2307 VSS.n498 VSS.n492 2450.91
R2308 VSS.n492 VSS.n68 2450.91
R2309 VSS.n498 VSS.n493 2450.91
R2310 VSS.n493 VSS.n68 2450.91
R2311 VSS.n636 VSS.n635 2450.91
R2312 VSS.n637 VSS.n635 2450.91
R2313 VSS.n642 VSS.n636 2450.91
R2314 VSS.n642 VSS.n637 2450.91
R2315 VSS.n407 VSS.n401 2450.91
R2316 VSS.n401 VSS.n55 2450.91
R2317 VSS.n407 VSS.n402 2450.91
R2318 VSS.n402 VSS.n55 2450.91
R2319 VSS.n730 VSS.n724 2450.91
R2320 VSS.n730 VSS.n725 2450.91
R2321 VSS.n724 VSS.n723 2450.91
R2322 VSS.n725 VSS.n723 2450.91
R2323 VSS.n491 VSS.n485 2450.91
R2324 VSS.n485 VSS.n67 2450.91
R2325 VSS.n491 VSS.n486 2450.91
R2326 VSS.n486 VSS.n67 2450.91
R2327 VSS.n644 VSS.n643 2450.91
R2328 VSS.n645 VSS.n643 2450.91
R2329 VSS.n650 VSS.n644 2450.91
R2330 VSS.n650 VSS.n645 2450.91
R2331 VSS.n414 VSS.n408 2450.91
R2332 VSS.n408 VSS.n56 2450.91
R2333 VSS.n414 VSS.n409 2450.91
R2334 VSS.n409 VSS.n56 2450.91
R2335 VSS.n722 VSS.n716 2450.91
R2336 VSS.n722 VSS.n717 2450.91
R2337 VSS.n716 VSS.n715 2450.91
R2338 VSS.n717 VSS.n715 2450.91
R2339 VSS.n484 VSS.n478 2450.91
R2340 VSS.n478 VSS.n66 2450.91
R2341 VSS.n484 VSS.n479 2450.91
R2342 VSS.n479 VSS.n66 2450.91
R2343 VSS.n652 VSS.n651 2450.91
R2344 VSS.n653 VSS.n651 2450.91
R2345 VSS.n658 VSS.n652 2450.91
R2346 VSS.n658 VSS.n653 2450.91
R2347 VSS.n421 VSS.n415 2450.91
R2348 VSS.n415 VSS.n57 2450.91
R2349 VSS.n421 VSS.n416 2450.91
R2350 VSS.n416 VSS.n57 2450.91
R2351 VSS.n714 VSS.n708 2450.91
R2352 VSS.n714 VSS.n709 2450.91
R2353 VSS.n708 VSS.n707 2450.91
R2354 VSS.n709 VSS.n707 2450.91
R2355 VSS.n477 VSS.n471 2450.91
R2356 VSS.n471 VSS.n65 2450.91
R2357 VSS.n477 VSS.n472 2450.91
R2358 VSS.n472 VSS.n65 2450.91
R2359 VSS.n660 VSS.n659 2450.91
R2360 VSS.n661 VSS.n659 2450.91
R2361 VSS.n666 VSS.n660 2450.91
R2362 VSS.n666 VSS.n661 2450.91
R2363 VSS.n428 VSS.n422 2450.91
R2364 VSS.n422 VSS.n58 2450.91
R2365 VSS.n428 VSS.n423 2450.91
R2366 VSS.n423 VSS.n58 2450.91
R2367 VSS.n706 VSS.n700 2450.91
R2368 VSS.n706 VSS.n701 2450.91
R2369 VSS.n700 VSS.n699 2450.91
R2370 VSS.n701 VSS.n699 2450.91
R2371 VSS.n470 VSS.n464 2450.91
R2372 VSS.n464 VSS.n64 2450.91
R2373 VSS.n470 VSS.n465 2450.91
R2374 VSS.n465 VSS.n64 2450.91
R2375 VSS.n668 VSS.n667 2450.91
R2376 VSS.n669 VSS.n667 2450.91
R2377 VSS.n674 VSS.n668 2450.91
R2378 VSS.n674 VSS.n669 2450.91
R2379 VSS.n435 VSS.n429 2450.91
R2380 VSS.n429 VSS.n59 2450.91
R2381 VSS.n435 VSS.n430 2450.91
R2382 VSS.n430 VSS.n59 2450.91
R2383 VSS.n698 VSS.n692 2450.91
R2384 VSS.n698 VSS.n693 2450.91
R2385 VSS.n692 VSS.n691 2450.91
R2386 VSS.n693 VSS.n691 2450.91
R2387 VSS.n463 VSS.n457 2450.91
R2388 VSS.n457 VSS.n63 2450.91
R2389 VSS.n463 VSS.n458 2450.91
R2390 VSS.n458 VSS.n63 2450.91
R2391 VSS.n676 VSS.n675 2450.91
R2392 VSS.n677 VSS.n675 2450.91
R2393 VSS.n682 VSS.n676 2450.91
R2394 VSS.n682 VSS.n677 2450.91
R2395 VSS.n442 VSS.n436 2450.91
R2396 VSS.n436 VSS.n60 2450.91
R2397 VSS.n442 VSS.n437 2450.91
R2398 VSS.n437 VSS.n60 2450.91
R2399 VSS.n690 VSS.n684 2450.91
R2400 VSS.n690 VSS.n685 2450.91
R2401 VSS.n684 VSS.n683 2450.91
R2402 VSS.n685 VSS.n683 2450.91
R2403 VSS.n456 VSS.n450 2450.91
R2404 VSS.n450 VSS.n62 2450.91
R2405 VSS.n456 VSS.n451 2450.91
R2406 VSS.n451 VSS.n62 2450.91
R2407 VSS.n811 VSS.n43 2450.91
R2408 VSS.n811 VSS.n44 2450.91
R2409 VSS.n815 VSS.n43 2450.91
R2410 VSS.n815 VSS.n44 2450.91
R2411 VSS.n449 VSS.n443 2450.91
R2412 VSS.n443 VSS.n61 2450.91
R2413 VSS.n449 VSS.n444 2450.91
R2414 VSS.n444 VSS.n61 2450.91
R2415 VSS.n1435 VSS.n1434 2320.45
R2416 VSS.n1417 VSS.n1340 2294.47
R2417 VSS.n1413 VSS.n1340 2294.47
R2418 VSS.n1417 VSS.n1341 2294.47
R2419 VSS.n1413 VSS.n1341 2294.47
R2420 VSS.n1424 VSS.n1335 2294.47
R2421 VSS.n1420 VSS.n1335 2294.47
R2422 VSS.n1424 VSS.n1336 2294.47
R2423 VSS.n1420 VSS.n1336 2294.47
R2424 VSS.n1431 VSS.n1331 2294.47
R2425 VSS.n1427 VSS.n1331 2294.47
R2426 VSS.n1431 VSS.n1332 2294.47
R2427 VSS.n1427 VSS.n1332 2294.47
R2428 VSS.n1406 VSS.n1348 2213.35
R2429 VSS.n1410 VSS.n1348 2213.35
R2430 VSS.n1406 VSS.n1349 2213.35
R2431 VSS.n1410 VSS.n1349 2213.35
R2432 VSS.n332 VSS.n111 2068.5
R2433 VSS.n336 VSS.n111 2068.5
R2434 VSS.n332 VSS.n112 2068.5
R2435 VSS.n336 VSS.n112 2068.5
R2436 VSS.n1319 VSS.n850 2068.5
R2437 VSS.n850 VSS.n848 2068.5
R2438 VSS.n120 VSS.n114 2068.5
R2439 VSS.n114 VSS.n80 2068.5
R2440 VSS.n120 VSS.n115 2068.5
R2441 VSS.n115 VSS.n80 2068.5
R2442 VSS.n908 VSS.n10 2068.5
R2443 VSS.n908 VSS.n11 2068.5
R2444 VSS.n330 VSS.n324 2068.5
R2445 VSS.n324 VSS.n110 2068.5
R2446 VSS.n330 VSS.n325 2068.5
R2447 VSS.n325 VSS.n110 2068.5
R2448 VSS.n1305 VSS.n847 2068.5
R2449 VSS.n1305 VSS.n846 2068.5
R2450 VSS.n127 VSS.n121 2068.5
R2451 VSS.n121 VSS.n81 2068.5
R2452 VSS.n127 VSS.n122 2068.5
R2453 VSS.n122 VSS.n81 2068.5
R2454 VSS.n1286 VSS.n12 2068.5
R2455 VSS.n1286 VSS.n13 2068.5
R2456 VSS.n323 VSS.n317 2068.5
R2457 VSS.n317 VSS.n109 2068.5
R2458 VSS.n323 VSS.n318 2068.5
R2459 VSS.n318 VSS.n109 2068.5
R2460 VSS.n1272 VSS.n845 2068.5
R2461 VSS.n1272 VSS.n844 2068.5
R2462 VSS.n134 VSS.n128 2068.5
R2463 VSS.n128 VSS.n82 2068.5
R2464 VSS.n134 VSS.n129 2068.5
R2465 VSS.n129 VSS.n82 2068.5
R2466 VSS.n1258 VSS.n14 2068.5
R2467 VSS.n1258 VSS.n15 2068.5
R2468 VSS.n316 VSS.n310 2068.5
R2469 VSS.n310 VSS.n108 2068.5
R2470 VSS.n316 VSS.n311 2068.5
R2471 VSS.n311 VSS.n108 2068.5
R2472 VSS.n1244 VSS.n843 2068.5
R2473 VSS.n1244 VSS.n842 2068.5
R2474 VSS.n141 VSS.n135 2068.5
R2475 VSS.n135 VSS.n83 2068.5
R2476 VSS.n141 VSS.n136 2068.5
R2477 VSS.n136 VSS.n83 2068.5
R2478 VSS.n1230 VSS.n16 2068.5
R2479 VSS.n1230 VSS.n17 2068.5
R2480 VSS.n309 VSS.n303 2068.5
R2481 VSS.n303 VSS.n107 2068.5
R2482 VSS.n309 VSS.n304 2068.5
R2483 VSS.n304 VSS.n107 2068.5
R2484 VSS.n1216 VSS.n841 2068.5
R2485 VSS.n1216 VSS.n840 2068.5
R2486 VSS.n148 VSS.n142 2068.5
R2487 VSS.n142 VSS.n84 2068.5
R2488 VSS.n148 VSS.n143 2068.5
R2489 VSS.n143 VSS.n84 2068.5
R2490 VSS.n1202 VSS.n18 2068.5
R2491 VSS.n1202 VSS.n19 2068.5
R2492 VSS.n302 VSS.n296 2068.5
R2493 VSS.n296 VSS.n106 2068.5
R2494 VSS.n302 VSS.n297 2068.5
R2495 VSS.n297 VSS.n106 2068.5
R2496 VSS.n1188 VSS.n839 2068.5
R2497 VSS.n1188 VSS.n838 2068.5
R2498 VSS.n155 VSS.n149 2068.5
R2499 VSS.n149 VSS.n85 2068.5
R2500 VSS.n155 VSS.n150 2068.5
R2501 VSS.n150 VSS.n85 2068.5
R2502 VSS.n1174 VSS.n20 2068.5
R2503 VSS.n1174 VSS.n21 2068.5
R2504 VSS.n295 VSS.n289 2068.5
R2505 VSS.n289 VSS.n105 2068.5
R2506 VSS.n295 VSS.n290 2068.5
R2507 VSS.n290 VSS.n105 2068.5
R2508 VSS.n1160 VSS.n837 2068.5
R2509 VSS.n1160 VSS.n836 2068.5
R2510 VSS.n162 VSS.n156 2068.5
R2511 VSS.n156 VSS.n86 2068.5
R2512 VSS.n162 VSS.n157 2068.5
R2513 VSS.n157 VSS.n86 2068.5
R2514 VSS.n1146 VSS.n22 2068.5
R2515 VSS.n1146 VSS.n23 2068.5
R2516 VSS.n288 VSS.n282 2068.5
R2517 VSS.n282 VSS.n104 2068.5
R2518 VSS.n288 VSS.n283 2068.5
R2519 VSS.n283 VSS.n104 2068.5
R2520 VSS.n1132 VSS.n835 2068.5
R2521 VSS.n1132 VSS.n834 2068.5
R2522 VSS.n169 VSS.n163 2068.5
R2523 VSS.n163 VSS.n87 2068.5
R2524 VSS.n169 VSS.n164 2068.5
R2525 VSS.n164 VSS.n87 2068.5
R2526 VSS.n1118 VSS.n24 2068.5
R2527 VSS.n1118 VSS.n25 2068.5
R2528 VSS.n281 VSS.n275 2068.5
R2529 VSS.n275 VSS.n103 2068.5
R2530 VSS.n281 VSS.n276 2068.5
R2531 VSS.n276 VSS.n103 2068.5
R2532 VSS.n1104 VSS.n833 2068.5
R2533 VSS.n1104 VSS.n832 2068.5
R2534 VSS.n176 VSS.n170 2068.5
R2535 VSS.n170 VSS.n88 2068.5
R2536 VSS.n176 VSS.n171 2068.5
R2537 VSS.n171 VSS.n88 2068.5
R2538 VSS.n1090 VSS.n26 2068.5
R2539 VSS.n1090 VSS.n27 2068.5
R2540 VSS.n274 VSS.n268 2068.5
R2541 VSS.n268 VSS.n102 2068.5
R2542 VSS.n274 VSS.n269 2068.5
R2543 VSS.n269 VSS.n102 2068.5
R2544 VSS.n1076 VSS.n831 2068.5
R2545 VSS.n1076 VSS.n830 2068.5
R2546 VSS.n183 VSS.n177 2068.5
R2547 VSS.n177 VSS.n89 2068.5
R2548 VSS.n183 VSS.n178 2068.5
R2549 VSS.n178 VSS.n89 2068.5
R2550 VSS.n1062 VSS.n28 2068.5
R2551 VSS.n1062 VSS.n29 2068.5
R2552 VSS.n267 VSS.n261 2068.5
R2553 VSS.n261 VSS.n101 2068.5
R2554 VSS.n267 VSS.n262 2068.5
R2555 VSS.n262 VSS.n101 2068.5
R2556 VSS.n1048 VSS.n829 2068.5
R2557 VSS.n1048 VSS.n828 2068.5
R2558 VSS.n190 VSS.n184 2068.5
R2559 VSS.n184 VSS.n90 2068.5
R2560 VSS.n190 VSS.n185 2068.5
R2561 VSS.n185 VSS.n90 2068.5
R2562 VSS.n1034 VSS.n30 2068.5
R2563 VSS.n1034 VSS.n31 2068.5
R2564 VSS.n260 VSS.n254 2068.5
R2565 VSS.n254 VSS.n100 2068.5
R2566 VSS.n260 VSS.n255 2068.5
R2567 VSS.n255 VSS.n100 2068.5
R2568 VSS.n1020 VSS.n827 2068.5
R2569 VSS.n1020 VSS.n826 2068.5
R2570 VSS.n197 VSS.n191 2068.5
R2571 VSS.n191 VSS.n91 2068.5
R2572 VSS.n197 VSS.n192 2068.5
R2573 VSS.n192 VSS.n91 2068.5
R2574 VSS.n1006 VSS.n32 2068.5
R2575 VSS.n1006 VSS.n33 2068.5
R2576 VSS.n253 VSS.n247 2068.5
R2577 VSS.n247 VSS.n99 2068.5
R2578 VSS.n253 VSS.n248 2068.5
R2579 VSS.n248 VSS.n99 2068.5
R2580 VSS.n992 VSS.n825 2068.5
R2581 VSS.n992 VSS.n824 2068.5
R2582 VSS.n204 VSS.n198 2068.5
R2583 VSS.n198 VSS.n92 2068.5
R2584 VSS.n204 VSS.n199 2068.5
R2585 VSS.n199 VSS.n92 2068.5
R2586 VSS.n978 VSS.n34 2068.5
R2587 VSS.n978 VSS.n35 2068.5
R2588 VSS.n246 VSS.n240 2068.5
R2589 VSS.n240 VSS.n98 2068.5
R2590 VSS.n246 VSS.n241 2068.5
R2591 VSS.n241 VSS.n98 2068.5
R2592 VSS.n964 VSS.n823 2068.5
R2593 VSS.n964 VSS.n822 2068.5
R2594 VSS.n211 VSS.n205 2068.5
R2595 VSS.n205 VSS.n93 2068.5
R2596 VSS.n211 VSS.n206 2068.5
R2597 VSS.n206 VSS.n93 2068.5
R2598 VSS.n950 VSS.n36 2068.5
R2599 VSS.n950 VSS.n37 2068.5
R2600 VSS.n239 VSS.n233 2068.5
R2601 VSS.n233 VSS.n97 2068.5
R2602 VSS.n239 VSS.n234 2068.5
R2603 VSS.n234 VSS.n97 2068.5
R2604 VSS.n936 VSS.n821 2068.5
R2605 VSS.n936 VSS.n820 2068.5
R2606 VSS.n218 VSS.n212 2068.5
R2607 VSS.n212 VSS.n94 2068.5
R2608 VSS.n218 VSS.n213 2068.5
R2609 VSS.n213 VSS.n94 2068.5
R2610 VSS.n922 VSS.n38 2068.5
R2611 VSS.n922 VSS.n39 2068.5
R2612 VSS.n232 VSS.n226 2068.5
R2613 VSS.n226 VSS.n96 2068.5
R2614 VSS.n232 VSS.n227 2068.5
R2615 VSS.n227 VSS.n96 2068.5
R2616 VSS.n880 VSS.n819 2068.5
R2617 VSS.n880 VSS.n818 2068.5
R2618 VSS.n225 VSS.n219 2068.5
R2619 VSS.n219 VSS.n95 2068.5
R2620 VSS.n225 VSS.n220 2068.5
R2621 VSS.n220 VSS.n95 2068.5
R2622 VSS.n1320 VSS.n5 2068.5
R2623 VSS.n1324 VSS.n5 2068.5
R2624 VSS.n1314 VSS.n848 1778.79
R2625 VSS.n911 VSS.n11 1778.79
R2626 VSS.n901 VSS.n846 1778.79
R2627 VSS.n1289 VSS.n13 1778.79
R2628 VSS.n1275 VSS.n844 1778.79
R2629 VSS.n1261 VSS.n15 1778.79
R2630 VSS.n1247 VSS.n842 1778.79
R2631 VSS.n1233 VSS.n17 1778.79
R2632 VSS.n1219 VSS.n840 1778.79
R2633 VSS.n1205 VSS.n19 1778.79
R2634 VSS.n1191 VSS.n838 1778.79
R2635 VSS.n1177 VSS.n21 1778.79
R2636 VSS.n1163 VSS.n836 1778.79
R2637 VSS.n1149 VSS.n23 1778.79
R2638 VSS.n1135 VSS.n834 1778.79
R2639 VSS.n1121 VSS.n25 1778.79
R2640 VSS.n1107 VSS.n832 1778.79
R2641 VSS.n1093 VSS.n27 1778.79
R2642 VSS.n1079 VSS.n830 1778.79
R2643 VSS.n1065 VSS.n29 1778.79
R2644 VSS.n1051 VSS.n828 1778.79
R2645 VSS.n1037 VSS.n31 1778.79
R2646 VSS.n1023 VSS.n826 1778.79
R2647 VSS.n1009 VSS.n33 1778.79
R2648 VSS.n995 VSS.n824 1778.79
R2649 VSS.n981 VSS.n35 1778.79
R2650 VSS.n967 VSS.n822 1778.79
R2651 VSS.n953 VSS.n37 1778.79
R2652 VSS.n939 VSS.n820 1778.79
R2653 VSS.n925 VSS.n39 1778.79
R2654 VSS.n874 VSS.n818 1778.79
R2655 VSS.n1324 VSS.n4 1778.79
R2656 VSS.n1436 VSS.n1435 1749.69
R2657 VSS.n1326 VSS.n1325 1416.89
R2658 VSS.n1319 VSS.n849 1060.74
R2659 VSS.n915 VSS.n10 1060.74
R2660 VSS.n900 VSS.n847 1060.74
R2661 VSS.n1293 VSS.n12 1060.74
R2662 VSS.n1279 VSS.n845 1060.74
R2663 VSS.n1265 VSS.n14 1060.74
R2664 VSS.n1251 VSS.n843 1060.74
R2665 VSS.n1237 VSS.n16 1060.74
R2666 VSS.n1223 VSS.n841 1060.74
R2667 VSS.n1209 VSS.n18 1060.74
R2668 VSS.n1195 VSS.n839 1060.74
R2669 VSS.n1181 VSS.n20 1060.74
R2670 VSS.n1167 VSS.n837 1060.74
R2671 VSS.n1153 VSS.n22 1060.74
R2672 VSS.n1139 VSS.n835 1060.74
R2673 VSS.n1125 VSS.n24 1060.74
R2674 VSS.n1111 VSS.n833 1060.74
R2675 VSS.n1097 VSS.n26 1060.74
R2676 VSS.n1083 VSS.n831 1060.74
R2677 VSS.n1069 VSS.n28 1060.74
R2678 VSS.n1055 VSS.n829 1060.74
R2679 VSS.n1041 VSS.n30 1060.74
R2680 VSS.n1027 VSS.n827 1060.74
R2681 VSS.n1013 VSS.n32 1060.74
R2682 VSS.n999 VSS.n825 1060.74
R2683 VSS.n985 VSS.n34 1060.74
R2684 VSS.n971 VSS.n823 1060.74
R2685 VSS.n957 VSS.n36 1060.74
R2686 VSS.n943 VSS.n821 1060.74
R2687 VSS.n929 VSS.n38 1060.74
R2688 VSS.n873 VSS.n819 1060.74
R2689 VSS.n1320 VSS.n8 1060.74
R2690 VSS.n1436 VSS.n1327 977.264
R2691 VSS.n1434 VSS.n1433 769.809
R2692 VSS.n1426 VSS.n1425 743.09
R2693 VSS.n1419 VSS.n1418 743.09
R2694 VSS.n1433 VSS.n1432 689.648
R2695 VSS.n1437 VSS.n1436 683.298
R2696 VSS.n1314 VSS.n1313 568.865
R2697 VSS.n911 VSS.n854 568.865
R2698 VSS.n1311 VSS.n901 568.865
R2699 VSS.n1289 VSS.n855 568.865
R2700 VSS.n1275 VSS.n899 568.865
R2701 VSS.n1261 VSS.n856 568.865
R2702 VSS.n1247 VSS.n898 568.865
R2703 VSS.n1233 VSS.n857 568.865
R2704 VSS.n1219 VSS.n897 568.865
R2705 VSS.n1205 VSS.n858 568.865
R2706 VSS.n1191 VSS.n896 568.865
R2707 VSS.n1177 VSS.n859 568.865
R2708 VSS.n1163 VSS.n895 568.865
R2709 VSS.n1149 VSS.n860 568.865
R2710 VSS.n1135 VSS.n894 568.865
R2711 VSS.n1121 VSS.n861 568.865
R2712 VSS.n1107 VSS.n893 568.865
R2713 VSS.n1093 VSS.n862 568.865
R2714 VSS.n1079 VSS.n892 568.865
R2715 VSS.n1065 VSS.n863 568.865
R2716 VSS.n1051 VSS.n891 568.865
R2717 VSS.n1037 VSS.n864 568.865
R2718 VSS.n1023 VSS.n890 568.865
R2719 VSS.n1009 VSS.n865 568.865
R2720 VSS.n995 VSS.n889 568.865
R2721 VSS.n981 VSS.n866 568.865
R2722 VSS.n967 VSS.n888 568.865
R2723 VSS.n953 VSS.n867 568.865
R2724 VSS.n939 VSS.n887 568.865
R2725 VSS.n925 VSS.n868 568.865
R2726 VSS.n886 VSS.n874 568.865
R2727 VSS.n872 VSS.n4 568.865
R2728 VSS.n1382 VSS.n1381 521.067
R2729 VSS.n1390 VSS.n1388 521.067
R2730 VSS.n1398 VSS.n1396 521.067
R2731 VSS.n1405 VSS.n1404 521.067
R2732 VSS.n1438 VSS.n1437 346.894
R2733 VSS.n1401 VSS.n1400 301.93
R2734 VSS.n1402 VSS.n1401 301.93
R2735 VSS.n1393 VSS.n1392 301.93
R2736 VSS.n1394 VSS.n1393 301.93
R2737 VSS.n1385 VSS.n1384 301.93
R2738 VSS.n1386 VSS.n1385 301.93
R2739 VSS.n1378 VSS.n1377 301.93
R2740 VSS.n1379 VSS.n1378 301.93
R2741 VSS.n1402 VSS.n1354 300.8
R2742 VSS.n1394 VSS.n1358 300.8
R2743 VSS.n1386 VSS.n1362 300.8
R2744 VSS.n1379 VSS.n1366 300.8
R2745 VSS.n872 VSS.n871 292.5
R2746 VSS.n1312 VSS.n872 292.5
R2747 VSS.n870 VSS.n8 292.5
R2748 VSS.n853 VSS.n8 292.5
R2749 VSS.n1321 VSS.n1320 292.5
R2750 VSS.n1320 VSS.t61 292.5
R2751 VSS.n221 VSS.n219 292.5
R2752 VSS.n219 VSS.t60 292.5
R2753 VSS.n445 VSS.n443 292.5
R2754 VSS.n443 VSS.t3 292.5
R2755 VSS.n812 VSS.n811 292.5
R2756 VSS.n811 VSS.t1 292.5
R2757 VSS.n882 VSS.n818 292.5
R2758 VSS.t61 VSS.n818 292.5
R2759 VSS.n886 VSS.n885 292.5
R2760 VSS.n1312 VSS.n886 292.5
R2761 VSS.n878 VSS.n873 292.5
R2762 VSS.n873 VSS.n853 292.5
R2763 VSS.n879 VSS.n819 292.5
R2764 VSS.t61 VSS.n819 292.5
R2765 VSS.n230 VSS.n227 292.5
R2766 VSS.n227 VSS.t60 292.5
R2767 VSS.n228 VSS.n226 292.5
R2768 VSS.n226 VSS.t60 292.5
R2769 VSS.n454 VSS.n451 292.5
R2770 VSS.n451 VSS.t3 292.5
R2771 VSS.n452 VSS.n450 292.5
R2772 VSS.n450 VSS.t3 292.5
R2773 VSS.n687 VSS.n683 292.5
R2774 VSS.t1 VSS.n683 292.5
R2775 VSS.n690 VSS.n689 292.5
R2776 VSS.t1 VSS.n690 292.5
R2777 VSS.n924 VSS.n39 292.5
R2778 VSS.t61 VSS.n39 292.5
R2779 VSS.n928 VSS.n868 292.5
R2780 VSS.n1312 VSS.n868 292.5
R2781 VSS.n930 VSS.n929 292.5
R2782 VSS.n929 VSS.n853 292.5
R2783 VSS.n921 VSS.n38 292.5
R2784 VSS.t61 VSS.n38 292.5
R2785 VSS.n216 VSS.n213 292.5
R2786 VSS.n213 VSS.t60 292.5
R2787 VSS.n214 VSS.n212 292.5
R2788 VSS.n212 VSS.t60 292.5
R2789 VSS.n440 VSS.n437 292.5
R2790 VSS.n437 VSS.t3 292.5
R2791 VSS.n438 VSS.n436 292.5
R2792 VSS.n436 VSS.t3 292.5
R2793 VSS.n682 VSS.n681 292.5
R2794 VSS.t1 VSS.n682 292.5
R2795 VSS.n679 VSS.n675 292.5
R2796 VSS.t1 VSS.n675 292.5
R2797 VSS.n938 VSS.n820 292.5
R2798 VSS.t61 VSS.n820 292.5
R2799 VSS.n942 VSS.n887 292.5
R2800 VSS.n1312 VSS.n887 292.5
R2801 VSS.n944 VSS.n943 292.5
R2802 VSS.n943 VSS.n853 292.5
R2803 VSS.n935 VSS.n821 292.5
R2804 VSS.t61 VSS.n821 292.5
R2805 VSS.n237 VSS.n234 292.5
R2806 VSS.n234 VSS.t60 292.5
R2807 VSS.n235 VSS.n233 292.5
R2808 VSS.n233 VSS.t60 292.5
R2809 VSS.n461 VSS.n458 292.5
R2810 VSS.n458 VSS.t3 292.5
R2811 VSS.n459 VSS.n457 292.5
R2812 VSS.n457 VSS.t3 292.5
R2813 VSS.n695 VSS.n691 292.5
R2814 VSS.t1 VSS.n691 292.5
R2815 VSS.n698 VSS.n697 292.5
R2816 VSS.t1 VSS.n698 292.5
R2817 VSS.n952 VSS.n37 292.5
R2818 VSS.t61 VSS.n37 292.5
R2819 VSS.n956 VSS.n867 292.5
R2820 VSS.n1312 VSS.n867 292.5
R2821 VSS.n958 VSS.n957 292.5
R2822 VSS.n957 VSS.n853 292.5
R2823 VSS.n949 VSS.n36 292.5
R2824 VSS.t61 VSS.n36 292.5
R2825 VSS.n209 VSS.n206 292.5
R2826 VSS.n206 VSS.t60 292.5
R2827 VSS.n207 VSS.n205 292.5
R2828 VSS.n205 VSS.t60 292.5
R2829 VSS.n433 VSS.n430 292.5
R2830 VSS.n430 VSS.t3 292.5
R2831 VSS.n431 VSS.n429 292.5
R2832 VSS.n429 VSS.t3 292.5
R2833 VSS.n674 VSS.n673 292.5
R2834 VSS.t1 VSS.n674 292.5
R2835 VSS.n671 VSS.n667 292.5
R2836 VSS.t1 VSS.n667 292.5
R2837 VSS.n966 VSS.n822 292.5
R2838 VSS.t61 VSS.n822 292.5
R2839 VSS.n970 VSS.n888 292.5
R2840 VSS.n1312 VSS.n888 292.5
R2841 VSS.n972 VSS.n971 292.5
R2842 VSS.n971 VSS.n853 292.5
R2843 VSS.n963 VSS.n823 292.5
R2844 VSS.t61 VSS.n823 292.5
R2845 VSS.n244 VSS.n241 292.5
R2846 VSS.n241 VSS.t60 292.5
R2847 VSS.n242 VSS.n240 292.5
R2848 VSS.n240 VSS.t60 292.5
R2849 VSS.n468 VSS.n465 292.5
R2850 VSS.n465 VSS.t3 292.5
R2851 VSS.n466 VSS.n464 292.5
R2852 VSS.n464 VSS.t3 292.5
R2853 VSS.n703 VSS.n699 292.5
R2854 VSS.t1 VSS.n699 292.5
R2855 VSS.n706 VSS.n705 292.5
R2856 VSS.t1 VSS.n706 292.5
R2857 VSS.n980 VSS.n35 292.5
R2858 VSS.t61 VSS.n35 292.5
R2859 VSS.n984 VSS.n866 292.5
R2860 VSS.n1312 VSS.n866 292.5
R2861 VSS.n986 VSS.n985 292.5
R2862 VSS.n985 VSS.n853 292.5
R2863 VSS.n977 VSS.n34 292.5
R2864 VSS.t61 VSS.n34 292.5
R2865 VSS.n202 VSS.n199 292.5
R2866 VSS.n199 VSS.t60 292.5
R2867 VSS.n200 VSS.n198 292.5
R2868 VSS.n198 VSS.t60 292.5
R2869 VSS.n426 VSS.n423 292.5
R2870 VSS.n423 VSS.t3 292.5
R2871 VSS.n424 VSS.n422 292.5
R2872 VSS.n422 VSS.t3 292.5
R2873 VSS.n666 VSS.n665 292.5
R2874 VSS.t1 VSS.n666 292.5
R2875 VSS.n663 VSS.n659 292.5
R2876 VSS.t1 VSS.n659 292.5
R2877 VSS.n994 VSS.n824 292.5
R2878 VSS.t61 VSS.n824 292.5
R2879 VSS.n998 VSS.n889 292.5
R2880 VSS.n1312 VSS.n889 292.5
R2881 VSS.n1000 VSS.n999 292.5
R2882 VSS.n999 VSS.n853 292.5
R2883 VSS.n991 VSS.n825 292.5
R2884 VSS.t61 VSS.n825 292.5
R2885 VSS.n251 VSS.n248 292.5
R2886 VSS.n248 VSS.t60 292.5
R2887 VSS.n249 VSS.n247 292.5
R2888 VSS.n247 VSS.t60 292.5
R2889 VSS.n475 VSS.n472 292.5
R2890 VSS.n472 VSS.t3 292.5
R2891 VSS.n473 VSS.n471 292.5
R2892 VSS.n471 VSS.t3 292.5
R2893 VSS.n711 VSS.n707 292.5
R2894 VSS.t1 VSS.n707 292.5
R2895 VSS.n714 VSS.n713 292.5
R2896 VSS.t1 VSS.n714 292.5
R2897 VSS.n1008 VSS.n33 292.5
R2898 VSS.t61 VSS.n33 292.5
R2899 VSS.n1012 VSS.n865 292.5
R2900 VSS.n1312 VSS.n865 292.5
R2901 VSS.n1014 VSS.n1013 292.5
R2902 VSS.n1013 VSS.n853 292.5
R2903 VSS.n1005 VSS.n32 292.5
R2904 VSS.t61 VSS.n32 292.5
R2905 VSS.n195 VSS.n192 292.5
R2906 VSS.n192 VSS.t60 292.5
R2907 VSS.n193 VSS.n191 292.5
R2908 VSS.n191 VSS.t60 292.5
R2909 VSS.n419 VSS.n416 292.5
R2910 VSS.n416 VSS.t3 292.5
R2911 VSS.n417 VSS.n415 292.5
R2912 VSS.n415 VSS.t3 292.5
R2913 VSS.n658 VSS.n657 292.5
R2914 VSS.t1 VSS.n658 292.5
R2915 VSS.n655 VSS.n651 292.5
R2916 VSS.t1 VSS.n651 292.5
R2917 VSS.n1022 VSS.n826 292.5
R2918 VSS.t61 VSS.n826 292.5
R2919 VSS.n1026 VSS.n890 292.5
R2920 VSS.n1312 VSS.n890 292.5
R2921 VSS.n1028 VSS.n1027 292.5
R2922 VSS.n1027 VSS.n853 292.5
R2923 VSS.n1019 VSS.n827 292.5
R2924 VSS.t61 VSS.n827 292.5
R2925 VSS.n258 VSS.n255 292.5
R2926 VSS.n255 VSS.t60 292.5
R2927 VSS.n256 VSS.n254 292.5
R2928 VSS.n254 VSS.t60 292.5
R2929 VSS.n482 VSS.n479 292.5
R2930 VSS.n479 VSS.t3 292.5
R2931 VSS.n480 VSS.n478 292.5
R2932 VSS.n478 VSS.t3 292.5
R2933 VSS.n719 VSS.n715 292.5
R2934 VSS.t1 VSS.n715 292.5
R2935 VSS.n722 VSS.n721 292.5
R2936 VSS.t1 VSS.n722 292.5
R2937 VSS.n1036 VSS.n31 292.5
R2938 VSS.t61 VSS.n31 292.5
R2939 VSS.n1040 VSS.n864 292.5
R2940 VSS.n1312 VSS.n864 292.5
R2941 VSS.n1042 VSS.n1041 292.5
R2942 VSS.n1041 VSS.n853 292.5
R2943 VSS.n1033 VSS.n30 292.5
R2944 VSS.t61 VSS.n30 292.5
R2945 VSS.n188 VSS.n185 292.5
R2946 VSS.n185 VSS.t60 292.5
R2947 VSS.n186 VSS.n184 292.5
R2948 VSS.n184 VSS.t60 292.5
R2949 VSS.n412 VSS.n409 292.5
R2950 VSS.n409 VSS.t3 292.5
R2951 VSS.n410 VSS.n408 292.5
R2952 VSS.n408 VSS.t3 292.5
R2953 VSS.n650 VSS.n649 292.5
R2954 VSS.t1 VSS.n650 292.5
R2955 VSS.n647 VSS.n643 292.5
R2956 VSS.t1 VSS.n643 292.5
R2957 VSS.n1050 VSS.n828 292.5
R2958 VSS.t61 VSS.n828 292.5
R2959 VSS.n1054 VSS.n891 292.5
R2960 VSS.n1312 VSS.n891 292.5
R2961 VSS.n1056 VSS.n1055 292.5
R2962 VSS.n1055 VSS.n853 292.5
R2963 VSS.n1047 VSS.n829 292.5
R2964 VSS.t61 VSS.n829 292.5
R2965 VSS.n265 VSS.n262 292.5
R2966 VSS.n262 VSS.t60 292.5
R2967 VSS.n263 VSS.n261 292.5
R2968 VSS.n261 VSS.t60 292.5
R2969 VSS.n489 VSS.n486 292.5
R2970 VSS.n486 VSS.t3 292.5
R2971 VSS.n487 VSS.n485 292.5
R2972 VSS.n485 VSS.t3 292.5
R2973 VSS.n727 VSS.n723 292.5
R2974 VSS.t1 VSS.n723 292.5
R2975 VSS.n730 VSS.n729 292.5
R2976 VSS.t1 VSS.n730 292.5
R2977 VSS.n1064 VSS.n29 292.5
R2978 VSS.t61 VSS.n29 292.5
R2979 VSS.n1068 VSS.n863 292.5
R2980 VSS.n1312 VSS.n863 292.5
R2981 VSS.n1070 VSS.n1069 292.5
R2982 VSS.n1069 VSS.n853 292.5
R2983 VSS.n1061 VSS.n28 292.5
R2984 VSS.t61 VSS.n28 292.5
R2985 VSS.n181 VSS.n178 292.5
R2986 VSS.n178 VSS.t60 292.5
R2987 VSS.n179 VSS.n177 292.5
R2988 VSS.n177 VSS.t60 292.5
R2989 VSS.n405 VSS.n402 292.5
R2990 VSS.n402 VSS.t3 292.5
R2991 VSS.n403 VSS.n401 292.5
R2992 VSS.n401 VSS.t3 292.5
R2993 VSS.n642 VSS.n641 292.5
R2994 VSS.t1 VSS.n642 292.5
R2995 VSS.n639 VSS.n635 292.5
R2996 VSS.t1 VSS.n635 292.5
R2997 VSS.n1078 VSS.n830 292.5
R2998 VSS.t61 VSS.n830 292.5
R2999 VSS.n1082 VSS.n892 292.5
R3000 VSS.n1312 VSS.n892 292.5
R3001 VSS.n1084 VSS.n1083 292.5
R3002 VSS.n1083 VSS.n853 292.5
R3003 VSS.n1075 VSS.n831 292.5
R3004 VSS.t61 VSS.n831 292.5
R3005 VSS.n272 VSS.n269 292.5
R3006 VSS.n269 VSS.t60 292.5
R3007 VSS.n270 VSS.n268 292.5
R3008 VSS.n268 VSS.t60 292.5
R3009 VSS.n496 VSS.n493 292.5
R3010 VSS.n493 VSS.t3 292.5
R3011 VSS.n494 VSS.n492 292.5
R3012 VSS.n492 VSS.t3 292.5
R3013 VSS.n735 VSS.n731 292.5
R3014 VSS.t1 VSS.n731 292.5
R3015 VSS.n738 VSS.n737 292.5
R3016 VSS.t1 VSS.n738 292.5
R3017 VSS.n1092 VSS.n27 292.5
R3018 VSS.t61 VSS.n27 292.5
R3019 VSS.n1096 VSS.n862 292.5
R3020 VSS.n1312 VSS.n862 292.5
R3021 VSS.n1098 VSS.n1097 292.5
R3022 VSS.n1097 VSS.n853 292.5
R3023 VSS.n1089 VSS.n26 292.5
R3024 VSS.t61 VSS.n26 292.5
R3025 VSS.n174 VSS.n171 292.5
R3026 VSS.n171 VSS.t60 292.5
R3027 VSS.n172 VSS.n170 292.5
R3028 VSS.n170 VSS.t60 292.5
R3029 VSS.n398 VSS.n395 292.5
R3030 VSS.n395 VSS.t3 292.5
R3031 VSS.n396 VSS.n394 292.5
R3032 VSS.n394 VSS.t3 292.5
R3033 VSS.n634 VSS.n633 292.5
R3034 VSS.t1 VSS.n634 292.5
R3035 VSS.n631 VSS.n627 292.5
R3036 VSS.t1 VSS.n627 292.5
R3037 VSS.n1106 VSS.n832 292.5
R3038 VSS.t61 VSS.n832 292.5
R3039 VSS.n1110 VSS.n893 292.5
R3040 VSS.n1312 VSS.n893 292.5
R3041 VSS.n1112 VSS.n1111 292.5
R3042 VSS.n1111 VSS.n853 292.5
R3043 VSS.n1103 VSS.n833 292.5
R3044 VSS.t61 VSS.n833 292.5
R3045 VSS.n279 VSS.n276 292.5
R3046 VSS.n276 VSS.t60 292.5
R3047 VSS.n277 VSS.n275 292.5
R3048 VSS.n275 VSS.t60 292.5
R3049 VSS.n503 VSS.n500 292.5
R3050 VSS.n500 VSS.t3 292.5
R3051 VSS.n501 VSS.n499 292.5
R3052 VSS.n499 VSS.t3 292.5
R3053 VSS.n743 VSS.n739 292.5
R3054 VSS.t1 VSS.n739 292.5
R3055 VSS.n746 VSS.n745 292.5
R3056 VSS.t1 VSS.n746 292.5
R3057 VSS.n1120 VSS.n25 292.5
R3058 VSS.t61 VSS.n25 292.5
R3059 VSS.n1124 VSS.n861 292.5
R3060 VSS.n1312 VSS.n861 292.5
R3061 VSS.n1126 VSS.n1125 292.5
R3062 VSS.n1125 VSS.n853 292.5
R3063 VSS.n1117 VSS.n24 292.5
R3064 VSS.t61 VSS.n24 292.5
R3065 VSS.n167 VSS.n164 292.5
R3066 VSS.n164 VSS.t60 292.5
R3067 VSS.n165 VSS.n163 292.5
R3068 VSS.n163 VSS.t60 292.5
R3069 VSS.n391 VSS.n388 292.5
R3070 VSS.n388 VSS.t3 292.5
R3071 VSS.n389 VSS.n387 292.5
R3072 VSS.n387 VSS.t3 292.5
R3073 VSS.n626 VSS.n625 292.5
R3074 VSS.t1 VSS.n626 292.5
R3075 VSS.n623 VSS.n619 292.5
R3076 VSS.t1 VSS.n619 292.5
R3077 VSS.n1134 VSS.n834 292.5
R3078 VSS.t61 VSS.n834 292.5
R3079 VSS.n1138 VSS.n894 292.5
R3080 VSS.n1312 VSS.n894 292.5
R3081 VSS.n1140 VSS.n1139 292.5
R3082 VSS.n1139 VSS.n853 292.5
R3083 VSS.n1131 VSS.n835 292.5
R3084 VSS.t61 VSS.n835 292.5
R3085 VSS.n286 VSS.n283 292.5
R3086 VSS.n283 VSS.t60 292.5
R3087 VSS.n284 VSS.n282 292.5
R3088 VSS.n282 VSS.t60 292.5
R3089 VSS.n510 VSS.n507 292.5
R3090 VSS.n507 VSS.t3 292.5
R3091 VSS.n508 VSS.n506 292.5
R3092 VSS.n506 VSS.t3 292.5
R3093 VSS.n751 VSS.n747 292.5
R3094 VSS.t1 VSS.n747 292.5
R3095 VSS.n754 VSS.n753 292.5
R3096 VSS.t1 VSS.n754 292.5
R3097 VSS.n1148 VSS.n23 292.5
R3098 VSS.t61 VSS.n23 292.5
R3099 VSS.n1152 VSS.n860 292.5
R3100 VSS.n1312 VSS.n860 292.5
R3101 VSS.n1154 VSS.n1153 292.5
R3102 VSS.n1153 VSS.n853 292.5
R3103 VSS.n1145 VSS.n22 292.5
R3104 VSS.t61 VSS.n22 292.5
R3105 VSS.n160 VSS.n157 292.5
R3106 VSS.n157 VSS.t60 292.5
R3107 VSS.n158 VSS.n156 292.5
R3108 VSS.n156 VSS.t60 292.5
R3109 VSS.n384 VSS.n381 292.5
R3110 VSS.n381 VSS.t3 292.5
R3111 VSS.n382 VSS.n380 292.5
R3112 VSS.n380 VSS.t3 292.5
R3113 VSS.n618 VSS.n617 292.5
R3114 VSS.t1 VSS.n618 292.5
R3115 VSS.n615 VSS.n611 292.5
R3116 VSS.t1 VSS.n611 292.5
R3117 VSS.n1162 VSS.n836 292.5
R3118 VSS.t61 VSS.n836 292.5
R3119 VSS.n1166 VSS.n895 292.5
R3120 VSS.n1312 VSS.n895 292.5
R3121 VSS.n1168 VSS.n1167 292.5
R3122 VSS.n1167 VSS.n853 292.5
R3123 VSS.n1159 VSS.n837 292.5
R3124 VSS.t61 VSS.n837 292.5
R3125 VSS.n293 VSS.n290 292.5
R3126 VSS.n290 VSS.t60 292.5
R3127 VSS.n291 VSS.n289 292.5
R3128 VSS.n289 VSS.t60 292.5
R3129 VSS.n517 VSS.n514 292.5
R3130 VSS.n514 VSS.t3 292.5
R3131 VSS.n515 VSS.n513 292.5
R3132 VSS.n513 VSS.t3 292.5
R3133 VSS.n759 VSS.n755 292.5
R3134 VSS.t1 VSS.n755 292.5
R3135 VSS.n762 VSS.n761 292.5
R3136 VSS.t1 VSS.n762 292.5
R3137 VSS.n1176 VSS.n21 292.5
R3138 VSS.t61 VSS.n21 292.5
R3139 VSS.n1180 VSS.n859 292.5
R3140 VSS.n1312 VSS.n859 292.5
R3141 VSS.n1182 VSS.n1181 292.5
R3142 VSS.n1181 VSS.n853 292.5
R3143 VSS.n1173 VSS.n20 292.5
R3144 VSS.t61 VSS.n20 292.5
R3145 VSS.n153 VSS.n150 292.5
R3146 VSS.n150 VSS.t60 292.5
R3147 VSS.n151 VSS.n149 292.5
R3148 VSS.n149 VSS.t60 292.5
R3149 VSS.n377 VSS.n374 292.5
R3150 VSS.n374 VSS.t3 292.5
R3151 VSS.n375 VSS.n373 292.5
R3152 VSS.n373 VSS.t3 292.5
R3153 VSS.n610 VSS.n609 292.5
R3154 VSS.t1 VSS.n610 292.5
R3155 VSS.n607 VSS.n603 292.5
R3156 VSS.t1 VSS.n603 292.5
R3157 VSS.n1190 VSS.n838 292.5
R3158 VSS.t61 VSS.n838 292.5
R3159 VSS.n1194 VSS.n896 292.5
R3160 VSS.n1312 VSS.n896 292.5
R3161 VSS.n1196 VSS.n1195 292.5
R3162 VSS.n1195 VSS.n853 292.5
R3163 VSS.n1187 VSS.n839 292.5
R3164 VSS.t61 VSS.n839 292.5
R3165 VSS.n300 VSS.n297 292.5
R3166 VSS.n297 VSS.t60 292.5
R3167 VSS.n298 VSS.n296 292.5
R3168 VSS.n296 VSS.t60 292.5
R3169 VSS.n524 VSS.n521 292.5
R3170 VSS.n521 VSS.t3 292.5
R3171 VSS.n522 VSS.n520 292.5
R3172 VSS.n520 VSS.t3 292.5
R3173 VSS.n767 VSS.n763 292.5
R3174 VSS.t1 VSS.n763 292.5
R3175 VSS.n770 VSS.n769 292.5
R3176 VSS.t1 VSS.n770 292.5
R3177 VSS.n1204 VSS.n19 292.5
R3178 VSS.t61 VSS.n19 292.5
R3179 VSS.n1208 VSS.n858 292.5
R3180 VSS.n1312 VSS.n858 292.5
R3181 VSS.n1210 VSS.n1209 292.5
R3182 VSS.n1209 VSS.n853 292.5
R3183 VSS.n1201 VSS.n18 292.5
R3184 VSS.t61 VSS.n18 292.5
R3185 VSS.n146 VSS.n143 292.5
R3186 VSS.n143 VSS.t60 292.5
R3187 VSS.n144 VSS.n142 292.5
R3188 VSS.n142 VSS.t60 292.5
R3189 VSS.n370 VSS.n367 292.5
R3190 VSS.n367 VSS.t3 292.5
R3191 VSS.n368 VSS.n366 292.5
R3192 VSS.n366 VSS.t3 292.5
R3193 VSS.n602 VSS.n601 292.5
R3194 VSS.t1 VSS.n602 292.5
R3195 VSS.n599 VSS.n595 292.5
R3196 VSS.t1 VSS.n595 292.5
R3197 VSS.n1218 VSS.n840 292.5
R3198 VSS.t61 VSS.n840 292.5
R3199 VSS.n1222 VSS.n897 292.5
R3200 VSS.n1312 VSS.n897 292.5
R3201 VSS.n1224 VSS.n1223 292.5
R3202 VSS.n1223 VSS.n853 292.5
R3203 VSS.n1215 VSS.n841 292.5
R3204 VSS.t61 VSS.n841 292.5
R3205 VSS.n307 VSS.n304 292.5
R3206 VSS.n304 VSS.t60 292.5
R3207 VSS.n305 VSS.n303 292.5
R3208 VSS.n303 VSS.t60 292.5
R3209 VSS.n531 VSS.n528 292.5
R3210 VSS.n528 VSS.t3 292.5
R3211 VSS.n529 VSS.n527 292.5
R3212 VSS.n527 VSS.t3 292.5
R3213 VSS.n775 VSS.n771 292.5
R3214 VSS.t1 VSS.n771 292.5
R3215 VSS.n778 VSS.n777 292.5
R3216 VSS.t1 VSS.n778 292.5
R3217 VSS.n1232 VSS.n17 292.5
R3218 VSS.t61 VSS.n17 292.5
R3219 VSS.n1236 VSS.n857 292.5
R3220 VSS.n1312 VSS.n857 292.5
R3221 VSS.n1238 VSS.n1237 292.5
R3222 VSS.n1237 VSS.n853 292.5
R3223 VSS.n1229 VSS.n16 292.5
R3224 VSS.t61 VSS.n16 292.5
R3225 VSS.n139 VSS.n136 292.5
R3226 VSS.n136 VSS.t60 292.5
R3227 VSS.n137 VSS.n135 292.5
R3228 VSS.n135 VSS.t60 292.5
R3229 VSS.n363 VSS.n360 292.5
R3230 VSS.n360 VSS.t3 292.5
R3231 VSS.n361 VSS.n359 292.5
R3232 VSS.n359 VSS.t3 292.5
R3233 VSS.n594 VSS.n593 292.5
R3234 VSS.t1 VSS.n594 292.5
R3235 VSS.n591 VSS.n587 292.5
R3236 VSS.t1 VSS.n587 292.5
R3237 VSS.n1246 VSS.n842 292.5
R3238 VSS.t61 VSS.n842 292.5
R3239 VSS.n1250 VSS.n898 292.5
R3240 VSS.n1312 VSS.n898 292.5
R3241 VSS.n1252 VSS.n1251 292.5
R3242 VSS.n1251 VSS.n853 292.5
R3243 VSS.n1243 VSS.n843 292.5
R3244 VSS.t61 VSS.n843 292.5
R3245 VSS.n314 VSS.n311 292.5
R3246 VSS.n311 VSS.t60 292.5
R3247 VSS.n312 VSS.n310 292.5
R3248 VSS.n310 VSS.t60 292.5
R3249 VSS.n538 VSS.n535 292.5
R3250 VSS.n535 VSS.t3 292.5
R3251 VSS.n536 VSS.n534 292.5
R3252 VSS.n534 VSS.t3 292.5
R3253 VSS.n783 VSS.n779 292.5
R3254 VSS.t1 VSS.n779 292.5
R3255 VSS.n786 VSS.n785 292.5
R3256 VSS.t1 VSS.n786 292.5
R3257 VSS.n1260 VSS.n15 292.5
R3258 VSS.t61 VSS.n15 292.5
R3259 VSS.n1264 VSS.n856 292.5
R3260 VSS.n1312 VSS.n856 292.5
R3261 VSS.n1266 VSS.n1265 292.5
R3262 VSS.n1265 VSS.n853 292.5
R3263 VSS.n1257 VSS.n14 292.5
R3264 VSS.t61 VSS.n14 292.5
R3265 VSS.n132 VSS.n129 292.5
R3266 VSS.n129 VSS.t60 292.5
R3267 VSS.n130 VSS.n128 292.5
R3268 VSS.n128 VSS.t60 292.5
R3269 VSS.n356 VSS.n353 292.5
R3270 VSS.n353 VSS.t3 292.5
R3271 VSS.n354 VSS.n352 292.5
R3272 VSS.n352 VSS.t3 292.5
R3273 VSS.n586 VSS.n585 292.5
R3274 VSS.t1 VSS.n586 292.5
R3275 VSS.n583 VSS.n579 292.5
R3276 VSS.t1 VSS.n579 292.5
R3277 VSS.n1274 VSS.n844 292.5
R3278 VSS.t61 VSS.n844 292.5
R3279 VSS.n1278 VSS.n899 292.5
R3280 VSS.n1312 VSS.n899 292.5
R3281 VSS.n1280 VSS.n1279 292.5
R3282 VSS.n1279 VSS.n853 292.5
R3283 VSS.n1271 VSS.n845 292.5
R3284 VSS.t61 VSS.n845 292.5
R3285 VSS.n321 VSS.n318 292.5
R3286 VSS.n318 VSS.t60 292.5
R3287 VSS.n319 VSS.n317 292.5
R3288 VSS.n317 VSS.t60 292.5
R3289 VSS.n545 VSS.n542 292.5
R3290 VSS.n542 VSS.t3 292.5
R3291 VSS.n543 VSS.n541 292.5
R3292 VSS.n541 VSS.t3 292.5
R3293 VSS.n791 VSS.n787 292.5
R3294 VSS.t1 VSS.n787 292.5
R3295 VSS.n794 VSS.n793 292.5
R3296 VSS.t1 VSS.n794 292.5
R3297 VSS.n1288 VSS.n13 292.5
R3298 VSS.t61 VSS.n13 292.5
R3299 VSS.n1292 VSS.n855 292.5
R3300 VSS.n1312 VSS.n855 292.5
R3301 VSS.n1294 VSS.n1293 292.5
R3302 VSS.n1293 VSS.n853 292.5
R3303 VSS.n1285 VSS.n12 292.5
R3304 VSS.t61 VSS.n12 292.5
R3305 VSS.n125 VSS.n122 292.5
R3306 VSS.n122 VSS.t60 292.5
R3307 VSS.n123 VSS.n121 292.5
R3308 VSS.n121 VSS.t60 292.5
R3309 VSS.n349 VSS.n346 292.5
R3310 VSS.n346 VSS.t3 292.5
R3311 VSS.n347 VSS.n345 292.5
R3312 VSS.n345 VSS.t3 292.5
R3313 VSS.n578 VSS.n577 292.5
R3314 VSS.t1 VSS.n578 292.5
R3315 VSS.n575 VSS.n571 292.5
R3316 VSS.t1 VSS.n571 292.5
R3317 VSS.n1307 VSS.n846 292.5
R3318 VSS.t61 VSS.n846 292.5
R3319 VSS.n1311 VSS.n1310 292.5
R3320 VSS.n1312 VSS.n1311 292.5
R3321 VSS.n1303 VSS.n900 292.5
R3322 VSS.n900 VSS.n853 292.5
R3323 VSS.n1304 VSS.n847 292.5
R3324 VSS.t61 VSS.n847 292.5
R3325 VSS.n328 VSS.n325 292.5
R3326 VSS.n325 VSS.t60 292.5
R3327 VSS.n326 VSS.n324 292.5
R3328 VSS.n324 VSS.t60 292.5
R3329 VSS.n552 VSS.n549 292.5
R3330 VSS.n549 VSS.t3 292.5
R3331 VSS.n550 VSS.n548 292.5
R3332 VSS.n548 VSS.t3 292.5
R3333 VSS.n799 VSS.n795 292.5
R3334 VSS.t1 VSS.n795 292.5
R3335 VSS.n802 VSS.n801 292.5
R3336 VSS.t1 VSS.n802 292.5
R3337 VSS.n910 VSS.n11 292.5
R3338 VSS.t61 VSS.n11 292.5
R3339 VSS.n914 VSS.n854 292.5
R3340 VSS.n1312 VSS.n854 292.5
R3341 VSS.n916 VSS.n915 292.5
R3342 VSS.n915 VSS.n853 292.5
R3343 VSS.n907 VSS.n10 292.5
R3344 VSS.t61 VSS.n10 292.5
R3345 VSS.n118 VSS.n115 292.5
R3346 VSS.n115 VSS.t60 292.5
R3347 VSS.n116 VSS.n114 292.5
R3348 VSS.n114 VSS.t60 292.5
R3349 VSS.n342 VSS.n339 292.5
R3350 VSS.n339 VSS.t3 292.5
R3351 VSS.n340 VSS.n338 292.5
R3352 VSS.n338 VSS.t3 292.5
R3353 VSS.n570 VSS.n569 292.5
R3354 VSS.t1 VSS.n570 292.5
R3355 VSS.n567 VSS.n563 292.5
R3356 VSS.t1 VSS.n563 292.5
R3357 VSS.n1316 VSS.n848 292.5
R3358 VSS.t61 VSS.n848 292.5
R3359 VSS.n1313 VSS.n852 292.5
R3360 VSS.n1313 VSS.n1312 292.5
R3361 VSS.n902 VSS.n849 292.5
R3362 VSS.n853 VSS.n849 292.5
R3363 VSS.n1319 VSS.n1318 292.5
R3364 VSS.t61 VSS.n1319 292.5
R3365 VSS.n334 VSS.n112 292.5
R3366 VSS.n112 VSS.t60 292.5
R3367 VSS.n113 VSS.n111 292.5
R3368 VSS.n111 VSS.t60 292.5
R3369 VSS.n558 VSS.n78 292.5
R3370 VSS.n78 VSS.t3 292.5
R3371 VSS.n79 VSS.n77 292.5
R3372 VSS.n77 VSS.t3 292.5
R3373 VSS.n807 VSS.n803 292.5
R3374 VSS.t1 VSS.n803 292.5
R3375 VSS.n810 VSS.n809 292.5
R3376 VSS.t1 VSS.n810 292.5
R3377 VSS.n1324 VSS.n1323 292.5
R3378 VSS.n1325 VSS.n1324 292.5
R3379 VSS.n223 VSS.n220 292.5
R3380 VSS.n220 VSS.n3 292.5
R3381 VSS.n447 VSS.n444 292.5
R3382 VSS.n444 VSS.n42 292.5
R3383 VSS.n815 VSS.n814 292.5
R3384 VSS.n816 VSS.n815 292.5
R3385 VSS.n1429 VSS.n1332 292.5
R3386 VSS.n1332 VSS.t63 292.5
R3387 VSS.n1334 VSS.n1331 292.5
R3388 VSS.n1331 VSS.t63 292.5
R3389 VSS.n1422 VSS.n1336 292.5
R3390 VSS.n1336 VSS.t5 292.5
R3391 VSS.n1338 VSS.n1335 292.5
R3392 VSS.n1335 VSS.t5 292.5
R3393 VSS.n1415 VSS.n1341 292.5
R3394 VSS.t0 VSS.n1341 292.5
R3395 VSS.n1347 VSS.n1340 292.5
R3396 VSS.t0 VSS.n1340 292.5
R3397 VSS.n1378 VSS.n1365 292.5
R3398 VSS.n1365 VSS.t78 292.5
R3399 VSS.n1366 VSS.n1364 292.5
R3400 VSS.n1364 VSS.t78 292.5
R3401 VSS.n1385 VSS.n1361 292.5
R3402 VSS.n1361 VSS.t71 292.5
R3403 VSS.n1362 VSS.n1360 292.5
R3404 VSS.n1360 VSS.t71 292.5
R3405 VSS.n1393 VSS.n1357 292.5
R3406 VSS.n1357 VSS.t76 292.5
R3407 VSS.n1358 VSS.n1356 292.5
R3408 VSS.n1356 VSS.t76 292.5
R3409 VSS.n1401 VSS.n1353 292.5
R3410 VSS.n1353 VSS.t62 292.5
R3411 VSS.n1354 VSS.n1352 292.5
R3412 VSS.n1352 VSS.t62 292.5
R3413 VSS.n1408 VSS.n1349 292.5
R3414 VSS.n1349 VSS.t74 292.5
R3415 VSS.n1350 VSS.n1348 292.5
R3416 VSS.n1348 VSS.t74 292.5
R3417 VSS.n1400 VSS.n1355 241.319
R3418 VSS.n1392 VSS.n1359 241.319
R3419 VSS.n1384 VSS.n1363 241.319
R3420 VSS.n1377 VSS.n1375 241.319
R3421 VSS.n1432 VSS.t63 201.042
R3422 VSS.n1425 VSS.t5 201.042
R3423 VSS.n1419 VSS.t5 201.042
R3424 VSS.n1412 VSS.t0 201.042
R3425 VSS.n6 VSS.n4 195
R3426 VSS.n9 VSS.n4 195
R3427 VSS.n883 VSS.n874 195
R3428 VSS.n874 VSS.n9 195
R3429 VSS.n926 VSS.n925 195
R3430 VSS.n925 VSS.n9 195
R3431 VSS.n940 VSS.n939 195
R3432 VSS.n939 VSS.n9 195
R3433 VSS.n954 VSS.n953 195
R3434 VSS.n953 VSS.n9 195
R3435 VSS.n968 VSS.n967 195
R3436 VSS.n967 VSS.n9 195
R3437 VSS.n982 VSS.n981 195
R3438 VSS.n981 VSS.n9 195
R3439 VSS.n996 VSS.n995 195
R3440 VSS.n995 VSS.n9 195
R3441 VSS.n1010 VSS.n1009 195
R3442 VSS.n1009 VSS.n9 195
R3443 VSS.n1024 VSS.n1023 195
R3444 VSS.n1023 VSS.n9 195
R3445 VSS.n1038 VSS.n1037 195
R3446 VSS.n1037 VSS.n9 195
R3447 VSS.n1052 VSS.n1051 195
R3448 VSS.n1051 VSS.n9 195
R3449 VSS.n1066 VSS.n1065 195
R3450 VSS.n1065 VSS.n9 195
R3451 VSS.n1080 VSS.n1079 195
R3452 VSS.n1079 VSS.n9 195
R3453 VSS.n1094 VSS.n1093 195
R3454 VSS.n1093 VSS.n9 195
R3455 VSS.n1108 VSS.n1107 195
R3456 VSS.n1107 VSS.n9 195
R3457 VSS.n1122 VSS.n1121 195
R3458 VSS.n1121 VSS.n9 195
R3459 VSS.n1136 VSS.n1135 195
R3460 VSS.n1135 VSS.n9 195
R3461 VSS.n1150 VSS.n1149 195
R3462 VSS.n1149 VSS.n9 195
R3463 VSS.n1164 VSS.n1163 195
R3464 VSS.n1163 VSS.n9 195
R3465 VSS.n1178 VSS.n1177 195
R3466 VSS.n1177 VSS.n9 195
R3467 VSS.n1192 VSS.n1191 195
R3468 VSS.n1191 VSS.n9 195
R3469 VSS.n1206 VSS.n1205 195
R3470 VSS.n1205 VSS.n9 195
R3471 VSS.n1220 VSS.n1219 195
R3472 VSS.n1219 VSS.n9 195
R3473 VSS.n1234 VSS.n1233 195
R3474 VSS.n1233 VSS.n9 195
R3475 VSS.n1248 VSS.n1247 195
R3476 VSS.n1247 VSS.n9 195
R3477 VSS.n1262 VSS.n1261 195
R3478 VSS.n1261 VSS.n9 195
R3479 VSS.n1276 VSS.n1275 195
R3480 VSS.n1275 VSS.n9 195
R3481 VSS.n1290 VSS.n1289 195
R3482 VSS.n1289 VSS.n9 195
R3483 VSS.n1308 VSS.n901 195
R3484 VSS.n901 VSS.n9 195
R3485 VSS.n912 VSS.n911 195
R3486 VSS.n911 VSS.n9 195
R3487 VSS.n1315 VSS.n1314 195
R3488 VSS.n1314 VSS.n9 195
R3489 VSS.n1418 VSS.n1339 176.865
R3490 VSS.t78 VSS.n1329 170.101
R3491 VSS.n1381 VSS.t78 170.101
R3492 VSS.n1388 VSS.t71 170.101
R3493 VSS.n1396 VSS.t76 170.101
R3494 VSS.n1404 VSS.t62 170.101
R3495 VSS.n1405 VSS.t74 170.101
R3496 VSS.n1411 VSS.t74 170.101
R3497 VSS.n809 VSS.n806 159.248
R3498 VSS.n809 VSS.n808 159.248
R3499 VSS.n807 VSS.n806 159.248
R3500 VSS.n808 VSS.n807 159.248
R3501 VSS.n557 VSS.n79 159.248
R3502 VSS.n559 VSS.n79 159.248
R3503 VSS.n558 VSS.n557 159.248
R3504 VSS.n559 VSS.n558 159.248
R3505 VSS.n567 VSS.n566 159.248
R3506 VSS.n568 VSS.n567 159.248
R3507 VSS.n569 VSS.n566 159.248
R3508 VSS.n569 VSS.n568 159.248
R3509 VSS.n343 VSS.n340 159.248
R3510 VSS.n341 VSS.n340 159.248
R3511 VSS.n343 VSS.n342 159.248
R3512 VSS.n342 VSS.n341 159.248
R3513 VSS.n801 VSS.n798 159.248
R3514 VSS.n801 VSS.n800 159.248
R3515 VSS.n799 VSS.n798 159.248
R3516 VSS.n800 VSS.n799 159.248
R3517 VSS.n553 VSS.n550 159.248
R3518 VSS.n551 VSS.n550 159.248
R3519 VSS.n553 VSS.n552 159.248
R3520 VSS.n552 VSS.n551 159.248
R3521 VSS.n575 VSS.n574 159.248
R3522 VSS.n576 VSS.n575 159.248
R3523 VSS.n577 VSS.n574 159.248
R3524 VSS.n577 VSS.n576 159.248
R3525 VSS.n350 VSS.n347 159.248
R3526 VSS.n348 VSS.n347 159.248
R3527 VSS.n350 VSS.n349 159.248
R3528 VSS.n349 VSS.n348 159.248
R3529 VSS.n793 VSS.n790 159.248
R3530 VSS.n793 VSS.n792 159.248
R3531 VSS.n791 VSS.n790 159.248
R3532 VSS.n792 VSS.n791 159.248
R3533 VSS.n546 VSS.n543 159.248
R3534 VSS.n544 VSS.n543 159.248
R3535 VSS.n546 VSS.n545 159.248
R3536 VSS.n545 VSS.n544 159.248
R3537 VSS.n583 VSS.n582 159.248
R3538 VSS.n584 VSS.n583 159.248
R3539 VSS.n585 VSS.n582 159.248
R3540 VSS.n585 VSS.n584 159.248
R3541 VSS.n357 VSS.n354 159.248
R3542 VSS.n355 VSS.n354 159.248
R3543 VSS.n357 VSS.n356 159.248
R3544 VSS.n356 VSS.n355 159.248
R3545 VSS.n785 VSS.n782 159.248
R3546 VSS.n785 VSS.n784 159.248
R3547 VSS.n783 VSS.n782 159.248
R3548 VSS.n784 VSS.n783 159.248
R3549 VSS.n539 VSS.n536 159.248
R3550 VSS.n537 VSS.n536 159.248
R3551 VSS.n539 VSS.n538 159.248
R3552 VSS.n538 VSS.n537 159.248
R3553 VSS.n591 VSS.n590 159.248
R3554 VSS.n592 VSS.n591 159.248
R3555 VSS.n593 VSS.n590 159.248
R3556 VSS.n593 VSS.n592 159.248
R3557 VSS.n364 VSS.n361 159.248
R3558 VSS.n362 VSS.n361 159.248
R3559 VSS.n364 VSS.n363 159.248
R3560 VSS.n363 VSS.n362 159.248
R3561 VSS.n777 VSS.n774 159.248
R3562 VSS.n777 VSS.n776 159.248
R3563 VSS.n775 VSS.n774 159.248
R3564 VSS.n776 VSS.n775 159.248
R3565 VSS.n532 VSS.n529 159.248
R3566 VSS.n530 VSS.n529 159.248
R3567 VSS.n532 VSS.n531 159.248
R3568 VSS.n531 VSS.n530 159.248
R3569 VSS.n599 VSS.n598 159.248
R3570 VSS.n600 VSS.n599 159.248
R3571 VSS.n601 VSS.n598 159.248
R3572 VSS.n601 VSS.n600 159.248
R3573 VSS.n371 VSS.n368 159.248
R3574 VSS.n369 VSS.n368 159.248
R3575 VSS.n371 VSS.n370 159.248
R3576 VSS.n370 VSS.n369 159.248
R3577 VSS.n769 VSS.n766 159.248
R3578 VSS.n769 VSS.n768 159.248
R3579 VSS.n767 VSS.n766 159.248
R3580 VSS.n768 VSS.n767 159.248
R3581 VSS.n525 VSS.n522 159.248
R3582 VSS.n523 VSS.n522 159.248
R3583 VSS.n525 VSS.n524 159.248
R3584 VSS.n524 VSS.n523 159.248
R3585 VSS.n607 VSS.n606 159.248
R3586 VSS.n608 VSS.n607 159.248
R3587 VSS.n609 VSS.n606 159.248
R3588 VSS.n609 VSS.n608 159.248
R3589 VSS.n378 VSS.n375 159.248
R3590 VSS.n376 VSS.n375 159.248
R3591 VSS.n378 VSS.n377 159.248
R3592 VSS.n377 VSS.n376 159.248
R3593 VSS.n761 VSS.n758 159.248
R3594 VSS.n761 VSS.n760 159.248
R3595 VSS.n759 VSS.n758 159.248
R3596 VSS.n760 VSS.n759 159.248
R3597 VSS.n518 VSS.n515 159.248
R3598 VSS.n516 VSS.n515 159.248
R3599 VSS.n518 VSS.n517 159.248
R3600 VSS.n517 VSS.n516 159.248
R3601 VSS.n615 VSS.n614 159.248
R3602 VSS.n616 VSS.n615 159.248
R3603 VSS.n617 VSS.n614 159.248
R3604 VSS.n617 VSS.n616 159.248
R3605 VSS.n385 VSS.n382 159.248
R3606 VSS.n383 VSS.n382 159.248
R3607 VSS.n385 VSS.n384 159.248
R3608 VSS.n384 VSS.n383 159.248
R3609 VSS.n753 VSS.n750 159.248
R3610 VSS.n753 VSS.n752 159.248
R3611 VSS.n751 VSS.n750 159.248
R3612 VSS.n752 VSS.n751 159.248
R3613 VSS.n511 VSS.n508 159.248
R3614 VSS.n509 VSS.n508 159.248
R3615 VSS.n511 VSS.n510 159.248
R3616 VSS.n510 VSS.n509 159.248
R3617 VSS.n623 VSS.n622 159.248
R3618 VSS.n624 VSS.n623 159.248
R3619 VSS.n625 VSS.n622 159.248
R3620 VSS.n625 VSS.n624 159.248
R3621 VSS.n392 VSS.n389 159.248
R3622 VSS.n390 VSS.n389 159.248
R3623 VSS.n392 VSS.n391 159.248
R3624 VSS.n391 VSS.n390 159.248
R3625 VSS.n745 VSS.n742 159.248
R3626 VSS.n745 VSS.n744 159.248
R3627 VSS.n743 VSS.n742 159.248
R3628 VSS.n744 VSS.n743 159.248
R3629 VSS.n504 VSS.n501 159.248
R3630 VSS.n502 VSS.n501 159.248
R3631 VSS.n504 VSS.n503 159.248
R3632 VSS.n503 VSS.n502 159.248
R3633 VSS.n631 VSS.n630 159.248
R3634 VSS.n632 VSS.n631 159.248
R3635 VSS.n633 VSS.n630 159.248
R3636 VSS.n633 VSS.n632 159.248
R3637 VSS.n399 VSS.n396 159.248
R3638 VSS.n397 VSS.n396 159.248
R3639 VSS.n399 VSS.n398 159.248
R3640 VSS.n398 VSS.n397 159.248
R3641 VSS.n737 VSS.n734 159.248
R3642 VSS.n737 VSS.n736 159.248
R3643 VSS.n735 VSS.n734 159.248
R3644 VSS.n736 VSS.n735 159.248
R3645 VSS.n497 VSS.n494 159.248
R3646 VSS.n495 VSS.n494 159.248
R3647 VSS.n497 VSS.n496 159.248
R3648 VSS.n496 VSS.n495 159.248
R3649 VSS.n639 VSS.n638 159.248
R3650 VSS.n640 VSS.n639 159.248
R3651 VSS.n641 VSS.n638 159.248
R3652 VSS.n641 VSS.n640 159.248
R3653 VSS.n406 VSS.n403 159.248
R3654 VSS.n404 VSS.n403 159.248
R3655 VSS.n406 VSS.n405 159.248
R3656 VSS.n405 VSS.n404 159.248
R3657 VSS.n729 VSS.n726 159.248
R3658 VSS.n729 VSS.n728 159.248
R3659 VSS.n727 VSS.n726 159.248
R3660 VSS.n728 VSS.n727 159.248
R3661 VSS.n490 VSS.n487 159.248
R3662 VSS.n488 VSS.n487 159.248
R3663 VSS.n490 VSS.n489 159.248
R3664 VSS.n489 VSS.n488 159.248
R3665 VSS.n647 VSS.n646 159.248
R3666 VSS.n648 VSS.n647 159.248
R3667 VSS.n649 VSS.n646 159.248
R3668 VSS.n649 VSS.n648 159.248
R3669 VSS.n413 VSS.n410 159.248
R3670 VSS.n411 VSS.n410 159.248
R3671 VSS.n413 VSS.n412 159.248
R3672 VSS.n412 VSS.n411 159.248
R3673 VSS.n721 VSS.n718 159.248
R3674 VSS.n721 VSS.n720 159.248
R3675 VSS.n719 VSS.n718 159.248
R3676 VSS.n720 VSS.n719 159.248
R3677 VSS.n483 VSS.n480 159.248
R3678 VSS.n481 VSS.n480 159.248
R3679 VSS.n483 VSS.n482 159.248
R3680 VSS.n482 VSS.n481 159.248
R3681 VSS.n655 VSS.n654 159.248
R3682 VSS.n656 VSS.n655 159.248
R3683 VSS.n657 VSS.n654 159.248
R3684 VSS.n657 VSS.n656 159.248
R3685 VSS.n420 VSS.n417 159.248
R3686 VSS.n418 VSS.n417 159.248
R3687 VSS.n420 VSS.n419 159.248
R3688 VSS.n419 VSS.n418 159.248
R3689 VSS.n713 VSS.n710 159.248
R3690 VSS.n713 VSS.n712 159.248
R3691 VSS.n711 VSS.n710 159.248
R3692 VSS.n712 VSS.n711 159.248
R3693 VSS.n476 VSS.n473 159.248
R3694 VSS.n474 VSS.n473 159.248
R3695 VSS.n476 VSS.n475 159.248
R3696 VSS.n475 VSS.n474 159.248
R3697 VSS.n663 VSS.n662 159.248
R3698 VSS.n664 VSS.n663 159.248
R3699 VSS.n665 VSS.n662 159.248
R3700 VSS.n665 VSS.n664 159.248
R3701 VSS.n427 VSS.n424 159.248
R3702 VSS.n425 VSS.n424 159.248
R3703 VSS.n427 VSS.n426 159.248
R3704 VSS.n426 VSS.n425 159.248
R3705 VSS.n705 VSS.n702 159.248
R3706 VSS.n705 VSS.n704 159.248
R3707 VSS.n703 VSS.n702 159.248
R3708 VSS.n704 VSS.n703 159.248
R3709 VSS.n469 VSS.n466 159.248
R3710 VSS.n467 VSS.n466 159.248
R3711 VSS.n469 VSS.n468 159.248
R3712 VSS.n468 VSS.n467 159.248
R3713 VSS.n671 VSS.n670 159.248
R3714 VSS.n672 VSS.n671 159.248
R3715 VSS.n673 VSS.n670 159.248
R3716 VSS.n673 VSS.n672 159.248
R3717 VSS.n434 VSS.n431 159.248
R3718 VSS.n432 VSS.n431 159.248
R3719 VSS.n434 VSS.n433 159.248
R3720 VSS.n433 VSS.n432 159.248
R3721 VSS.n697 VSS.n694 159.248
R3722 VSS.n697 VSS.n696 159.248
R3723 VSS.n695 VSS.n694 159.248
R3724 VSS.n696 VSS.n695 159.248
R3725 VSS.n462 VSS.n459 159.248
R3726 VSS.n460 VSS.n459 159.248
R3727 VSS.n462 VSS.n461 159.248
R3728 VSS.n461 VSS.n460 159.248
R3729 VSS.n679 VSS.n678 159.248
R3730 VSS.n680 VSS.n679 159.248
R3731 VSS.n681 VSS.n678 159.248
R3732 VSS.n681 VSS.n680 159.248
R3733 VSS.n441 VSS.n438 159.248
R3734 VSS.n439 VSS.n438 159.248
R3735 VSS.n441 VSS.n440 159.248
R3736 VSS.n440 VSS.n439 159.248
R3737 VSS.n689 VSS.n686 159.248
R3738 VSS.n689 VSS.n688 159.248
R3739 VSS.n687 VSS.n686 159.248
R3740 VSS.n688 VSS.n687 159.248
R3741 VSS.n455 VSS.n452 159.248
R3742 VSS.n453 VSS.n452 159.248
R3743 VSS.n455 VSS.n454 159.248
R3744 VSS.n454 VSS.n453 159.248
R3745 VSS.n812 VSS.n45 159.248
R3746 VSS.n813 VSS.n812 159.248
R3747 VSS.n814 VSS.n45 159.248
R3748 VSS.n814 VSS.n813 159.248
R3749 VSS.n448 VSS.n445 159.248
R3750 VSS.n446 VSS.n445 159.248
R3751 VSS.n448 VSS.n447 159.248
R3752 VSS.n447 VSS.n446 159.248
R3753 VSS.n1415 VSS.n1414 149.083
R3754 VSS.n1416 VSS.n1415 149.083
R3755 VSS.n1422 VSS.n1421 149.083
R3756 VSS.n1423 VSS.n1422 149.083
R3757 VSS.n1430 VSS.n1429 149.083
R3758 VSS.n1429 VSS.n1428 149.083
R3759 VSS.n1428 VSS.n1334 147.953
R3760 VSS.n1414 VSS.n1347 147.953
R3761 VSS.n1421 VSS.n1338 147.953
R3762 VSS.n1322 VSS.n5 146.25
R3763 VSS.n40 VSS.n5 146.25
R3764 VSS.n222 VSS.n95 146.25
R3765 VSS.n337 VSS.n95 146.25
R3766 VSS.n225 VSS.n224 146.25
R3767 VSS.n331 VSS.n225 146.25
R3768 VSS.n881 VSS.n880 146.25
R3769 VSS.n880 VSS.n40 146.25
R3770 VSS.n229 VSS.n96 146.25
R3771 VSS.n337 VSS.n96 146.25
R3772 VSS.n232 VSS.n231 146.25
R3773 VSS.n331 VSS.n232 146.25
R3774 VSS.n923 VSS.n922 146.25
R3775 VSS.n922 VSS.n40 146.25
R3776 VSS.n215 VSS.n94 146.25
R3777 VSS.n337 VSS.n94 146.25
R3778 VSS.n218 VSS.n217 146.25
R3779 VSS.n331 VSS.n218 146.25
R3780 VSS.n937 VSS.n936 146.25
R3781 VSS.n936 VSS.n40 146.25
R3782 VSS.n236 VSS.n97 146.25
R3783 VSS.n337 VSS.n97 146.25
R3784 VSS.n239 VSS.n238 146.25
R3785 VSS.n331 VSS.n239 146.25
R3786 VSS.n951 VSS.n950 146.25
R3787 VSS.n950 VSS.n40 146.25
R3788 VSS.n208 VSS.n93 146.25
R3789 VSS.n337 VSS.n93 146.25
R3790 VSS.n211 VSS.n210 146.25
R3791 VSS.n331 VSS.n211 146.25
R3792 VSS.n965 VSS.n964 146.25
R3793 VSS.n964 VSS.n40 146.25
R3794 VSS.n243 VSS.n98 146.25
R3795 VSS.n337 VSS.n98 146.25
R3796 VSS.n246 VSS.n245 146.25
R3797 VSS.n331 VSS.n246 146.25
R3798 VSS.n979 VSS.n978 146.25
R3799 VSS.n978 VSS.n40 146.25
R3800 VSS.n201 VSS.n92 146.25
R3801 VSS.n337 VSS.n92 146.25
R3802 VSS.n204 VSS.n203 146.25
R3803 VSS.n331 VSS.n204 146.25
R3804 VSS.n993 VSS.n992 146.25
R3805 VSS.n992 VSS.n40 146.25
R3806 VSS.n250 VSS.n99 146.25
R3807 VSS.n337 VSS.n99 146.25
R3808 VSS.n253 VSS.n252 146.25
R3809 VSS.n331 VSS.n253 146.25
R3810 VSS.n1007 VSS.n1006 146.25
R3811 VSS.n1006 VSS.n40 146.25
R3812 VSS.n194 VSS.n91 146.25
R3813 VSS.n337 VSS.n91 146.25
R3814 VSS.n197 VSS.n196 146.25
R3815 VSS.n331 VSS.n197 146.25
R3816 VSS.n1021 VSS.n1020 146.25
R3817 VSS.n1020 VSS.n40 146.25
R3818 VSS.n257 VSS.n100 146.25
R3819 VSS.n337 VSS.n100 146.25
R3820 VSS.n260 VSS.n259 146.25
R3821 VSS.n331 VSS.n260 146.25
R3822 VSS.n1035 VSS.n1034 146.25
R3823 VSS.n1034 VSS.n40 146.25
R3824 VSS.n187 VSS.n90 146.25
R3825 VSS.n337 VSS.n90 146.25
R3826 VSS.n190 VSS.n189 146.25
R3827 VSS.n331 VSS.n190 146.25
R3828 VSS.n1049 VSS.n1048 146.25
R3829 VSS.n1048 VSS.n40 146.25
R3830 VSS.n264 VSS.n101 146.25
R3831 VSS.n337 VSS.n101 146.25
R3832 VSS.n267 VSS.n266 146.25
R3833 VSS.n331 VSS.n267 146.25
R3834 VSS.n1063 VSS.n1062 146.25
R3835 VSS.n1062 VSS.n40 146.25
R3836 VSS.n180 VSS.n89 146.25
R3837 VSS.n337 VSS.n89 146.25
R3838 VSS.n183 VSS.n182 146.25
R3839 VSS.n331 VSS.n183 146.25
R3840 VSS.n1077 VSS.n1076 146.25
R3841 VSS.n1076 VSS.n40 146.25
R3842 VSS.n271 VSS.n102 146.25
R3843 VSS.n337 VSS.n102 146.25
R3844 VSS.n274 VSS.n273 146.25
R3845 VSS.n331 VSS.n274 146.25
R3846 VSS.n1091 VSS.n1090 146.25
R3847 VSS.n1090 VSS.n40 146.25
R3848 VSS.n173 VSS.n88 146.25
R3849 VSS.n337 VSS.n88 146.25
R3850 VSS.n176 VSS.n175 146.25
R3851 VSS.n331 VSS.n176 146.25
R3852 VSS.n1105 VSS.n1104 146.25
R3853 VSS.n1104 VSS.n40 146.25
R3854 VSS.n278 VSS.n103 146.25
R3855 VSS.n337 VSS.n103 146.25
R3856 VSS.n281 VSS.n280 146.25
R3857 VSS.n331 VSS.n281 146.25
R3858 VSS.n1119 VSS.n1118 146.25
R3859 VSS.n1118 VSS.n40 146.25
R3860 VSS.n166 VSS.n87 146.25
R3861 VSS.n337 VSS.n87 146.25
R3862 VSS.n169 VSS.n168 146.25
R3863 VSS.n331 VSS.n169 146.25
R3864 VSS.n1133 VSS.n1132 146.25
R3865 VSS.n1132 VSS.n40 146.25
R3866 VSS.n285 VSS.n104 146.25
R3867 VSS.n337 VSS.n104 146.25
R3868 VSS.n288 VSS.n287 146.25
R3869 VSS.n331 VSS.n288 146.25
R3870 VSS.n1147 VSS.n1146 146.25
R3871 VSS.n1146 VSS.n40 146.25
R3872 VSS.n159 VSS.n86 146.25
R3873 VSS.n337 VSS.n86 146.25
R3874 VSS.n162 VSS.n161 146.25
R3875 VSS.n331 VSS.n162 146.25
R3876 VSS.n1161 VSS.n1160 146.25
R3877 VSS.n1160 VSS.n40 146.25
R3878 VSS.n292 VSS.n105 146.25
R3879 VSS.n337 VSS.n105 146.25
R3880 VSS.n295 VSS.n294 146.25
R3881 VSS.n331 VSS.n295 146.25
R3882 VSS.n1175 VSS.n1174 146.25
R3883 VSS.n1174 VSS.n40 146.25
R3884 VSS.n152 VSS.n85 146.25
R3885 VSS.n337 VSS.n85 146.25
R3886 VSS.n155 VSS.n154 146.25
R3887 VSS.n331 VSS.n155 146.25
R3888 VSS.n1189 VSS.n1188 146.25
R3889 VSS.n1188 VSS.n40 146.25
R3890 VSS.n299 VSS.n106 146.25
R3891 VSS.n337 VSS.n106 146.25
R3892 VSS.n302 VSS.n301 146.25
R3893 VSS.n331 VSS.n302 146.25
R3894 VSS.n1203 VSS.n1202 146.25
R3895 VSS.n1202 VSS.n40 146.25
R3896 VSS.n145 VSS.n84 146.25
R3897 VSS.n337 VSS.n84 146.25
R3898 VSS.n148 VSS.n147 146.25
R3899 VSS.n331 VSS.n148 146.25
R3900 VSS.n1217 VSS.n1216 146.25
R3901 VSS.n1216 VSS.n40 146.25
R3902 VSS.n306 VSS.n107 146.25
R3903 VSS.n337 VSS.n107 146.25
R3904 VSS.n309 VSS.n308 146.25
R3905 VSS.n331 VSS.n309 146.25
R3906 VSS.n1231 VSS.n1230 146.25
R3907 VSS.n1230 VSS.n40 146.25
R3908 VSS.n138 VSS.n83 146.25
R3909 VSS.n337 VSS.n83 146.25
R3910 VSS.n141 VSS.n140 146.25
R3911 VSS.n331 VSS.n141 146.25
R3912 VSS.n1245 VSS.n1244 146.25
R3913 VSS.n1244 VSS.n40 146.25
R3914 VSS.n313 VSS.n108 146.25
R3915 VSS.n337 VSS.n108 146.25
R3916 VSS.n316 VSS.n315 146.25
R3917 VSS.n331 VSS.n316 146.25
R3918 VSS.n1259 VSS.n1258 146.25
R3919 VSS.n1258 VSS.n40 146.25
R3920 VSS.n131 VSS.n82 146.25
R3921 VSS.n337 VSS.n82 146.25
R3922 VSS.n134 VSS.n133 146.25
R3923 VSS.n331 VSS.n134 146.25
R3924 VSS.n1273 VSS.n1272 146.25
R3925 VSS.n1272 VSS.n40 146.25
R3926 VSS.n320 VSS.n109 146.25
R3927 VSS.n337 VSS.n109 146.25
R3928 VSS.n323 VSS.n322 146.25
R3929 VSS.n331 VSS.n323 146.25
R3930 VSS.n1287 VSS.n1286 146.25
R3931 VSS.n1286 VSS.n40 146.25
R3932 VSS.n124 VSS.n81 146.25
R3933 VSS.n337 VSS.n81 146.25
R3934 VSS.n127 VSS.n126 146.25
R3935 VSS.n331 VSS.n127 146.25
R3936 VSS.n1306 VSS.n1305 146.25
R3937 VSS.n1305 VSS.n40 146.25
R3938 VSS.n327 VSS.n110 146.25
R3939 VSS.n337 VSS.n110 146.25
R3940 VSS.n330 VSS.n329 146.25
R3941 VSS.n331 VSS.n330 146.25
R3942 VSS.n909 VSS.n908 146.25
R3943 VSS.n908 VSS.n40 146.25
R3944 VSS.n117 VSS.n80 146.25
R3945 VSS.n337 VSS.n80 146.25
R3946 VSS.n120 VSS.n119 146.25
R3947 VSS.n331 VSS.n120 146.25
R3948 VSS.n1317 VSS.n850 146.25
R3949 VSS.n850 VSS.n40 146.25
R3950 VSS.n336 VSS.n335 146.25
R3951 VSS.n337 VSS.n336 146.25
R3952 VSS.n333 VSS.n332 146.25
R3953 VSS.n332 VSS.n331 146.25
R3954 VSS.n1409 VSS.n1408 143.812
R3955 VSS.n1408 VSS.n1407 143.812
R3956 VSS.n1409 VSS.n1350 142.683
R3957 VSS.n333 VSS.n113 134.4
R3958 VSS.n335 VSS.n113 134.4
R3959 VSS.n334 VSS.n333 134.4
R3960 VSS.n335 VSS.n334 134.4
R3961 VSS.n1318 VSS.n1317 134.4
R3962 VSS.n1317 VSS.n1316 134.4
R3963 VSS.n119 VSS.n116 134.4
R3964 VSS.n117 VSS.n116 134.4
R3965 VSS.n119 VSS.n118 134.4
R3966 VSS.n118 VSS.n117 134.4
R3967 VSS.n909 VSS.n907 134.4
R3968 VSS.n910 VSS.n909 134.4
R3969 VSS.n329 VSS.n326 134.4
R3970 VSS.n327 VSS.n326 134.4
R3971 VSS.n329 VSS.n328 134.4
R3972 VSS.n328 VSS.n327 134.4
R3973 VSS.n1306 VSS.n1304 134.4
R3974 VSS.n1307 VSS.n1306 134.4
R3975 VSS.n126 VSS.n123 134.4
R3976 VSS.n124 VSS.n123 134.4
R3977 VSS.n126 VSS.n125 134.4
R3978 VSS.n125 VSS.n124 134.4
R3979 VSS.n1287 VSS.n1285 134.4
R3980 VSS.n1288 VSS.n1287 134.4
R3981 VSS.n322 VSS.n319 134.4
R3982 VSS.n320 VSS.n319 134.4
R3983 VSS.n322 VSS.n321 134.4
R3984 VSS.n321 VSS.n320 134.4
R3985 VSS.n1273 VSS.n1271 134.4
R3986 VSS.n1274 VSS.n1273 134.4
R3987 VSS.n133 VSS.n130 134.4
R3988 VSS.n131 VSS.n130 134.4
R3989 VSS.n133 VSS.n132 134.4
R3990 VSS.n132 VSS.n131 134.4
R3991 VSS.n1259 VSS.n1257 134.4
R3992 VSS.n1260 VSS.n1259 134.4
R3993 VSS.n315 VSS.n312 134.4
R3994 VSS.n313 VSS.n312 134.4
R3995 VSS.n315 VSS.n314 134.4
R3996 VSS.n314 VSS.n313 134.4
R3997 VSS.n1245 VSS.n1243 134.4
R3998 VSS.n1246 VSS.n1245 134.4
R3999 VSS.n140 VSS.n137 134.4
R4000 VSS.n138 VSS.n137 134.4
R4001 VSS.n140 VSS.n139 134.4
R4002 VSS.n139 VSS.n138 134.4
R4003 VSS.n1231 VSS.n1229 134.4
R4004 VSS.n1232 VSS.n1231 134.4
R4005 VSS.n308 VSS.n305 134.4
R4006 VSS.n306 VSS.n305 134.4
R4007 VSS.n308 VSS.n307 134.4
R4008 VSS.n307 VSS.n306 134.4
R4009 VSS.n1217 VSS.n1215 134.4
R4010 VSS.n1218 VSS.n1217 134.4
R4011 VSS.n147 VSS.n144 134.4
R4012 VSS.n145 VSS.n144 134.4
R4013 VSS.n147 VSS.n146 134.4
R4014 VSS.n146 VSS.n145 134.4
R4015 VSS.n1203 VSS.n1201 134.4
R4016 VSS.n1204 VSS.n1203 134.4
R4017 VSS.n301 VSS.n298 134.4
R4018 VSS.n299 VSS.n298 134.4
R4019 VSS.n301 VSS.n300 134.4
R4020 VSS.n300 VSS.n299 134.4
R4021 VSS.n1189 VSS.n1187 134.4
R4022 VSS.n1190 VSS.n1189 134.4
R4023 VSS.n154 VSS.n151 134.4
R4024 VSS.n152 VSS.n151 134.4
R4025 VSS.n154 VSS.n153 134.4
R4026 VSS.n153 VSS.n152 134.4
R4027 VSS.n1175 VSS.n1173 134.4
R4028 VSS.n1176 VSS.n1175 134.4
R4029 VSS.n294 VSS.n291 134.4
R4030 VSS.n292 VSS.n291 134.4
R4031 VSS.n294 VSS.n293 134.4
R4032 VSS.n293 VSS.n292 134.4
R4033 VSS.n1161 VSS.n1159 134.4
R4034 VSS.n1162 VSS.n1161 134.4
R4035 VSS.n161 VSS.n158 134.4
R4036 VSS.n159 VSS.n158 134.4
R4037 VSS.n161 VSS.n160 134.4
R4038 VSS.n160 VSS.n159 134.4
R4039 VSS.n1147 VSS.n1145 134.4
R4040 VSS.n1148 VSS.n1147 134.4
R4041 VSS.n287 VSS.n284 134.4
R4042 VSS.n285 VSS.n284 134.4
R4043 VSS.n287 VSS.n286 134.4
R4044 VSS.n286 VSS.n285 134.4
R4045 VSS.n1133 VSS.n1131 134.4
R4046 VSS.n1134 VSS.n1133 134.4
R4047 VSS.n168 VSS.n165 134.4
R4048 VSS.n166 VSS.n165 134.4
R4049 VSS.n168 VSS.n167 134.4
R4050 VSS.n167 VSS.n166 134.4
R4051 VSS.n1119 VSS.n1117 134.4
R4052 VSS.n1120 VSS.n1119 134.4
R4053 VSS.n280 VSS.n277 134.4
R4054 VSS.n278 VSS.n277 134.4
R4055 VSS.n280 VSS.n279 134.4
R4056 VSS.n279 VSS.n278 134.4
R4057 VSS.n1105 VSS.n1103 134.4
R4058 VSS.n1106 VSS.n1105 134.4
R4059 VSS.n175 VSS.n172 134.4
R4060 VSS.n173 VSS.n172 134.4
R4061 VSS.n175 VSS.n174 134.4
R4062 VSS.n174 VSS.n173 134.4
R4063 VSS.n1091 VSS.n1089 134.4
R4064 VSS.n1092 VSS.n1091 134.4
R4065 VSS.n273 VSS.n270 134.4
R4066 VSS.n271 VSS.n270 134.4
R4067 VSS.n273 VSS.n272 134.4
R4068 VSS.n272 VSS.n271 134.4
R4069 VSS.n1077 VSS.n1075 134.4
R4070 VSS.n1078 VSS.n1077 134.4
R4071 VSS.n182 VSS.n179 134.4
R4072 VSS.n180 VSS.n179 134.4
R4073 VSS.n182 VSS.n181 134.4
R4074 VSS.n181 VSS.n180 134.4
R4075 VSS.n1063 VSS.n1061 134.4
R4076 VSS.n1064 VSS.n1063 134.4
R4077 VSS.n266 VSS.n263 134.4
R4078 VSS.n264 VSS.n263 134.4
R4079 VSS.n266 VSS.n265 134.4
R4080 VSS.n265 VSS.n264 134.4
R4081 VSS.n1049 VSS.n1047 134.4
R4082 VSS.n1050 VSS.n1049 134.4
R4083 VSS.n189 VSS.n186 134.4
R4084 VSS.n187 VSS.n186 134.4
R4085 VSS.n189 VSS.n188 134.4
R4086 VSS.n188 VSS.n187 134.4
R4087 VSS.n1035 VSS.n1033 134.4
R4088 VSS.n1036 VSS.n1035 134.4
R4089 VSS.n259 VSS.n256 134.4
R4090 VSS.n257 VSS.n256 134.4
R4091 VSS.n259 VSS.n258 134.4
R4092 VSS.n258 VSS.n257 134.4
R4093 VSS.n1021 VSS.n1019 134.4
R4094 VSS.n1022 VSS.n1021 134.4
R4095 VSS.n196 VSS.n193 134.4
R4096 VSS.n194 VSS.n193 134.4
R4097 VSS.n196 VSS.n195 134.4
R4098 VSS.n195 VSS.n194 134.4
R4099 VSS.n1007 VSS.n1005 134.4
R4100 VSS.n1008 VSS.n1007 134.4
R4101 VSS.n252 VSS.n249 134.4
R4102 VSS.n250 VSS.n249 134.4
R4103 VSS.n252 VSS.n251 134.4
R4104 VSS.n251 VSS.n250 134.4
R4105 VSS.n993 VSS.n991 134.4
R4106 VSS.n994 VSS.n993 134.4
R4107 VSS.n203 VSS.n200 134.4
R4108 VSS.n201 VSS.n200 134.4
R4109 VSS.n203 VSS.n202 134.4
R4110 VSS.n202 VSS.n201 134.4
R4111 VSS.n979 VSS.n977 134.4
R4112 VSS.n980 VSS.n979 134.4
R4113 VSS.n245 VSS.n242 134.4
R4114 VSS.n243 VSS.n242 134.4
R4115 VSS.n245 VSS.n244 134.4
R4116 VSS.n244 VSS.n243 134.4
R4117 VSS.n965 VSS.n963 134.4
R4118 VSS.n966 VSS.n965 134.4
R4119 VSS.n210 VSS.n207 134.4
R4120 VSS.n208 VSS.n207 134.4
R4121 VSS.n210 VSS.n209 134.4
R4122 VSS.n209 VSS.n208 134.4
R4123 VSS.n951 VSS.n949 134.4
R4124 VSS.n952 VSS.n951 134.4
R4125 VSS.n238 VSS.n235 134.4
R4126 VSS.n236 VSS.n235 134.4
R4127 VSS.n238 VSS.n237 134.4
R4128 VSS.n237 VSS.n236 134.4
R4129 VSS.n937 VSS.n935 134.4
R4130 VSS.n938 VSS.n937 134.4
R4131 VSS.n217 VSS.n214 134.4
R4132 VSS.n215 VSS.n214 134.4
R4133 VSS.n217 VSS.n216 134.4
R4134 VSS.n216 VSS.n215 134.4
R4135 VSS.n923 VSS.n921 134.4
R4136 VSS.n924 VSS.n923 134.4
R4137 VSS.n231 VSS.n228 134.4
R4138 VSS.n229 VSS.n228 134.4
R4139 VSS.n231 VSS.n230 134.4
R4140 VSS.n230 VSS.n229 134.4
R4141 VSS.n881 VSS.n879 134.4
R4142 VSS.n882 VSS.n881 134.4
R4143 VSS.n224 VSS.n221 134.4
R4144 VSS.n222 VSS.n221 134.4
R4145 VSS.n224 VSS.n223 134.4
R4146 VSS.n223 VSS.n222 134.4
R4147 VSS.n1322 VSS.n1321 134.4
R4148 VSS.n1323 VSS.n1322 134.4
R4149 VSS.n1368 VSS.t75 127.397
R4150 VSS.t63 VSS.n1328 127.242
R4151 VSS.n1428 VSS.n1427 117.001
R4152 VSS.n1427 VSS.n1426 117.001
R4153 VSS.n1431 VSS.n1430 117.001
R4154 VSS.n1432 VSS.n1431 117.001
R4155 VSS.n1421 VSS.n1420 117.001
R4156 VSS.n1420 VSS.n1419 117.001
R4157 VSS.n1424 VSS.n1423 117.001
R4158 VSS.n1425 VSS.n1424 117.001
R4159 VSS.n1414 VSS.n1413 117.001
R4160 VSS.n1413 VSS.n1412 117.001
R4161 VSS.n1417 VSS.n1416 117.001
R4162 VSS.n1418 VSS.n1417 117.001
R4163 VSS.n1410 VSS.n1409 117.001
R4164 VSS.n1411 VSS.n1410 117.001
R4165 VSS.n1407 VSS.n1406 117.001
R4166 VSS.n1406 VSS.n1405 117.001
R4167 VSS.n1316 VSS.n1315 115.576
R4168 VSS.n912 VSS.n910 115.576
R4169 VSS.n1308 VSS.n1307 115.576
R4170 VSS.n1290 VSS.n1288 115.576
R4171 VSS.n1276 VSS.n1274 115.576
R4172 VSS.n1262 VSS.n1260 115.576
R4173 VSS.n1248 VSS.n1246 115.576
R4174 VSS.n1234 VSS.n1232 115.576
R4175 VSS.n1220 VSS.n1218 115.576
R4176 VSS.n1206 VSS.n1204 115.576
R4177 VSS.n1192 VSS.n1190 115.576
R4178 VSS.n1178 VSS.n1176 115.576
R4179 VSS.n1164 VSS.n1162 115.576
R4180 VSS.n1150 VSS.n1148 115.576
R4181 VSS.n1136 VSS.n1134 115.576
R4182 VSS.n1122 VSS.n1120 115.576
R4183 VSS.n1108 VSS.n1106 115.576
R4184 VSS.n1094 VSS.n1092 115.576
R4185 VSS.n1080 VSS.n1078 115.576
R4186 VSS.n1066 VSS.n1064 115.576
R4187 VSS.n1052 VSS.n1050 115.576
R4188 VSS.n1038 VSS.n1036 115.576
R4189 VSS.n1024 VSS.n1022 115.576
R4190 VSS.n1010 VSS.n1008 115.576
R4191 VSS.n996 VSS.n994 115.576
R4192 VSS.n982 VSS.n980 115.576
R4193 VSS.n968 VSS.n966 115.576
R4194 VSS.n954 VSS.n952 115.576
R4195 VSS.n940 VSS.n938 115.576
R4196 VSS.n926 VSS.n924 115.576
R4197 VSS.n883 VSS.n882 115.576
R4198 VSS.n1323 VSS.n6 115.576
R4199 VSS.t71 VSS.n1330 107.659
R4200 VSS.n1389 VSS.t76 107.659
R4201 VSS.n1397 VSS.t62 107.659
R4202 VSS.n446 VSS.n61 97.5005
R4203 VSS.n561 VSS.n61 97.5005
R4204 VSS.n449 VSS.n448 97.5005
R4205 VSS.n555 VSS.n449 97.5005
R4206 VSS.n813 VSS.n44 97.5005
R4207 VSS.n44 VSS.n41 97.5005
R4208 VSS.n45 VSS.n43 97.5005
R4209 VSS.n562 VSS.n43 97.5005
R4210 VSS.n453 VSS.n62 97.5005
R4211 VSS.n561 VSS.n62 97.5005
R4212 VSS.n456 VSS.n455 97.5005
R4213 VSS.n555 VSS.n456 97.5005
R4214 VSS.n688 VSS.n685 97.5005
R4215 VSS.n685 VSS.n41 97.5005
R4216 VSS.n686 VSS.n684 97.5005
R4217 VSS.n684 VSS.n562 97.5005
R4218 VSS.n439 VSS.n60 97.5005
R4219 VSS.n561 VSS.n60 97.5005
R4220 VSS.n442 VSS.n441 97.5005
R4221 VSS.n555 VSS.n442 97.5005
R4222 VSS.n680 VSS.n677 97.5005
R4223 VSS.n677 VSS.n41 97.5005
R4224 VSS.n678 VSS.n676 97.5005
R4225 VSS.n676 VSS.n562 97.5005
R4226 VSS.n460 VSS.n63 97.5005
R4227 VSS.n561 VSS.n63 97.5005
R4228 VSS.n463 VSS.n462 97.5005
R4229 VSS.n555 VSS.n463 97.5005
R4230 VSS.n696 VSS.n693 97.5005
R4231 VSS.n693 VSS.n41 97.5005
R4232 VSS.n694 VSS.n692 97.5005
R4233 VSS.n692 VSS.n562 97.5005
R4234 VSS.n432 VSS.n59 97.5005
R4235 VSS.n561 VSS.n59 97.5005
R4236 VSS.n435 VSS.n434 97.5005
R4237 VSS.n555 VSS.n435 97.5005
R4238 VSS.n672 VSS.n669 97.5005
R4239 VSS.n669 VSS.n41 97.5005
R4240 VSS.n670 VSS.n668 97.5005
R4241 VSS.n668 VSS.n562 97.5005
R4242 VSS.n467 VSS.n64 97.5005
R4243 VSS.n561 VSS.n64 97.5005
R4244 VSS.n470 VSS.n469 97.5005
R4245 VSS.n555 VSS.n470 97.5005
R4246 VSS.n704 VSS.n701 97.5005
R4247 VSS.n701 VSS.n41 97.5005
R4248 VSS.n702 VSS.n700 97.5005
R4249 VSS.n700 VSS.n562 97.5005
R4250 VSS.n425 VSS.n58 97.5005
R4251 VSS.n561 VSS.n58 97.5005
R4252 VSS.n428 VSS.n427 97.5005
R4253 VSS.n555 VSS.n428 97.5005
R4254 VSS.n664 VSS.n661 97.5005
R4255 VSS.n661 VSS.n41 97.5005
R4256 VSS.n662 VSS.n660 97.5005
R4257 VSS.n660 VSS.n562 97.5005
R4258 VSS.n474 VSS.n65 97.5005
R4259 VSS.n561 VSS.n65 97.5005
R4260 VSS.n477 VSS.n476 97.5005
R4261 VSS.n555 VSS.n477 97.5005
R4262 VSS.n712 VSS.n709 97.5005
R4263 VSS.n709 VSS.n41 97.5005
R4264 VSS.n710 VSS.n708 97.5005
R4265 VSS.n708 VSS.n562 97.5005
R4266 VSS.n418 VSS.n57 97.5005
R4267 VSS.n561 VSS.n57 97.5005
R4268 VSS.n421 VSS.n420 97.5005
R4269 VSS.n555 VSS.n421 97.5005
R4270 VSS.n656 VSS.n653 97.5005
R4271 VSS.n653 VSS.n41 97.5005
R4272 VSS.n654 VSS.n652 97.5005
R4273 VSS.n652 VSS.n562 97.5005
R4274 VSS.n481 VSS.n66 97.5005
R4275 VSS.n561 VSS.n66 97.5005
R4276 VSS.n484 VSS.n483 97.5005
R4277 VSS.n555 VSS.n484 97.5005
R4278 VSS.n720 VSS.n717 97.5005
R4279 VSS.n717 VSS.n41 97.5005
R4280 VSS.n718 VSS.n716 97.5005
R4281 VSS.n716 VSS.n562 97.5005
R4282 VSS.n411 VSS.n56 97.5005
R4283 VSS.n561 VSS.n56 97.5005
R4284 VSS.n414 VSS.n413 97.5005
R4285 VSS.n555 VSS.n414 97.5005
R4286 VSS.n648 VSS.n645 97.5005
R4287 VSS.n645 VSS.n41 97.5005
R4288 VSS.n646 VSS.n644 97.5005
R4289 VSS.n644 VSS.n562 97.5005
R4290 VSS.n488 VSS.n67 97.5005
R4291 VSS.n561 VSS.n67 97.5005
R4292 VSS.n491 VSS.n490 97.5005
R4293 VSS.n555 VSS.n491 97.5005
R4294 VSS.n728 VSS.n725 97.5005
R4295 VSS.n725 VSS.n41 97.5005
R4296 VSS.n726 VSS.n724 97.5005
R4297 VSS.n724 VSS.n562 97.5005
R4298 VSS.n404 VSS.n55 97.5005
R4299 VSS.n561 VSS.n55 97.5005
R4300 VSS.n407 VSS.n406 97.5005
R4301 VSS.n555 VSS.n407 97.5005
R4302 VSS.n640 VSS.n637 97.5005
R4303 VSS.n637 VSS.n41 97.5005
R4304 VSS.n638 VSS.n636 97.5005
R4305 VSS.n636 VSS.n562 97.5005
R4306 VSS.n495 VSS.n68 97.5005
R4307 VSS.n561 VSS.n68 97.5005
R4308 VSS.n498 VSS.n497 97.5005
R4309 VSS.n555 VSS.n498 97.5005
R4310 VSS.n736 VSS.n733 97.5005
R4311 VSS.n733 VSS.n41 97.5005
R4312 VSS.n734 VSS.n732 97.5005
R4313 VSS.n732 VSS.n562 97.5005
R4314 VSS.n397 VSS.n54 97.5005
R4315 VSS.n561 VSS.n54 97.5005
R4316 VSS.n400 VSS.n399 97.5005
R4317 VSS.n555 VSS.n400 97.5005
R4318 VSS.n632 VSS.n629 97.5005
R4319 VSS.n629 VSS.n41 97.5005
R4320 VSS.n630 VSS.n628 97.5005
R4321 VSS.n628 VSS.n562 97.5005
R4322 VSS.n502 VSS.n69 97.5005
R4323 VSS.n561 VSS.n69 97.5005
R4324 VSS.n505 VSS.n504 97.5005
R4325 VSS.n555 VSS.n505 97.5005
R4326 VSS.n744 VSS.n741 97.5005
R4327 VSS.n741 VSS.n41 97.5005
R4328 VSS.n742 VSS.n740 97.5005
R4329 VSS.n740 VSS.n562 97.5005
R4330 VSS.n390 VSS.n53 97.5005
R4331 VSS.n561 VSS.n53 97.5005
R4332 VSS.n393 VSS.n392 97.5005
R4333 VSS.n555 VSS.n393 97.5005
R4334 VSS.n624 VSS.n621 97.5005
R4335 VSS.n621 VSS.n41 97.5005
R4336 VSS.n622 VSS.n620 97.5005
R4337 VSS.n620 VSS.n562 97.5005
R4338 VSS.n509 VSS.n70 97.5005
R4339 VSS.n561 VSS.n70 97.5005
R4340 VSS.n512 VSS.n511 97.5005
R4341 VSS.n555 VSS.n512 97.5005
R4342 VSS.n752 VSS.n749 97.5005
R4343 VSS.n749 VSS.n41 97.5005
R4344 VSS.n750 VSS.n748 97.5005
R4345 VSS.n748 VSS.n562 97.5005
R4346 VSS.n383 VSS.n52 97.5005
R4347 VSS.n561 VSS.n52 97.5005
R4348 VSS.n386 VSS.n385 97.5005
R4349 VSS.n555 VSS.n386 97.5005
R4350 VSS.n616 VSS.n613 97.5005
R4351 VSS.n613 VSS.n41 97.5005
R4352 VSS.n614 VSS.n612 97.5005
R4353 VSS.n612 VSS.n562 97.5005
R4354 VSS.n516 VSS.n71 97.5005
R4355 VSS.n561 VSS.n71 97.5005
R4356 VSS.n519 VSS.n518 97.5005
R4357 VSS.n555 VSS.n519 97.5005
R4358 VSS.n760 VSS.n757 97.5005
R4359 VSS.n757 VSS.n41 97.5005
R4360 VSS.n758 VSS.n756 97.5005
R4361 VSS.n756 VSS.n562 97.5005
R4362 VSS.n376 VSS.n51 97.5005
R4363 VSS.n561 VSS.n51 97.5005
R4364 VSS.n379 VSS.n378 97.5005
R4365 VSS.n555 VSS.n379 97.5005
R4366 VSS.n608 VSS.n605 97.5005
R4367 VSS.n605 VSS.n41 97.5005
R4368 VSS.n606 VSS.n604 97.5005
R4369 VSS.n604 VSS.n562 97.5005
R4370 VSS.n523 VSS.n72 97.5005
R4371 VSS.n561 VSS.n72 97.5005
R4372 VSS.n526 VSS.n525 97.5005
R4373 VSS.n555 VSS.n526 97.5005
R4374 VSS.n768 VSS.n765 97.5005
R4375 VSS.n765 VSS.n41 97.5005
R4376 VSS.n766 VSS.n764 97.5005
R4377 VSS.n764 VSS.n562 97.5005
R4378 VSS.n369 VSS.n50 97.5005
R4379 VSS.n561 VSS.n50 97.5005
R4380 VSS.n372 VSS.n371 97.5005
R4381 VSS.n555 VSS.n372 97.5005
R4382 VSS.n600 VSS.n597 97.5005
R4383 VSS.n597 VSS.n41 97.5005
R4384 VSS.n598 VSS.n596 97.5005
R4385 VSS.n596 VSS.n562 97.5005
R4386 VSS.n530 VSS.n73 97.5005
R4387 VSS.n561 VSS.n73 97.5005
R4388 VSS.n533 VSS.n532 97.5005
R4389 VSS.n555 VSS.n533 97.5005
R4390 VSS.n776 VSS.n773 97.5005
R4391 VSS.n773 VSS.n41 97.5005
R4392 VSS.n774 VSS.n772 97.5005
R4393 VSS.n772 VSS.n562 97.5005
R4394 VSS.n362 VSS.n49 97.5005
R4395 VSS.n561 VSS.n49 97.5005
R4396 VSS.n365 VSS.n364 97.5005
R4397 VSS.n555 VSS.n365 97.5005
R4398 VSS.n592 VSS.n589 97.5005
R4399 VSS.n589 VSS.n41 97.5005
R4400 VSS.n590 VSS.n588 97.5005
R4401 VSS.n588 VSS.n562 97.5005
R4402 VSS.n537 VSS.n74 97.5005
R4403 VSS.n561 VSS.n74 97.5005
R4404 VSS.n540 VSS.n539 97.5005
R4405 VSS.n555 VSS.n540 97.5005
R4406 VSS.n784 VSS.n781 97.5005
R4407 VSS.n781 VSS.n41 97.5005
R4408 VSS.n782 VSS.n780 97.5005
R4409 VSS.n780 VSS.n562 97.5005
R4410 VSS.n355 VSS.n48 97.5005
R4411 VSS.n561 VSS.n48 97.5005
R4412 VSS.n358 VSS.n357 97.5005
R4413 VSS.n555 VSS.n358 97.5005
R4414 VSS.n584 VSS.n581 97.5005
R4415 VSS.n581 VSS.n41 97.5005
R4416 VSS.n582 VSS.n580 97.5005
R4417 VSS.n580 VSS.n562 97.5005
R4418 VSS.n544 VSS.n75 97.5005
R4419 VSS.n561 VSS.n75 97.5005
R4420 VSS.n547 VSS.n546 97.5005
R4421 VSS.n555 VSS.n547 97.5005
R4422 VSS.n792 VSS.n789 97.5005
R4423 VSS.n789 VSS.n41 97.5005
R4424 VSS.n790 VSS.n788 97.5005
R4425 VSS.n788 VSS.n562 97.5005
R4426 VSS.n348 VSS.n47 97.5005
R4427 VSS.n561 VSS.n47 97.5005
R4428 VSS.n351 VSS.n350 97.5005
R4429 VSS.n555 VSS.n351 97.5005
R4430 VSS.n576 VSS.n573 97.5005
R4431 VSS.n573 VSS.n41 97.5005
R4432 VSS.n574 VSS.n572 97.5005
R4433 VSS.n572 VSS.n562 97.5005
R4434 VSS.n551 VSS.n76 97.5005
R4435 VSS.n561 VSS.n76 97.5005
R4436 VSS.n554 VSS.n553 97.5005
R4437 VSS.n555 VSS.n554 97.5005
R4438 VSS.n800 VSS.n797 97.5005
R4439 VSS.n797 VSS.n41 97.5005
R4440 VSS.n798 VSS.n796 97.5005
R4441 VSS.n796 VSS.n562 97.5005
R4442 VSS.n341 VSS.n46 97.5005
R4443 VSS.n561 VSS.n46 97.5005
R4444 VSS.n344 VSS.n343 97.5005
R4445 VSS.n555 VSS.n344 97.5005
R4446 VSS.n568 VSS.n565 97.5005
R4447 VSS.n565 VSS.n41 97.5005
R4448 VSS.n566 VSS.n564 97.5005
R4449 VSS.n564 VSS.n562 97.5005
R4450 VSS.n560 VSS.n559 97.5005
R4451 VSS.n561 VSS.n560 97.5005
R4452 VSS.n557 VSS.n556 97.5005
R4453 VSS.n556 VSS.n555 97.5005
R4454 VSS.n808 VSS.n805 97.5005
R4455 VSS.n805 VSS.n41 97.5005
R4456 VSS.n806 VSS.n804 97.5005
R4457 VSS.n804 VSS.n562 97.5005
R4458 VSS.n1342 VSS.t64 93.3938
R4459 VSS.n1416 VSS.n1346 88.4711
R4460 VSS.n1423 VSS.n1337 88.4711
R4461 VSS.n1430 VSS.n1333 88.4711
R4462 VSS.n904 VSS.t56 87.5157
R4463 VSS.n918 VSS.t55 87.5157
R4464 VSS.n1301 VSS.t39 87.5157
R4465 VSS.n1296 VSS.t65 87.5157
R4466 VSS.n1282 VSS.t45 87.5157
R4467 VSS.n1268 VSS.t26 87.5157
R4468 VSS.n1254 VSS.t68 87.5157
R4469 VSS.n1240 VSS.t8 87.5157
R4470 VSS.n1226 VSS.t29 87.5157
R4471 VSS.n1212 VSS.t41 87.5157
R4472 VSS.n1198 VSS.t31 87.5157
R4473 VSS.n1184 VSS.t46 87.5157
R4474 VSS.n1170 VSS.t72 87.5157
R4475 VSS.n1156 VSS.t58 87.5157
R4476 VSS.n1142 VSS.t52 87.5157
R4477 VSS.n1128 VSS.t49 87.5157
R4478 VSS.n1114 VSS.t48 87.5157
R4479 VSS.n1100 VSS.t23 87.5157
R4480 VSS.n1086 VSS.t13 87.5157
R4481 VSS.n1072 VSS.t19 87.5157
R4482 VSS.n1058 VSS.t9 87.5157
R4483 VSS.n1044 VSS.t30 87.5157
R4484 VSS.n1030 VSS.t33 87.5157
R4485 VSS.n1016 VSS.t7 87.5157
R4486 VSS.n1002 VSS.t6 87.5157
R4487 VSS.n988 VSS.t67 87.5157
R4488 VSS.n974 VSS.t69 87.5157
R4489 VSS.n960 VSS.t2 87.5157
R4490 VSS.n946 VSS.t27 87.5157
R4491 VSS.n932 VSS.t36 87.5157
R4492 VSS.n876 VSS.t16 87.5157
R4493 VSS.n0 VSS.t43 87.5157
R4494 VSS.n903 VSS.t42 87.4021
R4495 VSS.n917 VSS.t40 87.4021
R4496 VSS.n1302 VSS.t22 87.4021
R4497 VSS.n1295 VSS.t21 87.4021
R4498 VSS.n1281 VSS.t20 87.4021
R4499 VSS.n1267 VSS.t70 87.4021
R4500 VSS.n1253 VSS.t44 87.4021
R4501 VSS.n1239 VSS.t24 87.4021
R4502 VSS.n1225 VSS.t28 87.4021
R4503 VSS.n1211 VSS.t32 87.4021
R4504 VSS.n1197 VSS.t53 87.4021
R4505 VSS.n1183 VSS.t73 87.4021
R4506 VSS.n1169 VSS.t59 87.4021
R4507 VSS.n1155 VSS.t57 87.4021
R4508 VSS.n1141 VSS.t47 87.4021
R4509 VSS.n1127 VSS.t54 87.4021
R4510 VSS.n1113 VSS.t34 87.4021
R4511 VSS.n1099 VSS.t25 87.4021
R4512 VSS.n1085 VSS.t10 87.4021
R4513 VSS.n1071 VSS.t11 87.4021
R4514 VSS.n1057 VSS.t18 87.4021
R4515 VSS.n1043 VSS.t51 87.4021
R4516 VSS.n1029 VSS.t38 87.4021
R4517 VSS.n1015 VSS.t37 87.4021
R4518 VSS.n1001 VSS.t17 87.4021
R4519 VSS.n987 VSS.t50 87.4021
R4520 VSS.n973 VSS.t14 87.4021
R4521 VSS.n959 VSS.t66 87.4021
R4522 VSS.n945 VSS.t12 87.4021
R4523 VSS.n931 VSS.t35 87.4021
R4524 VSS.n877 VSS.t15 87.4021
R4525 VSS.n869 VSS.t4 87.4021
R4526 VSS.n1407 VSS.n1351 83.2005
R4527 VSS.n1313 VSS.n849 82.5754
R4528 VSS.n915 VSS.n854 82.5754
R4529 VSS.n1311 VSS.n900 82.5754
R4530 VSS.n1293 VSS.n855 82.5754
R4531 VSS.n1279 VSS.n899 82.5754
R4532 VSS.n1265 VSS.n856 82.5754
R4533 VSS.n1251 VSS.n898 82.5754
R4534 VSS.n1237 VSS.n857 82.5754
R4535 VSS.n1223 VSS.n897 82.5754
R4536 VSS.n1209 VSS.n858 82.5754
R4537 VSS.n1195 VSS.n896 82.5754
R4538 VSS.n1181 VSS.n859 82.5754
R4539 VSS.n1167 VSS.n895 82.5754
R4540 VSS.n1153 VSS.n860 82.5754
R4541 VSS.n1139 VSS.n894 82.5754
R4542 VSS.n1125 VSS.n861 82.5754
R4543 VSS.n1111 VSS.n893 82.5754
R4544 VSS.n1097 VSS.n862 82.5754
R4545 VSS.n1083 VSS.n892 82.5754
R4546 VSS.n1069 VSS.n863 82.5754
R4547 VSS.n1055 VSS.n891 82.5754
R4548 VSS.n1041 VSS.n864 82.5754
R4549 VSS.n1027 VSS.n890 82.5754
R4550 VSS.n1013 VSS.n865 82.5754
R4551 VSS.n999 VSS.n889 82.5754
R4552 VSS.n985 VSS.n866 82.5754
R4553 VSS.n971 VSS.n888 82.5754
R4554 VSS.n957 VSS.n867 82.5754
R4555 VSS.n943 VSS.n887 82.5754
R4556 VSS.n929 VSS.n868 82.5754
R4557 VSS.n886 VSS.n873 82.5754
R4558 VSS.n872 VSS.n8 82.5754
R4559 VSS.n1426 VSS.n1328 73.8004
R4560 VSS.n1318 VSS.n851 67.3887
R4561 VSS.n913 VSS.n907 67.3887
R4562 VSS.n1309 VSS.n1304 67.3887
R4563 VSS.n1291 VSS.n1285 67.3887
R4564 VSS.n1277 VSS.n1271 67.3887
R4565 VSS.n1263 VSS.n1257 67.3887
R4566 VSS.n1249 VSS.n1243 67.3887
R4567 VSS.n1235 VSS.n1229 67.3887
R4568 VSS.n1221 VSS.n1215 67.3887
R4569 VSS.n1207 VSS.n1201 67.3887
R4570 VSS.n1193 VSS.n1187 67.3887
R4571 VSS.n1179 VSS.n1173 67.3887
R4572 VSS.n1165 VSS.n1159 67.3887
R4573 VSS.n1151 VSS.n1145 67.3887
R4574 VSS.n1137 VSS.n1131 67.3887
R4575 VSS.n1123 VSS.n1117 67.3887
R4576 VSS.n1109 VSS.n1103 67.3887
R4577 VSS.n1095 VSS.n1089 67.3887
R4578 VSS.n1081 VSS.n1075 67.3887
R4579 VSS.n1067 VSS.n1061 67.3887
R4580 VSS.n1053 VSS.n1047 67.3887
R4581 VSS.n1039 VSS.n1033 67.3887
R4582 VSS.n1025 VSS.n1019 67.3887
R4583 VSS.n1011 VSS.n1005 67.3887
R4584 VSS.n997 VSS.n991 67.3887
R4585 VSS.n983 VSS.n977 67.3887
R4586 VSS.n969 VSS.n963 67.3887
R4587 VSS.n955 VSS.n949 67.3887
R4588 VSS.n941 VSS.n935 67.3887
R4589 VSS.n927 VSS.n921 67.3887
R4590 VSS.n884 VSS.n879 67.3887
R4591 VSS.n1321 VSS.n7 67.3887
R4592 VSS.n1382 VSS.n1330 62.4424
R4593 VSS.n1390 VSS.n1389 62.4424
R4594 VSS.n1398 VSS.n1397 62.4424
R4595 VSS.n903 VSS.n902 58.0587
R4596 VSS.n917 VSS.n916 58.0587
R4597 VSS.n1303 VSS.n1302 58.0587
R4598 VSS.n1295 VSS.n1294 58.0587
R4599 VSS.n1281 VSS.n1280 58.0587
R4600 VSS.n1267 VSS.n1266 58.0587
R4601 VSS.n1253 VSS.n1252 58.0587
R4602 VSS.n1239 VSS.n1238 58.0587
R4603 VSS.n1225 VSS.n1224 58.0587
R4604 VSS.n1211 VSS.n1210 58.0587
R4605 VSS.n1197 VSS.n1196 58.0587
R4606 VSS.n1183 VSS.n1182 58.0587
R4607 VSS.n1169 VSS.n1168 58.0587
R4608 VSS.n1155 VSS.n1154 58.0587
R4609 VSS.n1141 VSS.n1140 58.0587
R4610 VSS.n1127 VSS.n1126 58.0587
R4611 VSS.n1113 VSS.n1112 58.0587
R4612 VSS.n1099 VSS.n1098 58.0587
R4613 VSS.n1085 VSS.n1084 58.0587
R4614 VSS.n1071 VSS.n1070 58.0587
R4615 VSS.n1057 VSS.n1056 58.0587
R4616 VSS.n1043 VSS.n1042 58.0587
R4617 VSS.n1029 VSS.n1028 58.0587
R4618 VSS.n1015 VSS.n1014 58.0587
R4619 VSS.n1001 VSS.n1000 58.0587
R4620 VSS.n987 VSS.n986 58.0587
R4621 VSS.n973 VSS.n972 58.0587
R4622 VSS.n959 VSS.n958 58.0587
R4623 VSS.n945 VSS.n944 58.0587
R4624 VSS.n931 VSS.n930 58.0587
R4625 VSS.n878 VSS.n877 58.0587
R4626 VSS.n870 VSS.n869 58.0587
R4627 VSS.t61 VSS.n817 50.6672
R4628 VSS.n1355 VSS.n1354 50.5605
R4629 VSS.n1359 VSS.n1358 50.5605
R4630 VSS.n1363 VSS.n1362 50.5605
R4631 VSS.n1375 VSS.n1366 50.5605
R4632 VSS.n1347 VSS.n1346 50.5605
R4633 VSS.n1338 VSS.n1337 50.5605
R4634 VSS.n1334 VSS.n1333 50.5605
R4635 VSS.n1351 VSS.n1350 50.5605
R4636 VSS.n816 VSS.n42 47.1116
R4637 VSS.n42 VSS.n3 47.1116
R4638 VSS.n1325 VSS.n3 47.1116
R4639 VSS.n1342 VSS.n1333 39.0503
R4640 VSS.n1375 VSS.n1374 36.8966
R4641 VSS.n1370 VSS.n1355 36.7901
R4642 VSS.n1372 VSS.n1359 36.7901
R4643 VSS.n1373 VSS.n1363 36.7901
R4644 VSS.n1369 VSS.n1351 35.9151
R4645 VSS.n1380 VSS.n1379 34.4123
R4646 VSS.n1381 VSS.n1380 34.4123
R4647 VSS.n1377 VSS.n1376 34.4123
R4648 VSS.n1376 VSS.n1329 34.4123
R4649 VSS.n1387 VSS.n1386 34.4123
R4650 VSS.n1388 VSS.n1387 34.4123
R4651 VSS.n1384 VSS.n1383 34.4123
R4652 VSS.n1383 VSS.n1382 34.4123
R4653 VSS.n1395 VSS.n1394 34.4123
R4654 VSS.n1396 VSS.n1395 34.4123
R4655 VSS.n1392 VSS.n1391 34.4123
R4656 VSS.n1391 VSS.n1390 34.4123
R4657 VSS.n1403 VSS.n1402 34.4123
R4658 VSS.n1404 VSS.n1403 34.4123
R4659 VSS.n1400 VSS.n1399 34.4123
R4660 VSS.n1399 VSS.n1398 34.4123
R4661 VSS.n1315 VSS.n851 33.1299
R4662 VSS.n913 VSS.n912 33.1299
R4663 VSS.n1309 VSS.n1308 33.1299
R4664 VSS.n1291 VSS.n1290 33.1299
R4665 VSS.n1277 VSS.n1276 33.1299
R4666 VSS.n1263 VSS.n1262 33.1299
R4667 VSS.n1249 VSS.n1248 33.1299
R4668 VSS.n1235 VSS.n1234 33.1299
R4669 VSS.n1221 VSS.n1220 33.1299
R4670 VSS.n1207 VSS.n1206 33.1299
R4671 VSS.n1193 VSS.n1192 33.1299
R4672 VSS.n1179 VSS.n1178 33.1299
R4673 VSS.n1165 VSS.n1164 33.1299
R4674 VSS.n1151 VSS.n1150 33.1299
R4675 VSS.n1137 VSS.n1136 33.1299
R4676 VSS.n1123 VSS.n1122 33.1299
R4677 VSS.n1109 VSS.n1108 33.1299
R4678 VSS.n1095 VSS.n1094 33.1299
R4679 VSS.n1081 VSS.n1080 33.1299
R4680 VSS.n1067 VSS.n1066 33.1299
R4681 VSS.n1053 VSS.n1052 33.1299
R4682 VSS.n1039 VSS.n1038 33.1299
R4683 VSS.n1025 VSS.n1024 33.1299
R4684 VSS.n1011 VSS.n1010 33.1299
R4685 VSS.n997 VSS.n996 33.1299
R4686 VSS.n983 VSS.n982 33.1299
R4687 VSS.n969 VSS.n968 33.1299
R4688 VSS.n955 VSS.n954 33.1299
R4689 VSS.n941 VSS.n940 33.1299
R4690 VSS.n927 VSS.n926 33.1299
R4691 VSS.n884 VSS.n883 33.1299
R4692 VSS.n7 VSS.n6 33.1299
R4693 VSS.n1346 VSS.n1345 32.5359
R4694 VSS.n1343 VSS.n1337 32.5359
R4695 VSS.n853 VSS.n817 27.2903
R4696 VSS.n1371 VSS.t77 26.8495
R4697 VSS.n1374 VSS.t79 26.8495
R4698 VSS.t0 VSS.n1339 24.1763
R4699 VSS.t61 VSS.n9 12.1379
R4700 VSS.t61 VSS.n40 12.1379
R4701 VSS.n331 VSS.t60 12.1379
R4702 VSS.n337 VSS.t60 12.1379
R4703 VSS.n555 VSS.t3 12.1379
R4704 VSS.n561 VSS.t3 12.1379
R4705 VSS.t1 VSS.n562 12.1379
R4706 VSS.t1 VSS.n41 12.1379
R4707 VSS.n1367 VSS.n2 7.34675
R4708 VSS.n852 VSS.n851 6.03479
R4709 VSS.n914 VSS.n913 6.03479
R4710 VSS.n1310 VSS.n1309 6.03479
R4711 VSS.n1292 VSS.n1291 6.03479
R4712 VSS.n1278 VSS.n1277 6.03479
R4713 VSS.n1264 VSS.n1263 6.03479
R4714 VSS.n1250 VSS.n1249 6.03479
R4715 VSS.n1236 VSS.n1235 6.03479
R4716 VSS.n1222 VSS.n1221 6.03479
R4717 VSS.n1208 VSS.n1207 6.03479
R4718 VSS.n1194 VSS.n1193 6.03479
R4719 VSS.n1180 VSS.n1179 6.03479
R4720 VSS.n1166 VSS.n1165 6.03479
R4721 VSS.n1152 VSS.n1151 6.03479
R4722 VSS.n1138 VSS.n1137 6.03479
R4723 VSS.n1124 VSS.n1123 6.03479
R4724 VSS.n1110 VSS.n1109 6.03479
R4725 VSS.n1096 VSS.n1095 6.03479
R4726 VSS.n1082 VSS.n1081 6.03479
R4727 VSS.n1068 VSS.n1067 6.03479
R4728 VSS.n1054 VSS.n1053 6.03479
R4729 VSS.n1040 VSS.n1039 6.03479
R4730 VSS.n1026 VSS.n1025 6.03479
R4731 VSS.n1012 VSS.n1011 6.03479
R4732 VSS.n998 VSS.n997 6.03479
R4733 VSS.n984 VSS.n983 6.03479
R4734 VSS.n970 VSS.n969 6.03479
R4735 VSS.n956 VSS.n955 6.03479
R4736 VSS.n942 VSS.n941 6.03479
R4737 VSS.n928 VSS.n927 6.03479
R4738 VSS.n885 VSS.n884 6.03479
R4739 VSS.n871 VSS.n7 6.03479
R4740 VSS.n1312 VSS.n9 5.10285
R4741 VSS.n331 VSS.n40 4.25245
R4742 VSS.n555 VSS.n337 4.25245
R4743 VSS.n562 VSS.n561 4.25245
R4744 VSS.n1344 VSS.n2 3.4105
R4745 VSS.n1439 VSS.n1438 3.4105
R4746 VSS.n1441 VSS.n1440 3.4105
R4747 VSS.n875 VSS.n1 3.4105
R4748 VSS.n934 VSS.n933 3.4105
R4749 VSS.n948 VSS.n947 3.4105
R4750 VSS.n962 VSS.n961 3.4105
R4751 VSS.n976 VSS.n975 3.4105
R4752 VSS.n990 VSS.n989 3.4105
R4753 VSS.n1004 VSS.n1003 3.4105
R4754 VSS.n1018 VSS.n1017 3.4105
R4755 VSS.n1032 VSS.n1031 3.4105
R4756 VSS.n1046 VSS.n1045 3.4105
R4757 VSS.n1060 VSS.n1059 3.4105
R4758 VSS.n1074 VSS.n1073 3.4105
R4759 VSS.n1088 VSS.n1087 3.4105
R4760 VSS.n1102 VSS.n1101 3.4105
R4761 VSS.n1116 VSS.n1115 3.4105
R4762 VSS.n1130 VSS.n1129 3.4105
R4763 VSS.n1144 VSS.n1143 3.4105
R4764 VSS.n1158 VSS.n1157 3.4105
R4765 VSS.n1172 VSS.n1171 3.4105
R4766 VSS.n1186 VSS.n1185 3.4105
R4767 VSS.n1200 VSS.n1199 3.4105
R4768 VSS.n1214 VSS.n1213 3.4105
R4769 VSS.n1228 VSS.n1227 3.4105
R4770 VSS.n1242 VSS.n1241 3.4105
R4771 VSS.n1256 VSS.n1255 3.4105
R4772 VSS.n1270 VSS.n1269 3.4105
R4773 VSS.n1284 VSS.n1283 3.4105
R4774 VSS.n1298 VSS.n1297 3.4105
R4775 VSS.n1300 VSS.n1299 3.4105
R4776 VSS.n920 VSS.n919 3.4105
R4777 VSS.n906 VSS.n905 3.4105
R4778 VSS.n1439 VSS.n2 2.66775
R4779 VSS.n1440 VSS.n1439 1.58675
R4780 VSS.n902 VSS.n852 1.2805
R4781 VSS.n916 VSS.n914 1.2805
R4782 VSS.n1310 VSS.n1303 1.2805
R4783 VSS.n1294 VSS.n1292 1.2805
R4784 VSS.n1280 VSS.n1278 1.2805
R4785 VSS.n1266 VSS.n1264 1.2805
R4786 VSS.n1252 VSS.n1250 1.2805
R4787 VSS.n1238 VSS.n1236 1.2805
R4788 VSS.n1224 VSS.n1222 1.2805
R4789 VSS.n1210 VSS.n1208 1.2805
R4790 VSS.n1196 VSS.n1194 1.2805
R4791 VSS.n1182 VSS.n1180 1.2805
R4792 VSS.n1168 VSS.n1166 1.2805
R4793 VSS.n1154 VSS.n1152 1.2805
R4794 VSS.n1140 VSS.n1138 1.2805
R4795 VSS.n1126 VSS.n1124 1.2805
R4796 VSS.n1112 VSS.n1110 1.2805
R4797 VSS.n1098 VSS.n1096 1.2805
R4798 VSS.n1084 VSS.n1082 1.2805
R4799 VSS.n1070 VSS.n1068 1.2805
R4800 VSS.n1056 VSS.n1054 1.2805
R4801 VSS.n1042 VSS.n1040 1.2805
R4802 VSS.n1028 VSS.n1026 1.2805
R4803 VSS.n1014 VSS.n1012 1.2805
R4804 VSS.n1000 VSS.n998 1.2805
R4805 VSS.n986 VSS.n984 1.2805
R4806 VSS.n972 VSS.n970 1.2805
R4807 VSS.n958 VSS.n956 1.2805
R4808 VSS.n944 VSS.n942 1.2805
R4809 VSS.n930 VSS.n928 1.2805
R4810 VSS.n885 VSS.n878 1.2805
R4811 VSS.n871 VSS.n870 1.2805
R4812 VSS.n1312 VSS.n853 1.08282
R4813 VSS.n920 VSS.n906 1.058
R4814 VSS.n1299 VSS.n920 1.058
R4815 VSS.n1299 VSS.n1298 1.058
R4816 VSS.n1298 VSS.n1284 1.058
R4817 VSS.n1284 VSS.n1270 1.058
R4818 VSS.n1270 VSS.n1256 1.058
R4819 VSS.n1256 VSS.n1242 1.058
R4820 VSS.n1242 VSS.n1228 1.058
R4821 VSS.n1228 VSS.n1214 1.058
R4822 VSS.n1214 VSS.n1200 1.058
R4823 VSS.n1200 VSS.n1186 1.058
R4824 VSS.n1186 VSS.n1172 1.058
R4825 VSS.n1172 VSS.n1158 1.058
R4826 VSS.n1158 VSS.n1144 1.058
R4827 VSS.n1144 VSS.n1130 1.058
R4828 VSS.n1130 VSS.n1116 1.058
R4829 VSS.n1116 VSS.n1102 1.058
R4830 VSS.n1102 VSS.n1088 1.058
R4831 VSS.n1088 VSS.n1074 1.058
R4832 VSS.n1074 VSS.n1060 1.058
R4833 VSS.n1060 VSS.n1046 1.058
R4834 VSS.n1046 VSS.n1032 1.058
R4835 VSS.n1032 VSS.n1018 1.058
R4836 VSS.n1018 VSS.n1004 1.058
R4837 VSS.n1004 VSS.n990 1.058
R4838 VSS.n990 VSS.n976 1.058
R4839 VSS.n976 VSS.n962 1.058
R4840 VSS.n962 VSS.n948 1.058
R4841 VSS.n948 VSS.n934 1.058
R4842 VSS.n934 VSS.n1 1.058
R4843 VSS.n1440 VSS.n1 1.058
R4844 VSS.n817 VSS.n816 0.889389
R4845 VSS.n906 VSS 0.83475
R4846 VSS.n1345 VSS.n1343 0.7055
R4847 VSS.n1373 VSS.n1372 0.627167
R4848 VSS.n1370 VSS.n1369 0.627167
R4849 VSS.n1343 VSS.n1342 0.6068
R4850 VSS.n1374 VSS.n1373 0.520633
R4851 VSS.n1371 VSS.n1370 0.520633
R4852 VSS.n1367 VSS 0.48225
R4853 VSS.n1344 VSS 0.48225
R4854 VSS.n1438 VSS 0.48225
R4855 VSS.n905 VSS 0.48225
R4856 VSS.n919 VSS 0.48225
R4857 VSS.n1300 VSS 0.48225
R4858 VSS.n1297 VSS 0.48225
R4859 VSS.n1283 VSS 0.48225
R4860 VSS.n1269 VSS 0.48225
R4861 VSS.n1255 VSS 0.48225
R4862 VSS.n1241 VSS 0.48225
R4863 VSS.n1227 VSS 0.48225
R4864 VSS.n1213 VSS 0.48225
R4865 VSS.n1199 VSS 0.48225
R4866 VSS.n1185 VSS 0.48225
R4867 VSS.n1171 VSS 0.48225
R4868 VSS.n1157 VSS 0.48225
R4869 VSS.n1143 VSS 0.48225
R4870 VSS.n1129 VSS 0.48225
R4871 VSS.n1115 VSS 0.48225
R4872 VSS.n1101 VSS 0.48225
R4873 VSS.n1087 VSS 0.48225
R4874 VSS.n1073 VSS 0.48225
R4875 VSS.n1059 VSS 0.48225
R4876 VSS.n1045 VSS 0.48225
R4877 VSS.n1031 VSS 0.48225
R4878 VSS.n1017 VSS 0.48225
R4879 VSS.n1003 VSS 0.48225
R4880 VSS.n989 VSS 0.48225
R4881 VSS.n975 VSS 0.48225
R4882 VSS.n961 VSS 0.48225
R4883 VSS.n947 VSS 0.48225
R4884 VSS.n933 VSS 0.48225
R4885 VSS.n875 VSS 0.48225
R4886 VSS VSS.n1441 0.48225
R4887 VSS.n1345 VSS.n1344 0.368667
R4888 VSS.n905 VSS.n904 0.313833
R4889 VSS.n919 VSS.n918 0.313833
R4890 VSS.n1301 VSS.n1300 0.313833
R4891 VSS.n1297 VSS.n1296 0.313833
R4892 VSS.n1283 VSS.n1282 0.313833
R4893 VSS.n1269 VSS.n1268 0.313833
R4894 VSS.n1255 VSS.n1254 0.313833
R4895 VSS.n1241 VSS.n1240 0.313833
R4896 VSS.n1227 VSS.n1226 0.313833
R4897 VSS.n1213 VSS.n1212 0.313833
R4898 VSS.n1199 VSS.n1198 0.313833
R4899 VSS.n1185 VSS.n1184 0.313833
R4900 VSS.n1171 VSS.n1170 0.313833
R4901 VSS.n1157 VSS.n1156 0.313833
R4902 VSS.n1143 VSS.n1142 0.313833
R4903 VSS.n1129 VSS.n1128 0.313833
R4904 VSS.n1115 VSS.n1114 0.313833
R4905 VSS.n1101 VSS.n1100 0.313833
R4906 VSS.n1087 VSS.n1086 0.313833
R4907 VSS.n1073 VSS.n1072 0.313833
R4908 VSS.n1059 VSS.n1058 0.313833
R4909 VSS.n1045 VSS.n1044 0.313833
R4910 VSS.n1031 VSS.n1030 0.313833
R4911 VSS.n1017 VSS.n1016 0.313833
R4912 VSS.n1003 VSS.n1002 0.313833
R4913 VSS.n989 VSS.n988 0.313833
R4914 VSS.n975 VSS.n974 0.313833
R4915 VSS.n961 VSS.n960 0.313833
R4916 VSS.n947 VSS.n946 0.313833
R4917 VSS.n933 VSS.n932 0.313833
R4918 VSS.n876 VSS.n875 0.313833
R4919 VSS.n1441 VSS.n0 0.313833
R4920 VSS.n904 VSS.n903 0.290333
R4921 VSS.n918 VSS.n917 0.290333
R4922 VSS.n1302 VSS.n1301 0.290333
R4923 VSS.n1296 VSS.n1295 0.290333
R4924 VSS.n1282 VSS.n1281 0.290333
R4925 VSS.n1268 VSS.n1267 0.290333
R4926 VSS.n1254 VSS.n1253 0.290333
R4927 VSS.n1240 VSS.n1239 0.290333
R4928 VSS.n1226 VSS.n1225 0.290333
R4929 VSS.n1212 VSS.n1211 0.290333
R4930 VSS.n1198 VSS.n1197 0.290333
R4931 VSS.n1184 VSS.n1183 0.290333
R4932 VSS.n1170 VSS.n1169 0.290333
R4933 VSS.n1156 VSS.n1155 0.290333
R4934 VSS.n1142 VSS.n1141 0.290333
R4935 VSS.n1128 VSS.n1127 0.290333
R4936 VSS.n1114 VSS.n1113 0.290333
R4937 VSS.n1100 VSS.n1099 0.290333
R4938 VSS.n1086 VSS.n1085 0.290333
R4939 VSS.n1072 VSS.n1071 0.290333
R4940 VSS.n1058 VSS.n1057 0.290333
R4941 VSS.n1044 VSS.n1043 0.290333
R4942 VSS.n1030 VSS.n1029 0.290333
R4943 VSS.n1016 VSS.n1015 0.290333
R4944 VSS.n1002 VSS.n1001 0.290333
R4945 VSS.n988 VSS.n987 0.290333
R4946 VSS.n974 VSS.n973 0.290333
R4947 VSS.n960 VSS.n959 0.290333
R4948 VSS.n946 VSS.n945 0.290333
R4949 VSS.n932 VSS.n931 0.290333
R4950 VSS.n877 VSS.n876 0.290333
R4951 VSS.n869 VSS.n0 0.290333
R4952 VSS.n1368 VSS.n1367 0.269967
R4953 VSS.n1372 VSS.n1371 0.107033
R4954 VSS.n1369 VSS.n1368 0.107033
R4955 a_3465_n13274.t0 a_3465_n13274.t1 59.3393
R4956 a_1865_n13274.t0 a_1865_n13274.t1 60.5893
R4957 a_3077_n9274.t0 a_3077_n9274.t1 121.093
R4958 a_1477_n9274.t0 a_1477_n9274.t1 119.843
R4959 a_677_n8854.t0 a_677_n8854.n1 132.501
R4960 a_677_n8854.n1 a_677_n8854.n0 0.4893
R4961 a_677_n8854.n0 a_677_n8854.t2 1057.08
R4962 a_677_n8854.n0 a_677_n8854.t3 1055.83
R4963 a_677_n8854.n1 a_677_n8854.t1 341.236
R4964 a_1065_n6268.t0 a_1065_n6268.n0 93.6821
R4965 a_1065_n6268.n0 a_1065_n6268.t2 93.4879
R4966 a_1065_n6268.n0 a_1065_n6268.t1 92.9771
R4967 sense_amp_scale1p5_flat_0.SA_OUT.n3 sense_amp_scale1p5_flat_0.SA_OUT.t0 94.2167
R4968 sense_amp_scale1p5_flat_0.SA_OUT sense_amp_scale1p5_flat_0.SA_OUT.n0 0.0247833
R4969 sense_amp_scale1p5_flat_0.SA_OUT.n0 sense_amp_scale1p5_flat_0.SA_OUT.n3 0.2355
R4970 sense_amp_scale1p5_flat_0.SA_OUT.n3 sense_amp_scale1p5_flat_0.SA_OUT.n1 0.4893
R4971 sense_amp_scale1p5_flat_0.SA_OUT.n1 sense_amp_scale1p5_flat_0.SA_OUT.n2 0.313833
R4972 sense_amp_scale1p5_flat_0.SA_OUT.n2 sense_amp_scale1p5_flat_0.SA_OUT.t3 387.865
R4973 sense_amp_scale1p5_flat_0.SA_OUT.n2 sense_amp_scale1p5_flat_0.SA_OUT.t1 124.212
R4974 sense_amp_scale1p5_flat_0.SA_OUT.n1 sense_amp_scale1p5_flat_0.SA_OUT.t4 549.399
R4975 sense_amp_scale1p5_flat_0.SA_OUT.n0 sense_amp_scale1p5_flat_0.SA_OUT.t2 144.132
R4976 sense_amp_scale1p5_flat_0.SA_OUTB.n3 sense_amp_scale1p5_flat_0.SA_OUTB.t0 92.3521
R4977 sense_amp_scale1p5_flat_0.SA_OUTB sense_amp_scale1p5_flat_0.SA_OUTB.n0 0.024
R4978 sense_amp_scale1p5_flat_0.SA_OUTB.n0 sense_amp_scale1p5_flat_0.SA_OUTB.n2 0.2355
R4979 sense_amp_scale1p5_flat_0.SA_OUTB.n2 sense_amp_scale1p5_flat_0.SA_OUTB.n1 0.295033
R4980 sense_amp_scale1p5_flat_0.SA_OUTB.n1 sense_amp_scale1p5_flat_0.SA_OUTB.n3 0.313833
R4981 sense_amp_scale1p5_flat_0.SA_OUTB.n2 sense_amp_scale1p5_flat_0.SA_OUTB.t3 386.229
R4982 sense_amp_scale1p5_flat_0.SA_OUTB.n3 sense_amp_scale1p5_flat_0.SA_OUTB.t2 126.606
R4983 sense_amp_scale1p5_flat_0.SA_OUTB.n1 sense_amp_scale1p5_flat_0.SA_OUTB.t1 145.998
R4984 sense_amp_scale1p5_flat_0.SA_OUTB.n0 sense_amp_scale1p5_flat_0.SA_OUTB.t4 551.263
R4985 a_623_1116.t0 a_623_1116.n0 669.27
R4986 a_623_1116.n0 a_623_1116.n1 0.384333
R4987 a_623_1116.n1 a_623_1116.n2 0.1885
R4988 a_623_1116.n2 a_623_1116.t2 232.047
R4989 a_623_1116.n2 a_623_1116.t3 435.25
R4990 a_623_1116.n1 a_623_1116.t1 87.3032
R4991 a_623_1116.n0 a_623_1116.t4 314.149
R4992 a_576_1020.t1 a_576_1020.n2 668.986
R4993 a_576_1020.n2 a_576_1020.n0 0.196333
R4994 a_576_1020.n0 a_576_1020.n1 0.384333
R4995 a_576_1020.n1 a_576_1020.t2 232.115
R4996 a_576_1020.n1 a_576_1020.t0 87.1667
R4997 a_576_1020.n0 a_576_1020.t3 434.887
R4998 a_576_1020.n2 a_576_1020.t4 314.171
R4999 a_623_2916.t2 a_623_2916.n0 669.27
R5000 a_623_2916.n0 a_623_2916.n1 0.384333
R5001 a_623_2916.n1 a_623_2916.n2 0.1885
R5002 a_623_2916.n2 a_623_2916.t1 232.047
R5003 a_623_2916.n2 a_623_2916.t3 435.25
R5004 a_623_2916.n1 a_623_2916.t0 87.3032
R5005 a_623_2916.n0 a_623_2916.t4 314.149
R5006 a_576_2820.t2 a_576_2820.n2 668.986
R5007 a_576_2820.n2 a_576_2820.n0 0.196333
R5008 a_576_2820.n0 a_576_2820.n1 0.384333
R5009 a_576_2820.n1 a_576_2820.t0 232.115
R5010 a_576_2820.n1 a_576_2820.t1 87.1667
R5011 a_576_2820.n0 a_576_2820.t3 434.887
R5012 a_576_2820.n2 a_576_2820.t4 314.171
R5013 a_623_4716.t0 a_623_4716.n0 669.27
R5014 a_623_4716.n0 a_623_4716.n1 0.384333
R5015 a_623_4716.n1 a_623_4716.n2 0.1885
R5016 a_623_4716.n2 a_623_4716.t2 232.047
R5017 a_623_4716.n2 a_623_4716.t3 435.25
R5018 a_623_4716.n1 a_623_4716.t1 87.3032
R5019 a_623_4716.n0 a_623_4716.t4 314.149
R5020 a_576_4620.t1 a_576_4620.n2 668.986
R5021 a_576_4620.n2 a_576_4620.n0 0.196333
R5022 a_576_4620.n0 a_576_4620.n1 0.384333
R5023 a_576_4620.n1 a_576_4620.t2 232.115
R5024 a_576_4620.n1 a_576_4620.t0 87.1667
R5025 a_576_4620.n0 a_576_4620.t3 434.887
R5026 a_576_4620.n2 a_576_4620.t4 314.171
R5027 a_623_6516.t1 a_623_6516.n0 669.27
R5028 a_623_6516.n0 a_623_6516.n1 0.384333
R5029 a_623_6516.n1 a_623_6516.n2 0.1885
R5030 a_623_6516.n2 a_623_6516.t2 232.047
R5031 a_623_6516.n2 a_623_6516.t3 435.25
R5032 a_623_6516.n1 a_623_6516.t0 87.3032
R5033 a_623_6516.n0 a_623_6516.t4 314.149
R5034 a_576_6420.t1 a_576_6420.n2 668.986
R5035 a_576_6420.n2 a_576_6420.n0 0.196333
R5036 a_576_6420.n0 a_576_6420.n1 0.384333
R5037 a_576_6420.n1 a_576_6420.t2 232.115
R5038 a_576_6420.n1 a_576_6420.t0 87.1667
R5039 a_576_6420.n0 a_576_6420.t3 434.887
R5040 a_576_6420.n2 a_576_6420.t4 314.171
R5041 a_623_8316.t1 a_623_8316.n0 669.27
R5042 a_623_8316.n0 a_623_8316.n1 0.384333
R5043 a_623_8316.n1 a_623_8316.n2 0.1885
R5044 a_623_8316.n2 a_623_8316.t2 232.047
R5045 a_623_8316.n2 a_623_8316.t3 435.25
R5046 a_623_8316.n1 a_623_8316.t0 87.3032
R5047 a_623_8316.n0 a_623_8316.t4 314.149
R5048 a_576_8220.t1 a_576_8220.n2 668.986
R5049 a_576_8220.n2 a_576_8220.n0 0.196333
R5050 a_576_8220.n0 a_576_8220.n1 0.384333
R5051 a_576_8220.n1 a_576_8220.t2 232.115
R5052 a_576_8220.n1 a_576_8220.t0 87.1667
R5053 a_576_8220.n0 a_576_8220.t3 434.887
R5054 a_576_8220.n2 a_576_8220.t4 314.171
R5055 a_623_10116.t0 a_623_10116.n0 669.27
R5056 a_623_10116.n0 a_623_10116.n1 0.384333
R5057 a_623_10116.n1 a_623_10116.n2 0.1885
R5058 a_623_10116.n2 a_623_10116.t1 232.047
R5059 a_623_10116.n2 a_623_10116.t3 435.25
R5060 a_623_10116.n1 a_623_10116.t2 87.3032
R5061 a_623_10116.n0 a_623_10116.t4 314.149
R5062 a_576_10020.t1 a_576_10020.n2 668.986
R5063 a_576_10020.n2 a_576_10020.n0 0.196333
R5064 a_576_10020.n0 a_576_10020.n1 0.384333
R5065 a_576_10020.n1 a_576_10020.t2 232.115
R5066 a_576_10020.n1 a_576_10020.t0 87.1667
R5067 a_576_10020.n0 a_576_10020.t3 434.887
R5068 a_576_10020.n2 a_576_10020.t4 314.171
R5069 a_623_11916.t0 a_623_11916.n0 669.27
R5070 a_623_11916.n0 a_623_11916.n1 0.384333
R5071 a_623_11916.n1 a_623_11916.n2 0.1885
R5072 a_623_11916.n2 a_623_11916.t1 232.047
R5073 a_623_11916.n2 a_623_11916.t3 435.25
R5074 a_623_11916.n1 a_623_11916.t2 87.3032
R5075 a_623_11916.n0 a_623_11916.t4 314.149
R5076 a_576_11820.t1 a_576_11820.n2 668.986
R5077 a_576_11820.n2 a_576_11820.n0 0.196333
R5078 a_576_11820.n0 a_576_11820.n1 0.384333
R5079 a_576_11820.n1 a_576_11820.t2 232.115
R5080 a_576_11820.n1 a_576_11820.t0 87.1667
R5081 a_576_11820.n0 a_576_11820.t3 434.887
R5082 a_576_11820.n2 a_576_11820.t4 314.171
R5083 a_623_13716.t1 a_623_13716.n0 669.27
R5084 a_623_13716.n0 a_623_13716.n1 0.384333
R5085 a_623_13716.n1 a_623_13716.n2 0.1885
R5086 a_623_13716.n2 a_623_13716.t2 232.047
R5087 a_623_13716.n2 a_623_13716.t3 435.25
R5088 a_623_13716.n1 a_623_13716.t0 87.3032
R5089 a_623_13716.n0 a_623_13716.t4 314.149
R5090 a_576_13620.t1 a_576_13620.n2 668.986
R5091 a_576_13620.n2 a_576_13620.n0 0.196333
R5092 a_576_13620.n0 a_576_13620.n1 0.384333
R5093 a_576_13620.n1 a_576_13620.t2 232.115
R5094 a_576_13620.n1 a_576_13620.t0 87.1667
R5095 a_576_13620.n0 a_576_13620.t3 434.887
R5096 a_576_13620.n2 a_576_13620.t4 314.171
R5097 a_623_15516.t1 a_623_15516.n0 669.27
R5098 a_623_15516.n0 a_623_15516.n1 0.384333
R5099 a_623_15516.n1 a_623_15516.n2 0.1885
R5100 a_623_15516.n2 a_623_15516.t2 232.047
R5101 a_623_15516.n2 a_623_15516.t3 435.25
R5102 a_623_15516.n1 a_623_15516.t0 87.3032
R5103 a_623_15516.n0 a_623_15516.t4 314.149
R5104 a_576_15420.t1 a_576_15420.n2 668.986
R5105 a_576_15420.n2 a_576_15420.n0 0.196333
R5106 a_576_15420.n0 a_576_15420.n1 0.384333
R5107 a_576_15420.n1 a_576_15420.t2 232.115
R5108 a_576_15420.n1 a_576_15420.t0 87.1667
R5109 a_576_15420.n0 a_576_15420.t3 434.887
R5110 a_576_15420.n2 a_576_15420.t4 314.171
R5111 a_623_17316.t1 a_623_17316.n0 669.27
R5112 a_623_17316.n0 a_623_17316.n1 0.384333
R5113 a_623_17316.n1 a_623_17316.n2 0.1885
R5114 a_623_17316.n2 a_623_17316.t2 232.047
R5115 a_623_17316.n2 a_623_17316.t3 435.25
R5116 a_623_17316.n1 a_623_17316.t0 87.3032
R5117 a_623_17316.n0 a_623_17316.t4 314.149
R5118 a_576_17220.t1 a_576_17220.n2 668.986
R5119 a_576_17220.n2 a_576_17220.n0 0.196333
R5120 a_576_17220.n0 a_576_17220.n1 0.384333
R5121 a_576_17220.n1 a_576_17220.t2 232.115
R5122 a_576_17220.n1 a_576_17220.t0 87.1667
R5123 a_576_17220.n0 a_576_17220.t3 434.887
R5124 a_576_17220.n2 a_576_17220.t4 314.171
R5125 a_623_19116.t0 a_623_19116.n0 669.27
R5126 a_623_19116.n0 a_623_19116.n1 0.384333
R5127 a_623_19116.n1 a_623_19116.n2 0.1885
R5128 a_623_19116.n2 a_623_19116.t2 232.047
R5129 a_623_19116.n2 a_623_19116.t3 435.25
R5130 a_623_19116.n1 a_623_19116.t1 87.3032
R5131 a_623_19116.n0 a_623_19116.t4 314.149
R5132 a_576_19020.t1 a_576_19020.n2 668.986
R5133 a_576_19020.n2 a_576_19020.n0 0.196333
R5134 a_576_19020.n0 a_576_19020.n1 0.384333
R5135 a_576_19020.n1 a_576_19020.t2 232.115
R5136 a_576_19020.n1 a_576_19020.t0 87.1667
R5137 a_576_19020.n0 a_576_19020.t3 434.887
R5138 a_576_19020.n2 a_576_19020.t4 314.171
R5139 a_623_20916.t1 a_623_20916.n0 669.27
R5140 a_623_20916.n0 a_623_20916.n1 0.384333
R5141 a_623_20916.n1 a_623_20916.n2 0.1885
R5142 a_623_20916.n2 a_623_20916.t2 232.047
R5143 a_623_20916.n2 a_623_20916.t3 435.25
R5144 a_623_20916.n1 a_623_20916.t0 87.3032
R5145 a_623_20916.n0 a_623_20916.t4 314.149
R5146 a_576_20820.t1 a_576_20820.n2 668.986
R5147 a_576_20820.n2 a_576_20820.n0 0.196333
R5148 a_576_20820.n0 a_576_20820.n1 0.384333
R5149 a_576_20820.n1 a_576_20820.t2 232.115
R5150 a_576_20820.n1 a_576_20820.t0 87.1667
R5151 a_576_20820.n0 a_576_20820.t3 434.887
R5152 a_576_20820.n2 a_576_20820.t4 314.171
R5153 a_623_22716.t1 a_623_22716.n0 669.27
R5154 a_623_22716.n0 a_623_22716.n1 0.384333
R5155 a_623_22716.n1 a_623_22716.n2 0.1885
R5156 a_623_22716.n2 a_623_22716.t2 232.047
R5157 a_623_22716.n2 a_623_22716.t3 435.25
R5158 a_623_22716.n1 a_623_22716.t0 87.3032
R5159 a_623_22716.n0 a_623_22716.t4 314.149
R5160 a_576_22620.t1 a_576_22620.n2 668.986
R5161 a_576_22620.n2 a_576_22620.n0 0.196333
R5162 a_576_22620.n0 a_576_22620.n1 0.384333
R5163 a_576_22620.n1 a_576_22620.t2 232.115
R5164 a_576_22620.n1 a_576_22620.t0 87.1667
R5165 a_576_22620.n0 a_576_22620.t3 434.887
R5166 a_576_22620.n2 a_576_22620.t4 314.171
R5167 a_623_24516.t0 a_623_24516.n0 669.27
R5168 a_623_24516.n0 a_623_24516.n1 0.384333
R5169 a_623_24516.n1 a_623_24516.n2 0.1885
R5170 a_623_24516.n2 a_623_24516.t2 232.047
R5171 a_623_24516.n2 a_623_24516.t3 435.25
R5172 a_623_24516.n1 a_623_24516.t1 87.3032
R5173 a_623_24516.n0 a_623_24516.t4 314.149
R5174 a_576_24420.t1 a_576_24420.n2 668.986
R5175 a_576_24420.n2 a_576_24420.n0 0.196333
R5176 a_576_24420.n0 a_576_24420.n1 0.384333
R5177 a_576_24420.n1 a_576_24420.t2 232.115
R5178 a_576_24420.n1 a_576_24420.t0 87.1667
R5179 a_576_24420.n0 a_576_24420.t3 434.887
R5180 a_576_24420.n2 a_576_24420.t4 314.171
R5181 a_623_26316.t1 a_623_26316.n0 669.27
R5182 a_623_26316.n0 a_623_26316.n1 0.384333
R5183 a_623_26316.n1 a_623_26316.n2 0.1885
R5184 a_623_26316.n2 a_623_26316.t2 232.047
R5185 a_623_26316.n2 a_623_26316.t3 435.25
R5186 a_623_26316.n1 a_623_26316.t0 87.3032
R5187 a_623_26316.n0 a_623_26316.t4 314.149
R5188 a_576_26220.t1 a_576_26220.n2 668.986
R5189 a_576_26220.n2 a_576_26220.n0 0.196333
R5190 a_576_26220.n0 a_576_26220.n1 0.384333
R5191 a_576_26220.n1 a_576_26220.t2 232.115
R5192 a_576_26220.n1 a_576_26220.t0 87.1667
R5193 a_576_26220.n0 a_576_26220.t3 434.887
R5194 a_576_26220.n2 a_576_26220.t4 314.171
R5195 a_623_28116.t1 a_623_28116.n0 669.27
R5196 a_623_28116.n0 a_623_28116.n1 0.384333
R5197 a_623_28116.n1 a_623_28116.n2 0.1885
R5198 a_623_28116.n2 a_623_28116.t2 232.047
R5199 a_623_28116.n2 a_623_28116.t3 435.25
R5200 a_623_28116.n1 a_623_28116.t0 87.3032
R5201 a_623_28116.n0 a_623_28116.t4 314.149
R5202 a_576_28020.t1 a_576_28020.n2 668.986
R5203 a_576_28020.n2 a_576_28020.n0 0.196333
R5204 a_576_28020.n0 a_576_28020.n1 0.384333
R5205 a_576_28020.n1 a_576_28020.t2 232.115
R5206 a_576_28020.n1 a_576_28020.t0 87.1667
R5207 a_576_28020.n0 a_576_28020.t3 434.887
R5208 a_576_28020.n2 a_576_28020.t4 314.171
R5209 a_623_29916.t1 a_623_29916.n0 669.27
R5210 a_623_29916.n0 a_623_29916.n1 0.384333
R5211 a_623_29916.n1 a_623_29916.n2 0.1885
R5212 a_623_29916.n2 a_623_29916.t2 232.047
R5213 a_623_29916.n2 a_623_29916.t3 435.25
R5214 a_623_29916.n1 a_623_29916.t0 87.3032
R5215 a_623_29916.n0 a_623_29916.t4 314.149
R5216 a_576_29820.t1 a_576_29820.n2 668.986
R5217 a_576_29820.n2 a_576_29820.n0 0.196333
R5218 a_576_29820.n0 a_576_29820.n1 0.384333
R5219 a_576_29820.n1 a_576_29820.t2 232.115
R5220 a_576_29820.n1 a_576_29820.t0 87.1667
R5221 a_576_29820.n0 a_576_29820.t3 434.887
R5222 a_576_29820.n2 a_576_29820.t4 314.171
R5223 a_623_31716.t1 a_623_31716.n0 669.27
R5224 a_623_31716.n0 a_623_31716.n1 0.384333
R5225 a_623_31716.n1 a_623_31716.n2 0.1885
R5226 a_623_31716.n2 a_623_31716.t2 232.047
R5227 a_623_31716.n2 a_623_31716.t3 435.25
R5228 a_623_31716.n1 a_623_31716.t0 87.3032
R5229 a_623_31716.n0 a_623_31716.t4 314.149
R5230 a_576_31620.t1 a_576_31620.n2 668.986
R5231 a_576_31620.n2 a_576_31620.n0 0.196333
R5232 a_576_31620.n0 a_576_31620.n1 0.384333
R5233 a_576_31620.n1 a_576_31620.t2 232.115
R5234 a_576_31620.n1 a_576_31620.t0 87.1667
R5235 a_576_31620.n0 a_576_31620.t3 434.887
R5236 a_576_31620.n2 a_576_31620.t4 314.171
R5237 a_623_33516.t2 a_623_33516.n0 669.27
R5238 a_623_33516.n0 a_623_33516.n1 0.384333
R5239 a_623_33516.n1 a_623_33516.n2 0.1885
R5240 a_623_33516.n2 a_623_33516.t1 232.047
R5241 a_623_33516.n2 a_623_33516.t3 435.25
R5242 a_623_33516.n1 a_623_33516.t0 87.3032
R5243 a_623_33516.n0 a_623_33516.t4 314.149
R5244 a_576_33420.t1 a_576_33420.n2 668.986
R5245 a_576_33420.n2 a_576_33420.n0 0.196333
R5246 a_576_33420.n0 a_576_33420.n1 0.384333
R5247 a_576_33420.n1 a_576_33420.t2 232.115
R5248 a_576_33420.n1 a_576_33420.t0 87.1667
R5249 a_576_33420.n0 a_576_33420.t3 434.887
R5250 a_576_33420.n2 a_576_33420.t4 314.171
R5251 a_623_35316.t0 a_623_35316.n0 669.27
R5252 a_623_35316.n0 a_623_35316.n1 0.384333
R5253 a_623_35316.n1 a_623_35316.n2 0.1885
R5254 a_623_35316.n2 a_623_35316.t1 232.047
R5255 a_623_35316.n2 a_623_35316.t3 435.25
R5256 a_623_35316.n1 a_623_35316.t2 87.3032
R5257 a_623_35316.n0 a_623_35316.t4 314.149
R5258 a_576_35220.t1 a_576_35220.n2 668.986
R5259 a_576_35220.n2 a_576_35220.n0 0.196333
R5260 a_576_35220.n0 a_576_35220.n1 0.384333
R5261 a_576_35220.n1 a_576_35220.t2 232.115
R5262 a_576_35220.n1 a_576_35220.t0 87.1667
R5263 a_576_35220.n0 a_576_35220.t3 434.887
R5264 a_576_35220.n2 a_576_35220.t4 314.171
R5265 a_623_37116.t0 a_623_37116.n0 669.27
R5266 a_623_37116.n0 a_623_37116.n1 0.384333
R5267 a_623_37116.n1 a_623_37116.n2 0.1885
R5268 a_623_37116.n2 a_623_37116.t2 232.047
R5269 a_623_37116.n2 a_623_37116.t3 435.25
R5270 a_623_37116.n1 a_623_37116.t1 87.3032
R5271 a_623_37116.n0 a_623_37116.t4 314.149
R5272 a_576_37020.t1 a_576_37020.n2 668.986
R5273 a_576_37020.n2 a_576_37020.n0 0.196333
R5274 a_576_37020.n0 a_576_37020.n1 0.384333
R5275 a_576_37020.n1 a_576_37020.t2 232.115
R5276 a_576_37020.n1 a_576_37020.t0 87.1667
R5277 a_576_37020.n0 a_576_37020.t3 434.887
R5278 a_576_37020.n2 a_576_37020.t4 314.171
R5279 a_623_38916.t1 a_623_38916.n0 669.27
R5280 a_623_38916.n0 a_623_38916.n1 0.384333
R5281 a_623_38916.n1 a_623_38916.n2 0.1885
R5282 a_623_38916.n2 a_623_38916.t2 232.047
R5283 a_623_38916.n2 a_623_38916.t3 435.25
R5284 a_623_38916.n1 a_623_38916.t0 87.3032
R5285 a_623_38916.n0 a_623_38916.t4 314.149
R5286 a_576_38820.t1 a_576_38820.n2 668.986
R5287 a_576_38820.n2 a_576_38820.n0 0.196333
R5288 a_576_38820.n0 a_576_38820.n1 0.384333
R5289 a_576_38820.n1 a_576_38820.t2 232.115
R5290 a_576_38820.n1 a_576_38820.t0 87.1667
R5291 a_576_38820.n0 a_576_38820.t3 434.887
R5292 a_576_38820.n2 a_576_38820.t4 314.171
R5293 a_623_40716.t1 a_623_40716.n0 669.27
R5294 a_623_40716.n0 a_623_40716.n1 0.384333
R5295 a_623_40716.n1 a_623_40716.n2 0.1885
R5296 a_623_40716.n2 a_623_40716.t2 232.047
R5297 a_623_40716.n2 a_623_40716.t3 435.25
R5298 a_623_40716.n1 a_623_40716.t0 87.3032
R5299 a_623_40716.n0 a_623_40716.t4 314.149
R5300 a_576_40620.t1 a_576_40620.n2 668.986
R5301 a_576_40620.n2 a_576_40620.n0 0.196333
R5302 a_576_40620.n0 a_576_40620.n1 0.384333
R5303 a_576_40620.n1 a_576_40620.t2 232.115
R5304 a_576_40620.n1 a_576_40620.t0 87.1667
R5305 a_576_40620.n0 a_576_40620.t3 434.887
R5306 a_576_40620.n2 a_576_40620.t4 314.171
R5307 a_623_42516.t0 a_623_42516.n0 669.27
R5308 a_623_42516.n0 a_623_42516.n1 0.384333
R5309 a_623_42516.n1 a_623_42516.n2 0.1885
R5310 a_623_42516.n2 a_623_42516.t2 232.047
R5311 a_623_42516.n2 a_623_42516.t3 435.25
R5312 a_623_42516.n1 a_623_42516.t1 87.3032
R5313 a_623_42516.n0 a_623_42516.t4 314.149
R5314 a_576_42420.t1 a_576_42420.n2 668.986
R5315 a_576_42420.n2 a_576_42420.n0 0.196333
R5316 a_576_42420.n0 a_576_42420.n1 0.384333
R5317 a_576_42420.n1 a_576_42420.t2 232.115
R5318 a_576_42420.n1 a_576_42420.t0 87.1667
R5319 a_576_42420.n0 a_576_42420.t3 434.887
R5320 a_576_42420.n2 a_576_42420.t4 314.171
R5321 a_623_44316.t1 a_623_44316.n0 669.27
R5322 a_623_44316.n0 a_623_44316.n1 0.384333
R5323 a_623_44316.n1 a_623_44316.n2 0.1885
R5324 a_623_44316.n2 a_623_44316.t2 232.047
R5325 a_623_44316.n2 a_623_44316.t3 435.25
R5326 a_623_44316.n1 a_623_44316.t0 87.3032
R5327 a_623_44316.n0 a_623_44316.t4 314.149
R5328 a_576_44220.t1 a_576_44220.n2 668.986
R5329 a_576_44220.n2 a_576_44220.n0 0.196333
R5330 a_576_44220.n0 a_576_44220.n1 0.384333
R5331 a_576_44220.n1 a_576_44220.t2 232.115
R5332 a_576_44220.n1 a_576_44220.t0 87.1667
R5333 a_576_44220.n0 a_576_44220.t3 434.887
R5334 a_576_44220.n2 a_576_44220.t4 314.171
R5335 a_623_46116.t0 a_623_46116.n0 669.27
R5336 a_623_46116.n0 a_623_46116.n1 0.384333
R5337 a_623_46116.n1 a_623_46116.n2 0.1885
R5338 a_623_46116.n2 a_623_46116.t1 232.047
R5339 a_623_46116.n2 a_623_46116.t3 435.25
R5340 a_623_46116.n1 a_623_46116.t2 87.3032
R5341 a_623_46116.n0 a_623_46116.t4 314.149
R5342 a_576_46020.t1 a_576_46020.n2 668.986
R5343 a_576_46020.n2 a_576_46020.n0 0.196333
R5344 a_576_46020.n0 a_576_46020.n1 0.384333
R5345 a_576_46020.n1 a_576_46020.t2 232.115
R5346 a_576_46020.n1 a_576_46020.t0 87.1667
R5347 a_576_46020.n0 a_576_46020.t3 434.887
R5348 a_576_46020.n2 a_576_46020.t4 314.171
R5349 a_623_47916.t1 a_623_47916.n0 669.27
R5350 a_623_47916.n0 a_623_47916.n1 0.384333
R5351 a_623_47916.n1 a_623_47916.n2 0.1885
R5352 a_623_47916.n2 a_623_47916.t2 232.047
R5353 a_623_47916.n2 a_623_47916.t3 435.25
R5354 a_623_47916.n1 a_623_47916.t0 87.3032
R5355 a_623_47916.n0 a_623_47916.t4 314.149
R5356 a_576_47820.t1 a_576_47820.n2 668.986
R5357 a_576_47820.n2 a_576_47820.n0 0.196333
R5358 a_576_47820.n0 a_576_47820.n1 0.384333
R5359 a_576_47820.n1 a_576_47820.t2 232.115
R5360 a_576_47820.n1 a_576_47820.t0 87.1667
R5361 a_576_47820.n0 a_576_47820.t3 434.887
R5362 a_576_47820.n2 a_576_47820.t4 314.171
R5363 a_623_49716.t1 a_623_49716.n0 669.27
R5364 a_623_49716.n0 a_623_49716.n1 0.384333
R5365 a_623_49716.n1 a_623_49716.n2 0.1885
R5366 a_623_49716.n2 a_623_49716.t2 232.047
R5367 a_623_49716.n2 a_623_49716.t3 435.25
R5368 a_623_49716.n1 a_623_49716.t0 87.3032
R5369 a_623_49716.n0 a_623_49716.t4 314.149
R5370 a_576_49620.t1 a_576_49620.n2 668.986
R5371 a_576_49620.n2 a_576_49620.n0 0.196333
R5372 a_576_49620.n0 a_576_49620.n1 0.384333
R5373 a_576_49620.n1 a_576_49620.t2 232.115
R5374 a_576_49620.n1 a_576_49620.t0 87.1667
R5375 a_576_49620.n0 a_576_49620.t3 434.887
R5376 a_576_49620.n2 a_576_49620.t4 314.171
R5377 a_623_51516.t0 a_623_51516.n0 669.27
R5378 a_623_51516.n0 a_623_51516.n1 0.384333
R5379 a_623_51516.n1 a_623_51516.n2 0.1885
R5380 a_623_51516.n2 a_623_51516.t1 232.047
R5381 a_623_51516.n2 a_623_51516.t3 435.25
R5382 a_623_51516.n1 a_623_51516.t2 87.3032
R5383 a_623_51516.n0 a_623_51516.t4 314.149
R5384 a_576_51420.t1 a_576_51420.n2 668.986
R5385 a_576_51420.n2 a_576_51420.n0 0.196333
R5386 a_576_51420.n0 a_576_51420.n1 0.384333
R5387 a_576_51420.n1 a_576_51420.t2 232.115
R5388 a_576_51420.n1 a_576_51420.t0 87.1667
R5389 a_576_51420.n0 a_576_51420.t3 434.887
R5390 a_576_51420.n2 a_576_51420.t4 314.171
R5391 a_623_53316.t1 a_623_53316.n0 669.27
R5392 a_623_53316.n0 a_623_53316.n1 0.384333
R5393 a_623_53316.n1 a_623_53316.n2 0.1885
R5394 a_623_53316.n2 a_623_53316.t2 232.047
R5395 a_623_53316.n2 a_623_53316.t3 435.25
R5396 a_623_53316.n1 a_623_53316.t0 87.3032
R5397 a_623_53316.n0 a_623_53316.t4 314.149
R5398 a_576_53220.t1 a_576_53220.n2 668.986
R5399 a_576_53220.n2 a_576_53220.n0 0.196333
R5400 a_576_53220.n0 a_576_53220.n1 0.384333
R5401 a_576_53220.n1 a_576_53220.t2 232.115
R5402 a_576_53220.n1 a_576_53220.t0 87.1667
R5403 a_576_53220.n0 a_576_53220.t3 434.887
R5404 a_576_53220.n2 a_576_53220.t4 314.171
R5405 a_623_55116.t0 a_623_55116.n0 669.27
R5406 a_623_55116.n0 a_623_55116.n1 0.384333
R5407 a_623_55116.n1 a_623_55116.n2 0.1885
R5408 a_623_55116.n2 a_623_55116.t2 232.047
R5409 a_623_55116.n2 a_623_55116.t3 435.25
R5410 a_623_55116.n1 a_623_55116.t1 87.3032
R5411 a_623_55116.n0 a_623_55116.t4 314.149
R5412 a_576_55020.t1 a_576_55020.n2 668.986
R5413 a_576_55020.n2 a_576_55020.n0 0.196333
R5414 a_576_55020.n0 a_576_55020.n1 0.384333
R5415 a_576_55020.n1 a_576_55020.t2 232.115
R5416 a_576_55020.n1 a_576_55020.t0 87.1667
R5417 a_576_55020.n0 a_576_55020.t3 434.887
R5418 a_576_55020.n2 a_576_55020.t4 314.171
R5419 a_623_56916.t0 a_623_56916.n0 669.27
R5420 a_623_56916.n0 a_623_56916.n1 0.384333
R5421 a_623_56916.n1 a_623_56916.n2 0.1885
R5422 a_623_56916.n2 a_623_56916.t2 232.047
R5423 a_623_56916.n2 a_623_56916.t3 435.25
R5424 a_623_56916.n1 a_623_56916.t1 87.3032
R5425 a_623_56916.n0 a_623_56916.t4 314.149
R5426 a_576_56820.t1 a_576_56820.n2 668.986
R5427 a_576_56820.n2 a_576_56820.n0 0.196333
R5428 a_576_56820.n0 a_576_56820.n1 0.384333
R5429 a_576_56820.n1 a_576_56820.t2 232.115
R5430 a_576_56820.n1 a_576_56820.t0 87.1667
R5431 a_576_56820.n0 a_576_56820.t3 434.887
R5432 a_576_56820.n2 a_576_56820.t4 314.171
C34 DATA VSS 2.26218f
C35 DATA_B VSS 2.06278f
C36 WE VSS 4.04693f
C37 SCLK VSS 2.55881f
C38 PRECH VSS 1.28814f
C39 BLB VSS 58.51579f
C40 BL VSS 32.04364f
C41 WLOFF VSS 0.11499p
C42 VDD VSS 0.1641p
C43 sense_amp_scale1p5_flat_0.SA_OUT VSS 2.16226f $ **FLOATING
C44 sense_amp_scale1p5_flat_0.SA_OUTB VSS 2.64598f $ **FLOATING
C45 a_576_56820.t1 VSS 0.04697f $ **FLOATING
C46 a_576_56820.t4 VSS 0.10326f $ **FLOATING
C47 a_576_56820.t3 VSS 0.13128f $ **FLOATING
C48 a_576_56820.n0 VSS 0.48254f $ **FLOATING
C49 a_576_56820.t0 VSS 0.16678f $ **FLOATING
C50 a_576_56820.n1 VSS 1.93293f $ **FLOATING
C51 a_576_56820.t2 VSS 0.07734f $ **FLOATING
C52 a_576_56820.n2 VSS 1.40322f $ **FLOATING
C53 a_623_56916.t0 VSS 0.06134f $ **FLOATING
C54 a_623_56916.t4 VSS 0.13418f $ **FLOATING
C55 a_623_56916.n0 VSS 1.98419f $ **FLOATING
C56 a_623_56916.t1 VSS 0.21872f $ **FLOATING
C57 a_623_56916.n1 VSS 1.01409f $ **FLOATING
C58 a_623_56916.t3 VSS 0.17111f $ **FLOATING
C59 a_623_56916.n2 VSS 2.33234f $ **FLOATING
C60 a_623_56916.t2 VSS 0.10008f $ **FLOATING
C61 a_576_55020.t1 VSS 0.04719f $ **FLOATING
C62 a_576_55020.t4 VSS 0.10374f $ **FLOATING
C63 a_576_55020.t3 VSS 0.13189f $ **FLOATING
C64 a_576_55020.n0 VSS 0.48477f $ **FLOATING
C65 a_576_55020.t0 VSS 0.16755f $ **FLOATING
C66 a_576_55020.n1 VSS 1.94185f $ **FLOATING
C67 a_576_55020.t2 VSS 0.0777f $ **FLOATING
C68 a_576_55020.n2 VSS 1.4097f $ **FLOATING
C69 a_623_55116.t0 VSS 0.06157f $ **FLOATING
C70 a_623_55116.t4 VSS 0.13467f $ **FLOATING
C71 a_623_55116.n0 VSS 1.99144f $ **FLOATING
C72 a_623_55116.t1 VSS 0.21951f $ **FLOATING
C73 a_623_55116.n1 VSS 1.0178f $ **FLOATING
C74 a_623_55116.t3 VSS 0.17174f $ **FLOATING
C75 a_623_55116.n2 VSS 2.34087f $ **FLOATING
C76 a_623_55116.t2 VSS 0.10044f $ **FLOATING
C77 a_576_53220.t1 VSS 0.04719f $ **FLOATING
C78 a_576_53220.t4 VSS 0.10374f $ **FLOATING
C79 a_576_53220.t3 VSS 0.13189f $ **FLOATING
C80 a_576_53220.n0 VSS 0.48477f $ **FLOATING
C81 a_576_53220.t0 VSS 0.16755f $ **FLOATING
C82 a_576_53220.n1 VSS 1.94185f $ **FLOATING
C83 a_576_53220.t2 VSS 0.0777f $ **FLOATING
C84 a_576_53220.n2 VSS 1.4097f $ **FLOATING
C85 a_623_53316.t1 VSS 0.06157f $ **FLOATING
C86 a_623_53316.t4 VSS 0.13467f $ **FLOATING
C87 a_623_53316.n0 VSS 1.99144f $ **FLOATING
C88 a_623_53316.t0 VSS 0.21951f $ **FLOATING
C89 a_623_53316.n1 VSS 1.0178f $ **FLOATING
C90 a_623_53316.t3 VSS 0.17174f $ **FLOATING
C91 a_623_53316.n2 VSS 2.34087f $ **FLOATING
C92 a_623_53316.t2 VSS 0.10044f $ **FLOATING
C93 a_576_51420.t1 VSS 0.04719f $ **FLOATING
C94 a_576_51420.t4 VSS 0.10374f $ **FLOATING
C95 a_576_51420.t3 VSS 0.13189f $ **FLOATING
C96 a_576_51420.n0 VSS 0.48477f $ **FLOATING
C97 a_576_51420.t0 VSS 0.16755f $ **FLOATING
C98 a_576_51420.n1 VSS 1.94185f $ **FLOATING
C99 a_576_51420.t2 VSS 0.0777f $ **FLOATING
C100 a_576_51420.n2 VSS 1.4097f $ **FLOATING
C101 a_623_51516.t0 VSS 0.06157f $ **FLOATING
C102 a_623_51516.t4 VSS 0.13467f $ **FLOATING
C103 a_623_51516.n0 VSS 1.99144f $ **FLOATING
C104 a_623_51516.t2 VSS 0.21951f $ **FLOATING
C105 a_623_51516.n1 VSS 1.0178f $ **FLOATING
C106 a_623_51516.t3 VSS 0.17174f $ **FLOATING
C107 a_623_51516.n2 VSS 2.34087f $ **FLOATING
C108 a_623_51516.t1 VSS 0.10044f $ **FLOATING
C109 a_576_49620.t1 VSS 0.04719f $ **FLOATING
C110 a_576_49620.t4 VSS 0.10374f $ **FLOATING
C111 a_576_49620.t3 VSS 0.13189f $ **FLOATING
C112 a_576_49620.n0 VSS 0.48477f $ **FLOATING
C113 a_576_49620.t0 VSS 0.16755f $ **FLOATING
C114 a_576_49620.n1 VSS 1.94185f $ **FLOATING
C115 a_576_49620.t2 VSS 0.0777f $ **FLOATING
C116 a_576_49620.n2 VSS 1.4097f $ **FLOATING
C117 a_623_49716.t1 VSS 0.06157f $ **FLOATING
C118 a_623_49716.t4 VSS 0.13467f $ **FLOATING
C119 a_623_49716.n0 VSS 1.99144f $ **FLOATING
C120 a_623_49716.t0 VSS 0.21951f $ **FLOATING
C121 a_623_49716.n1 VSS 1.0178f $ **FLOATING
C122 a_623_49716.t3 VSS 0.17174f $ **FLOATING
C123 a_623_49716.n2 VSS 2.34087f $ **FLOATING
C124 a_623_49716.t2 VSS 0.10044f $ **FLOATING
C125 a_576_47820.t1 VSS 0.04719f $ **FLOATING
C126 a_576_47820.t4 VSS 0.10374f $ **FLOATING
C127 a_576_47820.t3 VSS 0.13189f $ **FLOATING
C128 a_576_47820.n0 VSS 0.48477f $ **FLOATING
C129 a_576_47820.t0 VSS 0.16755f $ **FLOATING
C130 a_576_47820.n1 VSS 1.94185f $ **FLOATING
C131 a_576_47820.t2 VSS 0.0777f $ **FLOATING
C132 a_576_47820.n2 VSS 1.4097f $ **FLOATING
C133 a_623_47916.t1 VSS 0.06157f $ **FLOATING
C134 a_623_47916.t4 VSS 0.13467f $ **FLOATING
C135 a_623_47916.n0 VSS 1.99144f $ **FLOATING
C136 a_623_47916.t0 VSS 0.21951f $ **FLOATING
C137 a_623_47916.n1 VSS 1.0178f $ **FLOATING
C138 a_623_47916.t3 VSS 0.17174f $ **FLOATING
C139 a_623_47916.n2 VSS 2.34087f $ **FLOATING
C140 a_623_47916.t2 VSS 0.10044f $ **FLOATING
C141 a_576_46020.t1 VSS 0.04719f $ **FLOATING
C142 a_576_46020.t4 VSS 0.10374f $ **FLOATING
C143 a_576_46020.t3 VSS 0.13189f $ **FLOATING
C144 a_576_46020.n0 VSS 0.48477f $ **FLOATING
C145 a_576_46020.t0 VSS 0.16755f $ **FLOATING
C146 a_576_46020.n1 VSS 1.94185f $ **FLOATING
C147 a_576_46020.t2 VSS 0.0777f $ **FLOATING
C148 a_576_46020.n2 VSS 1.4097f $ **FLOATING
C149 a_623_46116.t0 VSS 0.06157f $ **FLOATING
C150 a_623_46116.t4 VSS 0.13467f $ **FLOATING
C151 a_623_46116.n0 VSS 1.99144f $ **FLOATING
C152 a_623_46116.t2 VSS 0.21951f $ **FLOATING
C153 a_623_46116.n1 VSS 1.0178f $ **FLOATING
C154 a_623_46116.t3 VSS 0.17174f $ **FLOATING
C155 a_623_46116.n2 VSS 2.34087f $ **FLOATING
C156 a_623_46116.t1 VSS 0.10044f $ **FLOATING
C157 a_576_44220.t1 VSS 0.04719f $ **FLOATING
C158 a_576_44220.t4 VSS 0.10374f $ **FLOATING
C159 a_576_44220.t3 VSS 0.13189f $ **FLOATING
C160 a_576_44220.n0 VSS 0.48477f $ **FLOATING
C161 a_576_44220.t0 VSS 0.16755f $ **FLOATING
C162 a_576_44220.n1 VSS 1.94185f $ **FLOATING
C163 a_576_44220.t2 VSS 0.0777f $ **FLOATING
C164 a_576_44220.n2 VSS 1.4097f $ **FLOATING
C165 a_623_44316.t1 VSS 0.06157f $ **FLOATING
C166 a_623_44316.t4 VSS 0.13467f $ **FLOATING
C167 a_623_44316.n0 VSS 1.99144f $ **FLOATING
C168 a_623_44316.t0 VSS 0.21951f $ **FLOATING
C169 a_623_44316.n1 VSS 1.0178f $ **FLOATING
C170 a_623_44316.t3 VSS 0.17174f $ **FLOATING
C171 a_623_44316.n2 VSS 2.34087f $ **FLOATING
C172 a_623_44316.t2 VSS 0.10044f $ **FLOATING
C173 a_576_42420.t1 VSS 0.04719f $ **FLOATING
C174 a_576_42420.t4 VSS 0.10374f $ **FLOATING
C175 a_576_42420.t3 VSS 0.13189f $ **FLOATING
C176 a_576_42420.n0 VSS 0.48477f $ **FLOATING
C177 a_576_42420.t0 VSS 0.16755f $ **FLOATING
C178 a_576_42420.n1 VSS 1.94185f $ **FLOATING
C179 a_576_42420.t2 VSS 0.0777f $ **FLOATING
C180 a_576_42420.n2 VSS 1.4097f $ **FLOATING
C181 a_623_42516.t0 VSS 0.06157f $ **FLOATING
C182 a_623_42516.t4 VSS 0.13467f $ **FLOATING
C183 a_623_42516.n0 VSS 1.99144f $ **FLOATING
C184 a_623_42516.t1 VSS 0.21951f $ **FLOATING
C185 a_623_42516.n1 VSS 1.0178f $ **FLOATING
C186 a_623_42516.t3 VSS 0.17174f $ **FLOATING
C187 a_623_42516.n2 VSS 2.34087f $ **FLOATING
C188 a_623_42516.t2 VSS 0.10044f $ **FLOATING
C189 a_576_40620.t1 VSS 0.04719f $ **FLOATING
C190 a_576_40620.t4 VSS 0.10374f $ **FLOATING
C191 a_576_40620.t3 VSS 0.13189f $ **FLOATING
C192 a_576_40620.n0 VSS 0.48477f $ **FLOATING
C193 a_576_40620.t0 VSS 0.16755f $ **FLOATING
C194 a_576_40620.n1 VSS 1.94185f $ **FLOATING
C195 a_576_40620.t2 VSS 0.0777f $ **FLOATING
C196 a_576_40620.n2 VSS 1.4097f $ **FLOATING
C197 a_623_40716.t1 VSS 0.06157f $ **FLOATING
C198 a_623_40716.t4 VSS 0.13467f $ **FLOATING
C199 a_623_40716.n0 VSS 1.99144f $ **FLOATING
C200 a_623_40716.t0 VSS 0.21951f $ **FLOATING
C201 a_623_40716.n1 VSS 1.0178f $ **FLOATING
C202 a_623_40716.t3 VSS 0.17174f $ **FLOATING
C203 a_623_40716.n2 VSS 2.34087f $ **FLOATING
C204 a_623_40716.t2 VSS 0.10044f $ **FLOATING
C205 a_576_38820.t1 VSS 0.04719f $ **FLOATING
C206 a_576_38820.t4 VSS 0.10374f $ **FLOATING
C207 a_576_38820.t3 VSS 0.13189f $ **FLOATING
C208 a_576_38820.n0 VSS 0.48477f $ **FLOATING
C209 a_576_38820.t0 VSS 0.16755f $ **FLOATING
C210 a_576_38820.n1 VSS 1.94185f $ **FLOATING
C211 a_576_38820.t2 VSS 0.0777f $ **FLOATING
C212 a_576_38820.n2 VSS 1.4097f $ **FLOATING
C213 a_623_38916.t1 VSS 0.06157f $ **FLOATING
C214 a_623_38916.t4 VSS 0.13467f $ **FLOATING
C215 a_623_38916.n0 VSS 1.99144f $ **FLOATING
C216 a_623_38916.t0 VSS 0.21951f $ **FLOATING
C217 a_623_38916.n1 VSS 1.0178f $ **FLOATING
C218 a_623_38916.t3 VSS 0.17174f $ **FLOATING
C219 a_623_38916.n2 VSS 2.34087f $ **FLOATING
C220 a_623_38916.t2 VSS 0.10044f $ **FLOATING
C221 a_576_37020.t1 VSS 0.04719f $ **FLOATING
C222 a_576_37020.t4 VSS 0.10374f $ **FLOATING
C223 a_576_37020.t3 VSS 0.13189f $ **FLOATING
C224 a_576_37020.n0 VSS 0.48477f $ **FLOATING
C225 a_576_37020.t0 VSS 0.16755f $ **FLOATING
C226 a_576_37020.n1 VSS 1.94185f $ **FLOATING
C227 a_576_37020.t2 VSS 0.0777f $ **FLOATING
C228 a_576_37020.n2 VSS 1.4097f $ **FLOATING
C229 a_623_37116.t0 VSS 0.06157f $ **FLOATING
C230 a_623_37116.t4 VSS 0.13467f $ **FLOATING
C231 a_623_37116.n0 VSS 1.99144f $ **FLOATING
C232 a_623_37116.t1 VSS 0.21951f $ **FLOATING
C233 a_623_37116.n1 VSS 1.0178f $ **FLOATING
C234 a_623_37116.t3 VSS 0.17174f $ **FLOATING
C235 a_623_37116.n2 VSS 2.34087f $ **FLOATING
C236 a_623_37116.t2 VSS 0.10044f $ **FLOATING
C237 a_576_35220.t1 VSS 0.04719f $ **FLOATING
C238 a_576_35220.t4 VSS 0.10374f $ **FLOATING
C239 a_576_35220.t3 VSS 0.13189f $ **FLOATING
C240 a_576_35220.n0 VSS 0.48477f $ **FLOATING
C241 a_576_35220.t0 VSS 0.16755f $ **FLOATING
C242 a_576_35220.n1 VSS 1.94185f $ **FLOATING
C243 a_576_35220.t2 VSS 0.0777f $ **FLOATING
C244 a_576_35220.n2 VSS 1.4097f $ **FLOATING
C245 a_623_35316.t0 VSS 0.06157f $ **FLOATING
C246 a_623_35316.t4 VSS 0.13467f $ **FLOATING
C247 a_623_35316.n0 VSS 1.99144f $ **FLOATING
C248 a_623_35316.t2 VSS 0.21951f $ **FLOATING
C249 a_623_35316.n1 VSS 1.0178f $ **FLOATING
C250 a_623_35316.t3 VSS 0.17174f $ **FLOATING
C251 a_623_35316.n2 VSS 2.34087f $ **FLOATING
C252 a_623_35316.t1 VSS 0.10044f $ **FLOATING
C253 a_576_33420.t1 VSS 0.04719f $ **FLOATING
C254 a_576_33420.t4 VSS 0.10374f $ **FLOATING
C255 a_576_33420.t3 VSS 0.13189f $ **FLOATING
C256 a_576_33420.n0 VSS 0.48477f $ **FLOATING
C257 a_576_33420.t0 VSS 0.16755f $ **FLOATING
C258 a_576_33420.n1 VSS 1.94185f $ **FLOATING
C259 a_576_33420.t2 VSS 0.0777f $ **FLOATING
C260 a_576_33420.n2 VSS 1.4097f $ **FLOATING
C261 a_623_33516.t2 VSS 0.06157f $ **FLOATING
C262 a_623_33516.t4 VSS 0.13467f $ **FLOATING
C263 a_623_33516.n0 VSS 1.99144f $ **FLOATING
C264 a_623_33516.t0 VSS 0.21951f $ **FLOATING
C265 a_623_33516.n1 VSS 1.0178f $ **FLOATING
C266 a_623_33516.t3 VSS 0.17174f $ **FLOATING
C267 a_623_33516.n2 VSS 2.34087f $ **FLOATING
C268 a_623_33516.t1 VSS 0.10044f $ **FLOATING
C269 a_576_31620.t1 VSS 0.04719f $ **FLOATING
C270 a_576_31620.t4 VSS 0.10374f $ **FLOATING
C271 a_576_31620.t3 VSS 0.13189f $ **FLOATING
C272 a_576_31620.n0 VSS 0.48477f $ **FLOATING
C273 a_576_31620.t0 VSS 0.16755f $ **FLOATING
C274 a_576_31620.n1 VSS 1.94185f $ **FLOATING
C275 a_576_31620.t2 VSS 0.0777f $ **FLOATING
C276 a_576_31620.n2 VSS 1.4097f $ **FLOATING
C277 a_623_31716.t1 VSS 0.06157f $ **FLOATING
C278 a_623_31716.t4 VSS 0.13467f $ **FLOATING
C279 a_623_31716.n0 VSS 1.99144f $ **FLOATING
C280 a_623_31716.t0 VSS 0.21951f $ **FLOATING
C281 a_623_31716.n1 VSS 1.0178f $ **FLOATING
C282 a_623_31716.t3 VSS 0.17174f $ **FLOATING
C283 a_623_31716.n2 VSS 2.34087f $ **FLOATING
C284 a_623_31716.t2 VSS 0.10044f $ **FLOATING
C285 a_576_29820.t1 VSS 0.04719f $ **FLOATING
C286 a_576_29820.t4 VSS 0.10374f $ **FLOATING
C287 a_576_29820.t3 VSS 0.13189f $ **FLOATING
C288 a_576_29820.n0 VSS 0.48477f $ **FLOATING
C289 a_576_29820.t0 VSS 0.16755f $ **FLOATING
C290 a_576_29820.n1 VSS 1.94185f $ **FLOATING
C291 a_576_29820.t2 VSS 0.0777f $ **FLOATING
C292 a_576_29820.n2 VSS 1.4097f $ **FLOATING
C293 a_623_29916.t1 VSS 0.06157f $ **FLOATING
C294 a_623_29916.t4 VSS 0.13467f $ **FLOATING
C295 a_623_29916.n0 VSS 1.99144f $ **FLOATING
C296 a_623_29916.t0 VSS 0.21951f $ **FLOATING
C297 a_623_29916.n1 VSS 1.0178f $ **FLOATING
C298 a_623_29916.t3 VSS 0.17174f $ **FLOATING
C299 a_623_29916.n2 VSS 2.34087f $ **FLOATING
C300 a_623_29916.t2 VSS 0.10044f $ **FLOATING
C301 a_576_28020.t1 VSS 0.04719f $ **FLOATING
C302 a_576_28020.t4 VSS 0.10374f $ **FLOATING
C303 a_576_28020.t3 VSS 0.13189f $ **FLOATING
C304 a_576_28020.n0 VSS 0.48477f $ **FLOATING
C305 a_576_28020.t0 VSS 0.16755f $ **FLOATING
C306 a_576_28020.n1 VSS 1.94185f $ **FLOATING
C307 a_576_28020.t2 VSS 0.0777f $ **FLOATING
C308 a_576_28020.n2 VSS 1.4097f $ **FLOATING
C309 a_623_28116.t1 VSS 0.06157f $ **FLOATING
C310 a_623_28116.t4 VSS 0.13467f $ **FLOATING
C311 a_623_28116.n0 VSS 1.99144f $ **FLOATING
C312 a_623_28116.t0 VSS 0.21951f $ **FLOATING
C313 a_623_28116.n1 VSS 1.0178f $ **FLOATING
C314 a_623_28116.t3 VSS 0.17174f $ **FLOATING
C315 a_623_28116.n2 VSS 2.34087f $ **FLOATING
C316 a_623_28116.t2 VSS 0.10044f $ **FLOATING
C317 a_576_26220.t1 VSS 0.04719f $ **FLOATING
C318 a_576_26220.t4 VSS 0.10374f $ **FLOATING
C319 a_576_26220.t3 VSS 0.13189f $ **FLOATING
C320 a_576_26220.n0 VSS 0.48477f $ **FLOATING
C321 a_576_26220.t0 VSS 0.16755f $ **FLOATING
C322 a_576_26220.n1 VSS 1.94185f $ **FLOATING
C323 a_576_26220.t2 VSS 0.0777f $ **FLOATING
C324 a_576_26220.n2 VSS 1.4097f $ **FLOATING
C325 a_623_26316.t1 VSS 0.06157f $ **FLOATING
C326 a_623_26316.t4 VSS 0.13467f $ **FLOATING
C327 a_623_26316.n0 VSS 1.99144f $ **FLOATING
C328 a_623_26316.t0 VSS 0.21951f $ **FLOATING
C329 a_623_26316.n1 VSS 1.0178f $ **FLOATING
C330 a_623_26316.t3 VSS 0.17174f $ **FLOATING
C331 a_623_26316.n2 VSS 2.34087f $ **FLOATING
C332 a_623_26316.t2 VSS 0.10044f $ **FLOATING
C333 a_576_24420.t1 VSS 0.04719f $ **FLOATING
C334 a_576_24420.t4 VSS 0.10374f $ **FLOATING
C335 a_576_24420.t3 VSS 0.13189f $ **FLOATING
C336 a_576_24420.n0 VSS 0.48477f $ **FLOATING
C337 a_576_24420.t0 VSS 0.16755f $ **FLOATING
C338 a_576_24420.n1 VSS 1.94185f $ **FLOATING
C339 a_576_24420.t2 VSS 0.0777f $ **FLOATING
C340 a_576_24420.n2 VSS 1.4097f $ **FLOATING
C341 a_623_24516.t0 VSS 0.06157f $ **FLOATING
C342 a_623_24516.t4 VSS 0.13467f $ **FLOATING
C343 a_623_24516.n0 VSS 1.99144f $ **FLOATING
C344 a_623_24516.t1 VSS 0.21951f $ **FLOATING
C345 a_623_24516.n1 VSS 1.0178f $ **FLOATING
C346 a_623_24516.t3 VSS 0.17174f $ **FLOATING
C347 a_623_24516.n2 VSS 2.34087f $ **FLOATING
C348 a_623_24516.t2 VSS 0.10044f $ **FLOATING
C349 a_576_22620.t1 VSS 0.04719f $ **FLOATING
C350 a_576_22620.t4 VSS 0.10374f $ **FLOATING
C351 a_576_22620.t3 VSS 0.13189f $ **FLOATING
C352 a_576_22620.n0 VSS 0.48477f $ **FLOATING
C353 a_576_22620.t0 VSS 0.16755f $ **FLOATING
C354 a_576_22620.n1 VSS 1.94185f $ **FLOATING
C355 a_576_22620.t2 VSS 0.0777f $ **FLOATING
C356 a_576_22620.n2 VSS 1.4097f $ **FLOATING
C357 a_623_22716.t1 VSS 0.06157f $ **FLOATING
C358 a_623_22716.t4 VSS 0.13467f $ **FLOATING
C359 a_623_22716.n0 VSS 1.99144f $ **FLOATING
C360 a_623_22716.t0 VSS 0.21951f $ **FLOATING
C361 a_623_22716.n1 VSS 1.0178f $ **FLOATING
C362 a_623_22716.t3 VSS 0.17174f $ **FLOATING
C363 a_623_22716.n2 VSS 2.34087f $ **FLOATING
C364 a_623_22716.t2 VSS 0.10044f $ **FLOATING
C365 a_576_20820.t1 VSS 0.04719f $ **FLOATING
C366 a_576_20820.t4 VSS 0.10374f $ **FLOATING
C367 a_576_20820.t3 VSS 0.13189f $ **FLOATING
C368 a_576_20820.n0 VSS 0.48477f $ **FLOATING
C369 a_576_20820.t0 VSS 0.16755f $ **FLOATING
C370 a_576_20820.n1 VSS 1.94185f $ **FLOATING
C371 a_576_20820.t2 VSS 0.0777f $ **FLOATING
C372 a_576_20820.n2 VSS 1.4097f $ **FLOATING
C373 a_623_20916.t1 VSS 0.06157f $ **FLOATING
C374 a_623_20916.t4 VSS 0.13467f $ **FLOATING
C375 a_623_20916.n0 VSS 1.99144f $ **FLOATING
C376 a_623_20916.t0 VSS 0.21951f $ **FLOATING
C377 a_623_20916.n1 VSS 1.0178f $ **FLOATING
C378 a_623_20916.t3 VSS 0.17174f $ **FLOATING
C379 a_623_20916.n2 VSS 2.34087f $ **FLOATING
C380 a_623_20916.t2 VSS 0.10044f $ **FLOATING
C381 a_576_19020.t1 VSS 0.04719f $ **FLOATING
C382 a_576_19020.t4 VSS 0.10374f $ **FLOATING
C383 a_576_19020.t3 VSS 0.13189f $ **FLOATING
C384 a_576_19020.n0 VSS 0.48477f $ **FLOATING
C385 a_576_19020.t0 VSS 0.16755f $ **FLOATING
C386 a_576_19020.n1 VSS 1.94185f $ **FLOATING
C387 a_576_19020.t2 VSS 0.0777f $ **FLOATING
C388 a_576_19020.n2 VSS 1.4097f $ **FLOATING
C389 a_623_19116.t0 VSS 0.06157f $ **FLOATING
C390 a_623_19116.t4 VSS 0.13467f $ **FLOATING
C391 a_623_19116.n0 VSS 1.99144f $ **FLOATING
C392 a_623_19116.t1 VSS 0.21951f $ **FLOATING
C393 a_623_19116.n1 VSS 1.0178f $ **FLOATING
C394 a_623_19116.t3 VSS 0.17174f $ **FLOATING
C395 a_623_19116.n2 VSS 2.34087f $ **FLOATING
C396 a_623_19116.t2 VSS 0.10044f $ **FLOATING
C397 a_576_17220.t1 VSS 0.04719f $ **FLOATING
C398 a_576_17220.t4 VSS 0.10374f $ **FLOATING
C399 a_576_17220.t3 VSS 0.13189f $ **FLOATING
C400 a_576_17220.n0 VSS 0.48477f $ **FLOATING
C401 a_576_17220.t0 VSS 0.16755f $ **FLOATING
C402 a_576_17220.n1 VSS 1.94185f $ **FLOATING
C403 a_576_17220.t2 VSS 0.0777f $ **FLOATING
C404 a_576_17220.n2 VSS 1.4097f $ **FLOATING
C405 a_623_17316.t1 VSS 0.06157f $ **FLOATING
C406 a_623_17316.t4 VSS 0.13467f $ **FLOATING
C407 a_623_17316.n0 VSS 1.99144f $ **FLOATING
C408 a_623_17316.t0 VSS 0.21951f $ **FLOATING
C409 a_623_17316.n1 VSS 1.0178f $ **FLOATING
C410 a_623_17316.t3 VSS 0.17174f $ **FLOATING
C411 a_623_17316.n2 VSS 2.34087f $ **FLOATING
C412 a_623_17316.t2 VSS 0.10044f $ **FLOATING
C413 a_576_15420.t1 VSS 0.04719f $ **FLOATING
C414 a_576_15420.t4 VSS 0.10374f $ **FLOATING
C415 a_576_15420.t3 VSS 0.13189f $ **FLOATING
C416 a_576_15420.n0 VSS 0.48477f $ **FLOATING
C417 a_576_15420.t0 VSS 0.16755f $ **FLOATING
C418 a_576_15420.n1 VSS 1.94185f $ **FLOATING
C419 a_576_15420.t2 VSS 0.0777f $ **FLOATING
C420 a_576_15420.n2 VSS 1.4097f $ **FLOATING
C421 a_623_15516.t1 VSS 0.06157f $ **FLOATING
C422 a_623_15516.t4 VSS 0.13467f $ **FLOATING
C423 a_623_15516.n0 VSS 1.99144f $ **FLOATING
C424 a_623_15516.t0 VSS 0.21951f $ **FLOATING
C425 a_623_15516.n1 VSS 1.0178f $ **FLOATING
C426 a_623_15516.t3 VSS 0.17174f $ **FLOATING
C427 a_623_15516.n2 VSS 2.34087f $ **FLOATING
C428 a_623_15516.t2 VSS 0.10044f $ **FLOATING
C429 a_576_13620.t1 VSS 0.04719f $ **FLOATING
C430 a_576_13620.t4 VSS 0.10374f $ **FLOATING
C431 a_576_13620.t3 VSS 0.13189f $ **FLOATING
C432 a_576_13620.n0 VSS 0.48477f $ **FLOATING
C433 a_576_13620.t0 VSS 0.16755f $ **FLOATING
C434 a_576_13620.n1 VSS 1.94185f $ **FLOATING
C435 a_576_13620.t2 VSS 0.0777f $ **FLOATING
C436 a_576_13620.n2 VSS 1.4097f $ **FLOATING
C437 a_623_13716.t1 VSS 0.06157f $ **FLOATING
C438 a_623_13716.t4 VSS 0.13467f $ **FLOATING
C439 a_623_13716.n0 VSS 1.99144f $ **FLOATING
C440 a_623_13716.t0 VSS 0.21951f $ **FLOATING
C441 a_623_13716.n1 VSS 1.0178f $ **FLOATING
C442 a_623_13716.t3 VSS 0.17174f $ **FLOATING
C443 a_623_13716.n2 VSS 2.34087f $ **FLOATING
C444 a_623_13716.t2 VSS 0.10044f $ **FLOATING
C445 a_576_11820.t1 VSS 0.04719f $ **FLOATING
C446 a_576_11820.t4 VSS 0.10374f $ **FLOATING
C447 a_576_11820.t3 VSS 0.13189f $ **FLOATING
C448 a_576_11820.n0 VSS 0.48477f $ **FLOATING
C449 a_576_11820.t0 VSS 0.16755f $ **FLOATING
C450 a_576_11820.n1 VSS 1.94185f $ **FLOATING
C451 a_576_11820.t2 VSS 0.0777f $ **FLOATING
C452 a_576_11820.n2 VSS 1.4097f $ **FLOATING
C453 a_623_11916.t0 VSS 0.06157f $ **FLOATING
C454 a_623_11916.t4 VSS 0.13467f $ **FLOATING
C455 a_623_11916.n0 VSS 1.99144f $ **FLOATING
C456 a_623_11916.t2 VSS 0.21951f $ **FLOATING
C457 a_623_11916.n1 VSS 1.0178f $ **FLOATING
C458 a_623_11916.t3 VSS 0.17174f $ **FLOATING
C459 a_623_11916.n2 VSS 2.34087f $ **FLOATING
C460 a_623_11916.t1 VSS 0.10044f $ **FLOATING
C461 a_576_10020.t1 VSS 0.04719f $ **FLOATING
C462 a_576_10020.t4 VSS 0.10374f $ **FLOATING
C463 a_576_10020.t3 VSS 0.13189f $ **FLOATING
C464 a_576_10020.n0 VSS 0.48477f $ **FLOATING
C465 a_576_10020.t0 VSS 0.16755f $ **FLOATING
C466 a_576_10020.n1 VSS 1.94185f $ **FLOATING
C467 a_576_10020.t2 VSS 0.0777f $ **FLOATING
C468 a_576_10020.n2 VSS 1.4097f $ **FLOATING
C469 a_623_10116.t0 VSS 0.06157f $ **FLOATING
C470 a_623_10116.t4 VSS 0.13467f $ **FLOATING
C471 a_623_10116.n0 VSS 1.99144f $ **FLOATING
C472 a_623_10116.t2 VSS 0.21951f $ **FLOATING
C473 a_623_10116.n1 VSS 1.0178f $ **FLOATING
C474 a_623_10116.t3 VSS 0.17174f $ **FLOATING
C475 a_623_10116.n2 VSS 2.34087f $ **FLOATING
C476 a_623_10116.t1 VSS 0.10044f $ **FLOATING
C477 a_576_8220.t1 VSS 0.04719f $ **FLOATING
C478 a_576_8220.t4 VSS 0.10374f $ **FLOATING
C479 a_576_8220.t3 VSS 0.13189f $ **FLOATING
C480 a_576_8220.n0 VSS 0.48477f $ **FLOATING
C481 a_576_8220.t0 VSS 0.16755f $ **FLOATING
C482 a_576_8220.n1 VSS 1.94185f $ **FLOATING
C483 a_576_8220.t2 VSS 0.0777f $ **FLOATING
C484 a_576_8220.n2 VSS 1.4097f $ **FLOATING
C485 a_623_8316.t1 VSS 0.06157f $ **FLOATING
C486 a_623_8316.t4 VSS 0.13467f $ **FLOATING
C487 a_623_8316.n0 VSS 1.99144f $ **FLOATING
C488 a_623_8316.t0 VSS 0.21951f $ **FLOATING
C489 a_623_8316.n1 VSS 1.0178f $ **FLOATING
C490 a_623_8316.t3 VSS 0.17174f $ **FLOATING
C491 a_623_8316.n2 VSS 2.34087f $ **FLOATING
C492 a_623_8316.t2 VSS 0.10044f $ **FLOATING
C493 a_576_6420.t1 VSS 0.04719f $ **FLOATING
C494 a_576_6420.t4 VSS 0.10374f $ **FLOATING
C495 a_576_6420.t3 VSS 0.13189f $ **FLOATING
C496 a_576_6420.n0 VSS 0.48477f $ **FLOATING
C497 a_576_6420.t0 VSS 0.16755f $ **FLOATING
C498 a_576_6420.n1 VSS 1.94185f $ **FLOATING
C499 a_576_6420.t2 VSS 0.0777f $ **FLOATING
C500 a_576_6420.n2 VSS 1.4097f $ **FLOATING
C501 a_623_6516.t1 VSS 0.06157f $ **FLOATING
C502 a_623_6516.t4 VSS 0.13467f $ **FLOATING
C503 a_623_6516.n0 VSS 1.99144f $ **FLOATING
C504 a_623_6516.t0 VSS 0.21951f $ **FLOATING
C505 a_623_6516.n1 VSS 1.0178f $ **FLOATING
C506 a_623_6516.t3 VSS 0.17174f $ **FLOATING
C507 a_623_6516.n2 VSS 2.34087f $ **FLOATING
C508 a_623_6516.t2 VSS 0.10044f $ **FLOATING
C509 a_576_4620.t1 VSS 0.04719f $ **FLOATING
C510 a_576_4620.t4 VSS 0.10374f $ **FLOATING
C511 a_576_4620.t3 VSS 0.13189f $ **FLOATING
C512 a_576_4620.n0 VSS 0.48477f $ **FLOATING
C513 a_576_4620.t0 VSS 0.16755f $ **FLOATING
C514 a_576_4620.n1 VSS 1.94185f $ **FLOATING
C515 a_576_4620.t2 VSS 0.0777f $ **FLOATING
C516 a_576_4620.n2 VSS 1.4097f $ **FLOATING
C517 a_623_4716.t0 VSS 0.06157f $ **FLOATING
C518 a_623_4716.t4 VSS 0.13467f $ **FLOATING
C519 a_623_4716.n0 VSS 1.99144f $ **FLOATING
C520 a_623_4716.t1 VSS 0.21951f $ **FLOATING
C521 a_623_4716.n1 VSS 1.0178f $ **FLOATING
C522 a_623_4716.t3 VSS 0.17174f $ **FLOATING
C523 a_623_4716.n2 VSS 2.34087f $ **FLOATING
C524 a_623_4716.t2 VSS 0.10044f $ **FLOATING
C525 a_576_2820.t2 VSS 0.04719f $ **FLOATING
C526 a_576_2820.t4 VSS 0.10374f $ **FLOATING
C527 a_576_2820.t3 VSS 0.13189f $ **FLOATING
C528 a_576_2820.n0 VSS 0.48477f $ **FLOATING
C529 a_576_2820.t1 VSS 0.16755f $ **FLOATING
C530 a_576_2820.n1 VSS 1.94185f $ **FLOATING
C531 a_576_2820.t0 VSS 0.0777f $ **FLOATING
C532 a_576_2820.n2 VSS 1.4097f $ **FLOATING
C533 a_623_2916.t2 VSS 0.06157f $ **FLOATING
C534 a_623_2916.t4 VSS 0.13467f $ **FLOATING
C535 a_623_2916.n0 VSS 1.99144f $ **FLOATING
C536 a_623_2916.t0 VSS 0.21951f $ **FLOATING
C537 a_623_2916.n1 VSS 1.0178f $ **FLOATING
C538 a_623_2916.t3 VSS 0.17174f $ **FLOATING
C539 a_623_2916.n2 VSS 2.34087f $ **FLOATING
C540 a_623_2916.t1 VSS 0.10044f $ **FLOATING
C541 a_576_1020.t1 VSS 0.04698f $ **FLOATING
C542 a_576_1020.t4 VSS 0.10329f $ **FLOATING
C543 a_576_1020.t3 VSS 0.13132f $ **FLOATING
C544 a_576_1020.n0 VSS 0.4827f $ **FLOATING
C545 a_576_1020.t0 VSS 0.16683f $ **FLOATING
C546 a_576_1020.n1 VSS 1.93354f $ **FLOATING
C547 a_576_1020.t2 VSS 0.07736f $ **FLOATING
C548 a_576_1020.n2 VSS 1.40367f $ **FLOATING
C549 a_623_1116.t0 VSS 0.06136f $ **FLOATING
C550 a_623_1116.t4 VSS 0.13423f $ **FLOATING
C551 a_623_1116.n0 VSS 1.98493f $ **FLOATING
C552 a_623_1116.t1 VSS 0.2188f $ **FLOATING
C553 a_623_1116.n1 VSS 1.01447f $ **FLOATING
C554 a_623_1116.t3 VSS 0.17118f $ **FLOATING
C555 a_623_1116.n2 VSS 2.3332f $ **FLOATING
C556 a_623_1116.t2 VSS 0.10012f $ **FLOATING
C557 sense_amp_scale1p5_flat_0.SA_OUTB.t0 VSS 0.09748f $ **FLOATING
C558 sense_amp_scale1p5_flat_0.SA_OUTB.t4 VSS 0.14255f $ **FLOATING
C559 sense_amp_scale1p5_flat_0.SA_OUTB.n0 VSS 1.2063f $ **FLOATING
C560 sense_amp_scale1p5_flat_0.SA_OUTB.t1 VSS 0.21916f $ **FLOATING
C561 sense_amp_scale1p5_flat_0.SA_OUTB.n1 VSS 1.3517f $ **FLOATING
C562 sense_amp_scale1p5_flat_0.SA_OUTB.t2 VSS 0.24896f $ **FLOATING
C563 sense_amp_scale1p5_flat_0.SA_OUTB.t3 VSS 0.09876f $ **FLOATING
C564 sense_amp_scale1p5_flat_0.SA_OUTB.n2 VSS 0.28518f $ **FLOATING
C565 sense_amp_scale1p5_flat_0.SA_OUTB.n3 VSS 2.07506f $ **FLOATING
C566 sense_amp_scale1p5_flat_0.SA_OUT.t0 VSS 0.12793f $ **FLOATING
C567 sense_amp_scale1p5_flat_0.SA_OUT.t2 VSS 0.20747f $ **FLOATING
C568 sense_amp_scale1p5_flat_0.SA_OUT.n0 VSS 0.88703f $ **FLOATING
C569 sense_amp_scale1p5_flat_0.SA_OUT.t4 VSS 0.14417f $ **FLOATING
C570 sense_amp_scale1p5_flat_0.SA_OUT.n1 VSS 1.00204f $ **FLOATING
C571 sense_amp_scale1p5_flat_0.SA_OUT.t1 VSS 0.22658f $ **FLOATING
C572 sense_amp_scale1p5_flat_0.SA_OUT.t3 VSS 0.10885f $ **FLOATING
C573 sense_amp_scale1p5_flat_0.SA_OUT.n2 VSS 1.71074f $ **FLOATING
C574 sense_amp_scale1p5_flat_0.SA_OUT.n3 VSS 0.90032f $ **FLOATING
C575 a_1065_n6268.t0 VSS 0.04377f $ **FLOATING
C576 a_1065_n6268.t1 VSS 0.04045f $ **FLOATING
C577 a_1065_n6268.n0 VSS 1.05641f $ **FLOATING
C578 a_1065_n6268.t2 VSS 0.04228f $ **FLOATING
C579 a_677_n8854.t0 VSS 0.25068f $ **FLOATING
C580 a_677_n8854.t1 VSS 0.12672f $ **FLOATING
C581 a_677_n8854.t3 VSS 0.37452f $ **FLOATING
C582 a_677_n8854.n0 VSS 5.25125f $ **FLOATING
C583 a_677_n8854.t2 VSS 0.37829f $ **FLOATING
C584 a_677_n8854.n1 VSS 4.22735f $ **FLOATING
C585 a_1477_n9274.t0 VSS 5.01482f $ **FLOATING
C586 a_1477_n9274.t1 VSS 5.0093f $ **FLOATING
C587 a_3077_n9274.t0 VSS 5.14161f $ **FLOATING
C588 a_3077_n9274.t1 VSS 5.13066f $ **FLOATING
C589 a_1865_n13274.t0 VSS 3.77893f $ **FLOATING
C590 a_1865_n13274.t1 VSS 3.78062f $ **FLOATING
C591 a_3465_n13274.t0 VSS 2.54465f $ **FLOATING
C592 a_3465_n13274.t1 VSS 2.53725f $ **FLOATING
C593 VDD.n0 VSS 0.14235f $ **FLOATING
C594 VDD.n1 VSS 0.15833f $ **FLOATING
C595 VDD.t137 VSS 1.51024f $ **FLOATING
C596 VDD.n3 VSS 1.14433f $ **FLOATING
C597 VDD.n4 VSS 0.16264f $ **FLOATING
C598 VDD.n5 VSS 0.16264f $ **FLOATING
C599 VDD.n7 VSS 1.14433f $ **FLOATING
C600 VDD.n8 VSS 0.16264f $ **FLOATING
C601 VDD.n9 VSS 0.10032f $ **FLOATING
C602 VDD.n10 VSS 0.11531f $ **FLOATING
C603 VDD.n11 VSS 0.14235f $ **FLOATING
C604 VDD.n12 VSS 0.15833f $ **FLOATING
C605 VDD.t131 VSS 1.51024f $ **FLOATING
C606 VDD.n14 VSS 1.14433f $ **FLOATING
C607 VDD.n15 VSS 0.16264f $ **FLOATING
C608 VDD.n16 VSS 0.16264f $ **FLOATING
C609 VDD.n18 VSS 1.14433f $ **FLOATING
C610 VDD.n19 VSS 0.16264f $ **FLOATING
C611 VDD.n20 VSS 0.10032f $ **FLOATING
C612 VDD.n21 VSS 0.10652f $ **FLOATING
C613 VDD.n22 VSS 0.67807f $ **FLOATING
C614 VDD.t132 VSS 0.41052f $ **FLOATING
C615 VDD.n23 VSS 0.8089f $ **FLOATING
C616 VDD.n24 VSS 0.14235f $ **FLOATING
C617 VDD.n25 VSS 0.15833f $ **FLOATING
C618 VDD.t122 VSS 1.51024f $ **FLOATING
C619 VDD.n27 VSS 1.14433f $ **FLOATING
C620 VDD.n28 VSS 0.16264f $ **FLOATING
C621 VDD.n29 VSS 0.16264f $ **FLOATING
C622 VDD.n31 VSS 1.14433f $ **FLOATING
C623 VDD.n32 VSS 0.16264f $ **FLOATING
C624 VDD.n33 VSS 0.10032f $ **FLOATING
C625 VDD.n34 VSS 0.10652f $ **FLOATING
C626 VDD.n35 VSS 0.31963f $ **FLOATING
C627 VDD.n36 VSS 0.14235f $ **FLOATING
C628 VDD.n37 VSS 0.15833f $ **FLOATING
C629 VDD.t129 VSS 1.51024f $ **FLOATING
C630 VDD.n39 VSS 1.14433f $ **FLOATING
C631 VDD.n40 VSS 0.16264f $ **FLOATING
C632 VDD.n41 VSS 0.16264f $ **FLOATING
C633 VDD.n43 VSS 1.14433f $ **FLOATING
C634 VDD.n44 VSS 0.16264f $ **FLOATING
C635 VDD.n45 VSS 0.10032f $ **FLOATING
C636 VDD.n46 VSS 0.10652f $ **FLOATING
C637 VDD.n47 VSS 0.22569f $ **FLOATING
C638 VDD.t130 VSS 0.41052f $ **FLOATING
C639 VDD.n48 VSS 0.78672f $ **FLOATING
C640 VDD.t92 VSS 0.54534f $ **FLOATING
C641 VDD.n49 VSS 0.07093f $ **FLOATING
C642 VDD.n50 VSS 0.07093f $ **FLOATING
C643 VDD.n51 VSS 0.07093f $ **FLOATING
C644 VDD.t90 VSS 0.35235f $ **FLOATING
C645 VDD.n52 VSS 0.07093f $ **FLOATING
C646 VDD.n53 VSS 0.07093f $ **FLOATING
C647 VDD.n54 VSS 0.07093f $ **FLOATING
C648 VDD.n56 VSS 0.25766f $ **FLOATING
C649 VDD.n57 VSS 0.0703f $ **FLOATING
C650 VDD.n58 VSS 0.07093f $ **FLOATING
C651 VDD.n59 VSS 0.0703f $ **FLOATING
C652 VDD.n60 VSS 0.0703f $ **FLOATING
C653 VDD.n61 VSS 0.26396f $ **FLOATING
C654 VDD.n62 VSS 0.28244f $ **FLOATING
C655 VDD.n63 VSS 0.0703f $ **FLOATING
C656 VDD.n64 VSS 0.0703f $ **FLOATING
C657 VDD.n65 VSS 0.07093f $ **FLOATING
C658 VDD.n66 VSS 0.0703f $ **FLOATING
C659 VDD.n67 VSS 0.0703f $ **FLOATING
C660 VDD.n68 VSS 0.36944f $ **FLOATING
C661 VDD.t93 VSS 0.02783f $ **FLOATING
C662 VDD.n69 VSS 0.41282f $ **FLOATING
C663 VDD.t91 VSS 0.028f $ **FLOATING
C664 VDD.n71 VSS 0.40332f $ **FLOATING
C665 VDD.t88 VSS 0.54534f $ **FLOATING
C666 VDD.n72 VSS 0.07093f $ **FLOATING
C667 VDD.n73 VSS 0.07093f $ **FLOATING
C668 VDD.n74 VSS 0.07093f $ **FLOATING
C669 VDD.t86 VSS 0.35235f $ **FLOATING
C670 VDD.n75 VSS 0.07093f $ **FLOATING
C671 VDD.n76 VSS 0.07093f $ **FLOATING
C672 VDD.n77 VSS 0.07093f $ **FLOATING
C673 VDD.n79 VSS 0.25766f $ **FLOATING
C674 VDD.n80 VSS 0.0703f $ **FLOATING
C675 VDD.n81 VSS 0.07093f $ **FLOATING
C676 VDD.n82 VSS 0.0703f $ **FLOATING
C677 VDD.n83 VSS 0.0703f $ **FLOATING
C678 VDD.n84 VSS 0.26396f $ **FLOATING
C679 VDD.n85 VSS 0.28244f $ **FLOATING
C680 VDD.n86 VSS 0.0703f $ **FLOATING
C681 VDD.n87 VSS 0.0703f $ **FLOATING
C682 VDD.n88 VSS 0.07093f $ **FLOATING
C683 VDD.n89 VSS 0.0703f $ **FLOATING
C684 VDD.n90 VSS 0.0703f $ **FLOATING
C685 VDD.n91 VSS 0.36944f $ **FLOATING
C686 VDD.t89 VSS 0.02783f $ **FLOATING
C687 VDD.n92 VSS 0.41282f $ **FLOATING
C688 VDD.t87 VSS 0.028f $ **FLOATING
C689 VDD.n94 VSS 0.7913f $ **FLOATING
C690 VDD.t84 VSS 0.54534f $ **FLOATING
C691 VDD.n95 VSS 0.07093f $ **FLOATING
C692 VDD.n96 VSS 0.07093f $ **FLOATING
C693 VDD.n97 VSS 0.07093f $ **FLOATING
C694 VDD.t78 VSS 0.35235f $ **FLOATING
C695 VDD.n98 VSS 0.07093f $ **FLOATING
C696 VDD.n99 VSS 0.07093f $ **FLOATING
C697 VDD.n100 VSS 0.07093f $ **FLOATING
C698 VDD.n102 VSS 0.25766f $ **FLOATING
C699 VDD.n103 VSS 0.0703f $ **FLOATING
C700 VDD.n104 VSS 0.07093f $ **FLOATING
C701 VDD.n105 VSS 0.0703f $ **FLOATING
C702 VDD.n106 VSS 0.0703f $ **FLOATING
C703 VDD.n107 VSS 0.26396f $ **FLOATING
C704 VDD.n108 VSS 0.28244f $ **FLOATING
C705 VDD.n109 VSS 0.0703f $ **FLOATING
C706 VDD.n110 VSS 0.0703f $ **FLOATING
C707 VDD.n111 VSS 0.07093f $ **FLOATING
C708 VDD.n112 VSS 0.0703f $ **FLOATING
C709 VDD.n113 VSS 0.0703f $ **FLOATING
C710 VDD.n114 VSS 0.36944f $ **FLOATING
C711 VDD.t85 VSS 0.02783f $ **FLOATING
C712 VDD.n115 VSS 0.41282f $ **FLOATING
C713 VDD.t79 VSS 0.028f $ **FLOATING
C714 VDD.n117 VSS 0.7913f $ **FLOATING
C715 VDD.t74 VSS 0.54534f $ **FLOATING
C716 VDD.n118 VSS 0.07093f $ **FLOATING
C717 VDD.n119 VSS 0.07093f $ **FLOATING
C718 VDD.n120 VSS 0.07093f $ **FLOATING
C719 VDD.t72 VSS 0.35235f $ **FLOATING
C720 VDD.n121 VSS 0.07093f $ **FLOATING
C721 VDD.n122 VSS 0.07093f $ **FLOATING
C722 VDD.n123 VSS 0.07093f $ **FLOATING
C723 VDD.n125 VSS 0.25766f $ **FLOATING
C724 VDD.n126 VSS 0.0703f $ **FLOATING
C725 VDD.n127 VSS 0.07093f $ **FLOATING
C726 VDD.n128 VSS 0.0703f $ **FLOATING
C727 VDD.n129 VSS 0.0703f $ **FLOATING
C728 VDD.n130 VSS 0.26396f $ **FLOATING
C729 VDD.n131 VSS 0.28244f $ **FLOATING
C730 VDD.n132 VSS 0.0703f $ **FLOATING
C731 VDD.n133 VSS 0.0703f $ **FLOATING
C732 VDD.n134 VSS 0.07093f $ **FLOATING
C733 VDD.n135 VSS 0.0703f $ **FLOATING
C734 VDD.n136 VSS 0.0703f $ **FLOATING
C735 VDD.n137 VSS 0.36944f $ **FLOATING
C736 VDD.t75 VSS 0.02783f $ **FLOATING
C737 VDD.n138 VSS 0.41282f $ **FLOATING
C738 VDD.t73 VSS 0.028f $ **FLOATING
C739 VDD.n140 VSS 0.7913f $ **FLOATING
C740 VDD.t100 VSS 0.54534f $ **FLOATING
C741 VDD.n141 VSS 0.07093f $ **FLOATING
C742 VDD.n142 VSS 0.07093f $ **FLOATING
C743 VDD.n143 VSS 0.07093f $ **FLOATING
C744 VDD.t68 VSS 0.35235f $ **FLOATING
C745 VDD.n144 VSS 0.07093f $ **FLOATING
C746 VDD.n145 VSS 0.07093f $ **FLOATING
C747 VDD.n146 VSS 0.07093f $ **FLOATING
C748 VDD.n148 VSS 0.25766f $ **FLOATING
C749 VDD.n149 VSS 0.0703f $ **FLOATING
C750 VDD.n150 VSS 0.07093f $ **FLOATING
C751 VDD.n151 VSS 0.0703f $ **FLOATING
C752 VDD.n152 VSS 0.0703f $ **FLOATING
C753 VDD.n153 VSS 0.26396f $ **FLOATING
C754 VDD.n154 VSS 0.28244f $ **FLOATING
C755 VDD.n155 VSS 0.0703f $ **FLOATING
C756 VDD.n156 VSS 0.0703f $ **FLOATING
C757 VDD.n157 VSS 0.07093f $ **FLOATING
C758 VDD.n158 VSS 0.0703f $ **FLOATING
C759 VDD.n159 VSS 0.0703f $ **FLOATING
C760 VDD.n160 VSS 0.36944f $ **FLOATING
C761 VDD.t101 VSS 0.02783f $ **FLOATING
C762 VDD.n161 VSS 0.41282f $ **FLOATING
C763 VDD.t69 VSS 0.028f $ **FLOATING
C764 VDD.n163 VSS 0.7913f $ **FLOATING
C765 VDD.t70 VSS 0.54534f $ **FLOATING
C766 VDD.n164 VSS 0.07093f $ **FLOATING
C767 VDD.n165 VSS 0.07093f $ **FLOATING
C768 VDD.n166 VSS 0.07093f $ **FLOATING
C769 VDD.t38 VSS 0.35235f $ **FLOATING
C770 VDD.n167 VSS 0.07093f $ **FLOATING
C771 VDD.n168 VSS 0.07093f $ **FLOATING
C772 VDD.n169 VSS 0.07093f $ **FLOATING
C773 VDD.n171 VSS 0.25766f $ **FLOATING
C774 VDD.n172 VSS 0.0703f $ **FLOATING
C775 VDD.n173 VSS 0.07093f $ **FLOATING
C776 VDD.n174 VSS 0.0703f $ **FLOATING
C777 VDD.n175 VSS 0.0703f $ **FLOATING
C778 VDD.n176 VSS 0.26396f $ **FLOATING
C779 VDD.n177 VSS 0.28244f $ **FLOATING
C780 VDD.n178 VSS 0.0703f $ **FLOATING
C781 VDD.n179 VSS 0.0703f $ **FLOATING
C782 VDD.n180 VSS 0.07093f $ **FLOATING
C783 VDD.n181 VSS 0.0703f $ **FLOATING
C784 VDD.n182 VSS 0.0703f $ **FLOATING
C785 VDD.n183 VSS 0.36944f $ **FLOATING
C786 VDD.t71 VSS 0.02783f $ **FLOATING
C787 VDD.n184 VSS 0.41282f $ **FLOATING
C788 VDD.t39 VSS 0.028f $ **FLOATING
C789 VDD.n186 VSS 0.7913f $ **FLOATING
C790 VDD.t58 VSS 0.54534f $ **FLOATING
C791 VDD.n187 VSS 0.07093f $ **FLOATING
C792 VDD.n188 VSS 0.07093f $ **FLOATING
C793 VDD.n189 VSS 0.07093f $ **FLOATING
C794 VDD.t112 VSS 0.35235f $ **FLOATING
C795 VDD.n190 VSS 0.07093f $ **FLOATING
C796 VDD.n191 VSS 0.07093f $ **FLOATING
C797 VDD.n192 VSS 0.07093f $ **FLOATING
C798 VDD.n194 VSS 0.25766f $ **FLOATING
C799 VDD.n195 VSS 0.0703f $ **FLOATING
C800 VDD.n196 VSS 0.07093f $ **FLOATING
C801 VDD.n197 VSS 0.0703f $ **FLOATING
C802 VDD.n198 VSS 0.0703f $ **FLOATING
C803 VDD.n199 VSS 0.26396f $ **FLOATING
C804 VDD.n200 VSS 0.28244f $ **FLOATING
C805 VDD.n201 VSS 0.0703f $ **FLOATING
C806 VDD.n202 VSS 0.0703f $ **FLOATING
C807 VDD.n203 VSS 0.07093f $ **FLOATING
C808 VDD.n204 VSS 0.0703f $ **FLOATING
C809 VDD.n205 VSS 0.0703f $ **FLOATING
C810 VDD.n206 VSS 0.36944f $ **FLOATING
C811 VDD.t59 VSS 0.02783f $ **FLOATING
C812 VDD.n207 VSS 0.41282f $ **FLOATING
C813 VDD.t113 VSS 0.028f $ **FLOATING
C814 VDD.n209 VSS 0.7913f $ **FLOATING
C815 VDD.t18 VSS 0.54534f $ **FLOATING
C816 VDD.n210 VSS 0.07093f $ **FLOATING
C817 VDD.n211 VSS 0.07093f $ **FLOATING
C818 VDD.n212 VSS 0.07093f $ **FLOATING
C819 VDD.t133 VSS 0.35235f $ **FLOATING
C820 VDD.n213 VSS 0.07093f $ **FLOATING
C821 VDD.n214 VSS 0.07093f $ **FLOATING
C822 VDD.n215 VSS 0.07093f $ **FLOATING
C823 VDD.n217 VSS 0.25766f $ **FLOATING
C824 VDD.n218 VSS 0.0703f $ **FLOATING
C825 VDD.n219 VSS 0.07093f $ **FLOATING
C826 VDD.n220 VSS 0.0703f $ **FLOATING
C827 VDD.n221 VSS 0.0703f $ **FLOATING
C828 VDD.n222 VSS 0.26396f $ **FLOATING
C829 VDD.n223 VSS 0.28244f $ **FLOATING
C830 VDD.n224 VSS 0.0703f $ **FLOATING
C831 VDD.n225 VSS 0.0703f $ **FLOATING
C832 VDD.n226 VSS 0.07093f $ **FLOATING
C833 VDD.n227 VSS 0.0703f $ **FLOATING
C834 VDD.n228 VSS 0.0703f $ **FLOATING
C835 VDD.n229 VSS 0.36944f $ **FLOATING
C836 VDD.t19 VSS 0.02783f $ **FLOATING
C837 VDD.n230 VSS 0.41282f $ **FLOATING
C838 VDD.t134 VSS 0.028f $ **FLOATING
C839 VDD.n232 VSS 0.7913f $ **FLOATING
C840 VDD.t30 VSS 0.54534f $ **FLOATING
C841 VDD.n233 VSS 0.07093f $ **FLOATING
C842 VDD.n234 VSS 0.07093f $ **FLOATING
C843 VDD.n235 VSS 0.07093f $ **FLOATING
C844 VDD.t20 VSS 0.35235f $ **FLOATING
C845 VDD.n236 VSS 0.07093f $ **FLOATING
C846 VDD.n237 VSS 0.07093f $ **FLOATING
C847 VDD.n238 VSS 0.07093f $ **FLOATING
C848 VDD.n240 VSS 0.25766f $ **FLOATING
C849 VDD.n241 VSS 0.0703f $ **FLOATING
C850 VDD.n242 VSS 0.07093f $ **FLOATING
C851 VDD.n243 VSS 0.0703f $ **FLOATING
C852 VDD.n244 VSS 0.0703f $ **FLOATING
C853 VDD.n245 VSS 0.26396f $ **FLOATING
C854 VDD.n246 VSS 0.28244f $ **FLOATING
C855 VDD.n247 VSS 0.0703f $ **FLOATING
C856 VDD.n248 VSS 0.0703f $ **FLOATING
C857 VDD.n249 VSS 0.07093f $ **FLOATING
C858 VDD.n250 VSS 0.0703f $ **FLOATING
C859 VDD.n251 VSS 0.0703f $ **FLOATING
C860 VDD.n252 VSS 0.36944f $ **FLOATING
C861 VDD.t31 VSS 0.02783f $ **FLOATING
C862 VDD.n253 VSS 0.41282f $ **FLOATING
C863 VDD.t21 VSS 0.028f $ **FLOATING
C864 VDD.n255 VSS 0.7913f $ **FLOATING
C865 VDD.t110 VSS 0.54534f $ **FLOATING
C866 VDD.n256 VSS 0.07093f $ **FLOATING
C867 VDD.n257 VSS 0.07093f $ **FLOATING
C868 VDD.n258 VSS 0.07093f $ **FLOATING
C869 VDD.t62 VSS 0.35235f $ **FLOATING
C870 VDD.n259 VSS 0.07093f $ **FLOATING
C871 VDD.n260 VSS 0.07093f $ **FLOATING
C872 VDD.n261 VSS 0.07093f $ **FLOATING
C873 VDD.n263 VSS 0.25766f $ **FLOATING
C874 VDD.n264 VSS 0.0703f $ **FLOATING
C875 VDD.n265 VSS 0.07093f $ **FLOATING
C876 VDD.n266 VSS 0.0703f $ **FLOATING
C877 VDD.n267 VSS 0.0703f $ **FLOATING
C878 VDD.n268 VSS 0.26396f $ **FLOATING
C879 VDD.n269 VSS 0.28244f $ **FLOATING
C880 VDD.n270 VSS 0.0703f $ **FLOATING
C881 VDD.n271 VSS 0.0703f $ **FLOATING
C882 VDD.n272 VSS 0.07093f $ **FLOATING
C883 VDD.n273 VSS 0.0703f $ **FLOATING
C884 VDD.n274 VSS 0.0703f $ **FLOATING
C885 VDD.n275 VSS 0.36944f $ **FLOATING
C886 VDD.t111 VSS 0.02783f $ **FLOATING
C887 VDD.n276 VSS 0.41282f $ **FLOATING
C888 VDD.t63 VSS 0.028f $ **FLOATING
C889 VDD.n278 VSS 0.7913f $ **FLOATING
C890 VDD.t60 VSS 0.54534f $ **FLOATING
C891 VDD.n279 VSS 0.07093f $ **FLOATING
C892 VDD.n280 VSS 0.07093f $ **FLOATING
C893 VDD.n281 VSS 0.07093f $ **FLOATING
C894 VDD.t98 VSS 0.35235f $ **FLOATING
C895 VDD.n282 VSS 0.07093f $ **FLOATING
C896 VDD.n283 VSS 0.07093f $ **FLOATING
C897 VDD.n284 VSS 0.07093f $ **FLOATING
C898 VDD.n286 VSS 0.25766f $ **FLOATING
C899 VDD.n287 VSS 0.0703f $ **FLOATING
C900 VDD.n288 VSS 0.07093f $ **FLOATING
C901 VDD.n289 VSS 0.0703f $ **FLOATING
C902 VDD.n290 VSS 0.0703f $ **FLOATING
C903 VDD.n291 VSS 0.26396f $ **FLOATING
C904 VDD.n292 VSS 0.28244f $ **FLOATING
C905 VDD.n293 VSS 0.0703f $ **FLOATING
C906 VDD.n294 VSS 0.0703f $ **FLOATING
C907 VDD.n295 VSS 0.07093f $ **FLOATING
C908 VDD.n296 VSS 0.0703f $ **FLOATING
C909 VDD.n297 VSS 0.0703f $ **FLOATING
C910 VDD.n298 VSS 0.36944f $ **FLOATING
C911 VDD.t61 VSS 0.02783f $ **FLOATING
C912 VDD.n299 VSS 0.41282f $ **FLOATING
C913 VDD.t99 VSS 0.028f $ **FLOATING
C914 VDD.n301 VSS 0.7913f $ **FLOATING
C915 VDD.t56 VSS 0.54534f $ **FLOATING
C916 VDD.n302 VSS 0.07093f $ **FLOATING
C917 VDD.n303 VSS 0.07093f $ **FLOATING
C918 VDD.n304 VSS 0.07093f $ **FLOATING
C919 VDD.t36 VSS 0.35235f $ **FLOATING
C920 VDD.n305 VSS 0.07093f $ **FLOATING
C921 VDD.n306 VSS 0.07093f $ **FLOATING
C922 VDD.n307 VSS 0.07093f $ **FLOATING
C923 VDD.n309 VSS 0.25766f $ **FLOATING
C924 VDD.n310 VSS 0.0703f $ **FLOATING
C925 VDD.n311 VSS 0.07093f $ **FLOATING
C926 VDD.n312 VSS 0.0703f $ **FLOATING
C927 VDD.n313 VSS 0.0703f $ **FLOATING
C928 VDD.n314 VSS 0.26396f $ **FLOATING
C929 VDD.n315 VSS 0.28244f $ **FLOATING
C930 VDD.n316 VSS 0.0703f $ **FLOATING
C931 VDD.n317 VSS 0.0703f $ **FLOATING
C932 VDD.n318 VSS 0.07093f $ **FLOATING
C933 VDD.n319 VSS 0.0703f $ **FLOATING
C934 VDD.n320 VSS 0.0703f $ **FLOATING
C935 VDD.n321 VSS 0.36944f $ **FLOATING
C936 VDD.t57 VSS 0.02783f $ **FLOATING
C937 VDD.n322 VSS 0.41282f $ **FLOATING
C938 VDD.t37 VSS 0.028f $ **FLOATING
C939 VDD.n324 VSS 0.7913f $ **FLOATING
C940 VDD.t34 VSS 0.54534f $ **FLOATING
C941 VDD.n325 VSS 0.07093f $ **FLOATING
C942 VDD.n326 VSS 0.07093f $ **FLOATING
C943 VDD.n327 VSS 0.07093f $ **FLOATING
C944 VDD.t24 VSS 0.35235f $ **FLOATING
C945 VDD.n328 VSS 0.07093f $ **FLOATING
C946 VDD.n329 VSS 0.07093f $ **FLOATING
C947 VDD.n330 VSS 0.07093f $ **FLOATING
C948 VDD.n332 VSS 0.25766f $ **FLOATING
C949 VDD.n333 VSS 0.0703f $ **FLOATING
C950 VDD.n334 VSS 0.07093f $ **FLOATING
C951 VDD.n335 VSS 0.0703f $ **FLOATING
C952 VDD.n336 VSS 0.0703f $ **FLOATING
C953 VDD.n337 VSS 0.26396f $ **FLOATING
C954 VDD.n338 VSS 0.28244f $ **FLOATING
C955 VDD.n339 VSS 0.0703f $ **FLOATING
C956 VDD.n340 VSS 0.0703f $ **FLOATING
C957 VDD.n341 VSS 0.07093f $ **FLOATING
C958 VDD.n342 VSS 0.0703f $ **FLOATING
C959 VDD.n343 VSS 0.0703f $ **FLOATING
C960 VDD.n344 VSS 0.36944f $ **FLOATING
C961 VDD.t35 VSS 0.02783f $ **FLOATING
C962 VDD.n345 VSS 0.41282f $ **FLOATING
C963 VDD.t25 VSS 0.028f $ **FLOATING
C964 VDD.n347 VSS 0.7913f $ **FLOATING
C965 VDD.t138 VSS 0.54534f $ **FLOATING
C966 VDD.n348 VSS 0.07093f $ **FLOATING
C967 VDD.n349 VSS 0.07093f $ **FLOATING
C968 VDD.n350 VSS 0.07093f $ **FLOATING
C969 VDD.t123 VSS 0.35235f $ **FLOATING
C970 VDD.n351 VSS 0.07093f $ **FLOATING
C971 VDD.n352 VSS 0.07093f $ **FLOATING
C972 VDD.n353 VSS 0.07093f $ **FLOATING
C973 VDD.n355 VSS 0.25766f $ **FLOATING
C974 VDD.n356 VSS 0.0703f $ **FLOATING
C975 VDD.n357 VSS 0.07093f $ **FLOATING
C976 VDD.n358 VSS 0.0703f $ **FLOATING
C977 VDD.n359 VSS 0.0703f $ **FLOATING
C978 VDD.n360 VSS 0.26396f $ **FLOATING
C979 VDD.n361 VSS 0.28244f $ **FLOATING
C980 VDD.n362 VSS 0.0703f $ **FLOATING
C981 VDD.n363 VSS 0.0703f $ **FLOATING
C982 VDD.n364 VSS 0.07093f $ **FLOATING
C983 VDD.n365 VSS 0.0703f $ **FLOATING
C984 VDD.n366 VSS 0.0703f $ **FLOATING
C985 VDD.n367 VSS 0.36944f $ **FLOATING
C986 VDD.t139 VSS 0.02783f $ **FLOATING
C987 VDD.n368 VSS 0.41282f $ **FLOATING
C988 VDD.t124 VSS 0.028f $ **FLOATING
C989 VDD.n370 VSS 0.7913f $ **FLOATING
C990 VDD.t120 VSS 0.54534f $ **FLOATING
C991 VDD.n371 VSS 0.07093f $ **FLOATING
C992 VDD.n372 VSS 0.07093f $ **FLOATING
C993 VDD.n373 VSS 0.07093f $ **FLOATING
C994 VDD.t118 VSS 0.35235f $ **FLOATING
C995 VDD.n374 VSS 0.07093f $ **FLOATING
C996 VDD.n375 VSS 0.07093f $ **FLOATING
C997 VDD.n376 VSS 0.07093f $ **FLOATING
C998 VDD.n378 VSS 0.25766f $ **FLOATING
C999 VDD.n379 VSS 0.0703f $ **FLOATING
C1000 VDD.n380 VSS 0.07093f $ **FLOATING
C1001 VDD.n381 VSS 0.0703f $ **FLOATING
C1002 VDD.n382 VSS 0.0703f $ **FLOATING
C1003 VDD.n383 VSS 0.26396f $ **FLOATING
C1004 VDD.n384 VSS 0.28244f $ **FLOATING
C1005 VDD.n385 VSS 0.0703f $ **FLOATING
C1006 VDD.n386 VSS 0.0703f $ **FLOATING
C1007 VDD.n387 VSS 0.07093f $ **FLOATING
C1008 VDD.n388 VSS 0.0703f $ **FLOATING
C1009 VDD.n389 VSS 0.0703f $ **FLOATING
C1010 VDD.n390 VSS 0.36944f $ **FLOATING
C1011 VDD.t121 VSS 0.02783f $ **FLOATING
C1012 VDD.n391 VSS 0.41282f $ **FLOATING
C1013 VDD.t119 VSS 0.028f $ **FLOATING
C1014 VDD.n393 VSS 0.7913f $ **FLOATING
C1015 VDD.t116 VSS 0.54534f $ **FLOATING
C1016 VDD.n394 VSS 0.07093f $ **FLOATING
C1017 VDD.n395 VSS 0.07093f $ **FLOATING
C1018 VDD.n396 VSS 0.07093f $ **FLOATING
C1019 VDD.t102 VSS 0.35235f $ **FLOATING
C1020 VDD.n397 VSS 0.07093f $ **FLOATING
C1021 VDD.n398 VSS 0.07093f $ **FLOATING
C1022 VDD.n399 VSS 0.07093f $ **FLOATING
C1023 VDD.n401 VSS 0.25766f $ **FLOATING
C1024 VDD.n402 VSS 0.0703f $ **FLOATING
C1025 VDD.n403 VSS 0.07093f $ **FLOATING
C1026 VDD.n404 VSS 0.0703f $ **FLOATING
C1027 VDD.n405 VSS 0.0703f $ **FLOATING
C1028 VDD.n406 VSS 0.26396f $ **FLOATING
C1029 VDD.n407 VSS 0.28244f $ **FLOATING
C1030 VDD.n408 VSS 0.0703f $ **FLOATING
C1031 VDD.n409 VSS 0.0703f $ **FLOATING
C1032 VDD.n410 VSS 0.07093f $ **FLOATING
C1033 VDD.n411 VSS 0.0703f $ **FLOATING
C1034 VDD.n412 VSS 0.0703f $ **FLOATING
C1035 VDD.n413 VSS 0.36944f $ **FLOATING
C1036 VDD.t117 VSS 0.02783f $ **FLOATING
C1037 VDD.n414 VSS 0.41282f $ **FLOATING
C1038 VDD.t103 VSS 0.028f $ **FLOATING
C1039 VDD.n416 VSS 0.7913f $ **FLOATING
C1040 VDD.t114 VSS 0.54534f $ **FLOATING
C1041 VDD.n417 VSS 0.07093f $ **FLOATING
C1042 VDD.n418 VSS 0.07093f $ **FLOATING
C1043 VDD.n419 VSS 0.07093f $ **FLOATING
C1044 VDD.t104 VSS 0.35235f $ **FLOATING
C1045 VDD.n420 VSS 0.07093f $ **FLOATING
C1046 VDD.n421 VSS 0.07093f $ **FLOATING
C1047 VDD.n422 VSS 0.07093f $ **FLOATING
C1048 VDD.n424 VSS 0.25766f $ **FLOATING
C1049 VDD.n425 VSS 0.0703f $ **FLOATING
C1050 VDD.n426 VSS 0.07093f $ **FLOATING
C1051 VDD.n427 VSS 0.0703f $ **FLOATING
C1052 VDD.n428 VSS 0.0703f $ **FLOATING
C1053 VDD.n429 VSS 0.26396f $ **FLOATING
C1054 VDD.n430 VSS 0.28244f $ **FLOATING
C1055 VDD.n431 VSS 0.0703f $ **FLOATING
C1056 VDD.n432 VSS 0.0703f $ **FLOATING
C1057 VDD.n433 VSS 0.07093f $ **FLOATING
C1058 VDD.n434 VSS 0.0703f $ **FLOATING
C1059 VDD.n435 VSS 0.0703f $ **FLOATING
C1060 VDD.n436 VSS 0.36944f $ **FLOATING
C1061 VDD.t115 VSS 0.02783f $ **FLOATING
C1062 VDD.n437 VSS 0.41282f $ **FLOATING
C1063 VDD.t105 VSS 0.028f $ **FLOATING
C1064 VDD.n439 VSS 0.7913f $ **FLOATING
C1065 VDD.t108 VSS 0.54534f $ **FLOATING
C1066 VDD.n440 VSS 0.07093f $ **FLOATING
C1067 VDD.n441 VSS 0.07093f $ **FLOATING
C1068 VDD.n442 VSS 0.07093f $ **FLOATING
C1069 VDD.t94 VSS 0.35235f $ **FLOATING
C1070 VDD.n443 VSS 0.07093f $ **FLOATING
C1071 VDD.n444 VSS 0.07093f $ **FLOATING
C1072 VDD.n445 VSS 0.07093f $ **FLOATING
C1073 VDD.n447 VSS 0.25766f $ **FLOATING
C1074 VDD.n448 VSS 0.0703f $ **FLOATING
C1075 VDD.n449 VSS 0.07093f $ **FLOATING
C1076 VDD.n450 VSS 0.0703f $ **FLOATING
C1077 VDD.n451 VSS 0.0703f $ **FLOATING
C1078 VDD.n452 VSS 0.26396f $ **FLOATING
C1079 VDD.n453 VSS 0.28244f $ **FLOATING
C1080 VDD.n454 VSS 0.0703f $ **FLOATING
C1081 VDD.n455 VSS 0.0703f $ **FLOATING
C1082 VDD.n456 VSS 0.07093f $ **FLOATING
C1083 VDD.n457 VSS 0.0703f $ **FLOATING
C1084 VDD.n458 VSS 0.0703f $ **FLOATING
C1085 VDD.n459 VSS 0.36944f $ **FLOATING
C1086 VDD.t109 VSS 0.02783f $ **FLOATING
C1087 VDD.n460 VSS 0.41282f $ **FLOATING
C1088 VDD.t95 VSS 0.028f $ **FLOATING
C1089 VDD.n462 VSS 0.7913f $ **FLOATING
C1090 VDD.t16 VSS 0.54534f $ **FLOATING
C1091 VDD.n463 VSS 0.07093f $ **FLOATING
C1092 VDD.n464 VSS 0.07093f $ **FLOATING
C1093 VDD.n465 VSS 0.07093f $ **FLOATING
C1094 VDD.t32 VSS 0.35235f $ **FLOATING
C1095 VDD.n466 VSS 0.07093f $ **FLOATING
C1096 VDD.n467 VSS 0.07093f $ **FLOATING
C1097 VDD.n468 VSS 0.07093f $ **FLOATING
C1098 VDD.n470 VSS 0.25766f $ **FLOATING
C1099 VDD.n471 VSS 0.0703f $ **FLOATING
C1100 VDD.n472 VSS 0.07093f $ **FLOATING
C1101 VDD.n473 VSS 0.0703f $ **FLOATING
C1102 VDD.n474 VSS 0.0703f $ **FLOATING
C1103 VDD.n475 VSS 0.26396f $ **FLOATING
C1104 VDD.n476 VSS 0.28244f $ **FLOATING
C1105 VDD.n477 VSS 0.0703f $ **FLOATING
C1106 VDD.n478 VSS 0.0703f $ **FLOATING
C1107 VDD.n479 VSS 0.07093f $ **FLOATING
C1108 VDD.n480 VSS 0.0703f $ **FLOATING
C1109 VDD.n481 VSS 0.0703f $ **FLOATING
C1110 VDD.n482 VSS 0.36944f $ **FLOATING
C1111 VDD.t17 VSS 0.02783f $ **FLOATING
C1112 VDD.n483 VSS 0.41282f $ **FLOATING
C1113 VDD.t33 VSS 0.028f $ **FLOATING
C1114 VDD.n485 VSS 0.7913f $ **FLOATING
C1115 VDD.t28 VSS 0.54534f $ **FLOATING
C1116 VDD.n486 VSS 0.07093f $ **FLOATING
C1117 VDD.n487 VSS 0.07093f $ **FLOATING
C1118 VDD.n488 VSS 0.07093f $ **FLOATING
C1119 VDD.t66 VSS 0.35235f $ **FLOATING
C1120 VDD.n489 VSS 0.07093f $ **FLOATING
C1121 VDD.n490 VSS 0.07093f $ **FLOATING
C1122 VDD.n491 VSS 0.07093f $ **FLOATING
C1123 VDD.n493 VSS 0.25766f $ **FLOATING
C1124 VDD.n494 VSS 0.0703f $ **FLOATING
C1125 VDD.n495 VSS 0.07093f $ **FLOATING
C1126 VDD.n496 VSS 0.0703f $ **FLOATING
C1127 VDD.n497 VSS 0.0703f $ **FLOATING
C1128 VDD.n498 VSS 0.26396f $ **FLOATING
C1129 VDD.n499 VSS 0.28244f $ **FLOATING
C1130 VDD.n500 VSS 0.0703f $ **FLOATING
C1131 VDD.n501 VSS 0.0703f $ **FLOATING
C1132 VDD.n502 VSS 0.07093f $ **FLOATING
C1133 VDD.n503 VSS 0.0703f $ **FLOATING
C1134 VDD.n504 VSS 0.0703f $ **FLOATING
C1135 VDD.n505 VSS 0.36944f $ **FLOATING
C1136 VDD.t29 VSS 0.02783f $ **FLOATING
C1137 VDD.n506 VSS 0.41282f $ **FLOATING
C1138 VDD.t67 VSS 0.028f $ **FLOATING
C1139 VDD.n508 VSS 0.7913f $ **FLOATING
C1140 VDD.t82 VSS 0.54534f $ **FLOATING
C1141 VDD.n509 VSS 0.07093f $ **FLOATING
C1142 VDD.n510 VSS 0.07093f $ **FLOATING
C1143 VDD.n511 VSS 0.07093f $ **FLOATING
C1144 VDD.t14 VSS 0.35235f $ **FLOATING
C1145 VDD.n512 VSS 0.07093f $ **FLOATING
C1146 VDD.n513 VSS 0.07093f $ **FLOATING
C1147 VDD.n514 VSS 0.07093f $ **FLOATING
C1148 VDD.n516 VSS 0.25766f $ **FLOATING
C1149 VDD.n517 VSS 0.0703f $ **FLOATING
C1150 VDD.n518 VSS 0.07093f $ **FLOATING
C1151 VDD.n519 VSS 0.0703f $ **FLOATING
C1152 VDD.n520 VSS 0.0703f $ **FLOATING
C1153 VDD.n521 VSS 0.26396f $ **FLOATING
C1154 VDD.n522 VSS 0.28244f $ **FLOATING
C1155 VDD.n523 VSS 0.0703f $ **FLOATING
C1156 VDD.n524 VSS 0.0703f $ **FLOATING
C1157 VDD.n525 VSS 0.07093f $ **FLOATING
C1158 VDD.n526 VSS 0.0703f $ **FLOATING
C1159 VDD.n527 VSS 0.0703f $ **FLOATING
C1160 VDD.n528 VSS 0.36944f $ **FLOATING
C1161 VDD.t83 VSS 0.02783f $ **FLOATING
C1162 VDD.n529 VSS 0.41282f $ **FLOATING
C1163 VDD.t15 VSS 0.028f $ **FLOATING
C1164 VDD.n531 VSS 0.7913f $ **FLOATING
C1165 VDD.t8 VSS 0.54534f $ **FLOATING
C1166 VDD.n532 VSS 0.07093f $ **FLOATING
C1167 VDD.n533 VSS 0.07093f $ **FLOATING
C1168 VDD.n534 VSS 0.07093f $ **FLOATING
C1169 VDD.t54 VSS 0.35235f $ **FLOATING
C1170 VDD.n535 VSS 0.07093f $ **FLOATING
C1171 VDD.n536 VSS 0.07093f $ **FLOATING
C1172 VDD.n537 VSS 0.07093f $ **FLOATING
C1173 VDD.n539 VSS 0.25766f $ **FLOATING
C1174 VDD.n540 VSS 0.0703f $ **FLOATING
C1175 VDD.n541 VSS 0.07093f $ **FLOATING
C1176 VDD.n542 VSS 0.0703f $ **FLOATING
C1177 VDD.n543 VSS 0.0703f $ **FLOATING
C1178 VDD.n544 VSS 0.26396f $ **FLOATING
C1179 VDD.n545 VSS 0.28244f $ **FLOATING
C1180 VDD.n546 VSS 0.0703f $ **FLOATING
C1181 VDD.n547 VSS 0.0703f $ **FLOATING
C1182 VDD.n548 VSS 0.07093f $ **FLOATING
C1183 VDD.n549 VSS 0.0703f $ **FLOATING
C1184 VDD.n550 VSS 0.0703f $ **FLOATING
C1185 VDD.n551 VSS 0.36944f $ **FLOATING
C1186 VDD.t9 VSS 0.02783f $ **FLOATING
C1187 VDD.n552 VSS 0.41282f $ **FLOATING
C1188 VDD.t55 VSS 0.028f $ **FLOATING
C1189 VDD.n554 VSS 0.7913f $ **FLOATING
C1190 VDD.t76 VSS 0.54534f $ **FLOATING
C1191 VDD.n555 VSS 0.07093f $ **FLOATING
C1192 VDD.n556 VSS 0.07093f $ **FLOATING
C1193 VDD.n557 VSS 0.07093f $ **FLOATING
C1194 VDD.t22 VSS 0.35235f $ **FLOATING
C1195 VDD.n558 VSS 0.07093f $ **FLOATING
C1196 VDD.n559 VSS 0.07093f $ **FLOATING
C1197 VDD.n560 VSS 0.07093f $ **FLOATING
C1198 VDD.n562 VSS 0.25766f $ **FLOATING
C1199 VDD.n563 VSS 0.0703f $ **FLOATING
C1200 VDD.n564 VSS 0.07093f $ **FLOATING
C1201 VDD.n565 VSS 0.0703f $ **FLOATING
C1202 VDD.n566 VSS 0.0703f $ **FLOATING
C1203 VDD.n567 VSS 0.26396f $ **FLOATING
C1204 VDD.n568 VSS 0.28244f $ **FLOATING
C1205 VDD.n569 VSS 0.0703f $ **FLOATING
C1206 VDD.n570 VSS 0.0703f $ **FLOATING
C1207 VDD.n571 VSS 0.07093f $ **FLOATING
C1208 VDD.n572 VSS 0.0703f $ **FLOATING
C1209 VDD.n573 VSS 0.0703f $ **FLOATING
C1210 VDD.n574 VSS 0.36944f $ **FLOATING
C1211 VDD.t77 VSS 0.02783f $ **FLOATING
C1212 VDD.n575 VSS 0.41282f $ **FLOATING
C1213 VDD.t23 VSS 0.028f $ **FLOATING
C1214 VDD.n577 VSS 0.7913f $ **FLOATING
C1215 VDD.t106 VSS 0.54534f $ **FLOATING
C1216 VDD.n578 VSS 0.07093f $ **FLOATING
C1217 VDD.n579 VSS 0.07093f $ **FLOATING
C1218 VDD.n580 VSS 0.07093f $ **FLOATING
C1219 VDD.t10 VSS 0.35235f $ **FLOATING
C1220 VDD.n581 VSS 0.07093f $ **FLOATING
C1221 VDD.n582 VSS 0.07093f $ **FLOATING
C1222 VDD.n583 VSS 0.07093f $ **FLOATING
C1223 VDD.n585 VSS 0.25766f $ **FLOATING
C1224 VDD.n586 VSS 0.0703f $ **FLOATING
C1225 VDD.n587 VSS 0.07093f $ **FLOATING
C1226 VDD.n588 VSS 0.0703f $ **FLOATING
C1227 VDD.n589 VSS 0.0703f $ **FLOATING
C1228 VDD.n590 VSS 0.26396f $ **FLOATING
C1229 VDD.n591 VSS 0.28244f $ **FLOATING
C1230 VDD.n592 VSS 0.0703f $ **FLOATING
C1231 VDD.n593 VSS 0.0703f $ **FLOATING
C1232 VDD.n594 VSS 0.07093f $ **FLOATING
C1233 VDD.n595 VSS 0.0703f $ **FLOATING
C1234 VDD.n596 VSS 0.0703f $ **FLOATING
C1235 VDD.n597 VSS 0.36944f $ **FLOATING
C1236 VDD.t107 VSS 0.02783f $ **FLOATING
C1237 VDD.n598 VSS 0.41282f $ **FLOATING
C1238 VDD.t11 VSS 0.028f $ **FLOATING
C1239 VDD.n600 VSS 0.7913f $ **FLOATING
C1240 VDD.t52 VSS 0.54534f $ **FLOATING
C1241 VDD.n601 VSS 0.07093f $ **FLOATING
C1242 VDD.n602 VSS 0.07093f $ **FLOATING
C1243 VDD.n603 VSS 0.07093f $ **FLOATING
C1244 VDD.t64 VSS 0.35235f $ **FLOATING
C1245 VDD.n604 VSS 0.07093f $ **FLOATING
C1246 VDD.n605 VSS 0.07093f $ **FLOATING
C1247 VDD.n606 VSS 0.07093f $ **FLOATING
C1248 VDD.n608 VSS 0.25766f $ **FLOATING
C1249 VDD.n609 VSS 0.0703f $ **FLOATING
C1250 VDD.n610 VSS 0.07093f $ **FLOATING
C1251 VDD.n611 VSS 0.0703f $ **FLOATING
C1252 VDD.n612 VSS 0.0703f $ **FLOATING
C1253 VDD.n613 VSS 0.26396f $ **FLOATING
C1254 VDD.n614 VSS 0.28244f $ **FLOATING
C1255 VDD.n615 VSS 0.0703f $ **FLOATING
C1256 VDD.n616 VSS 0.0703f $ **FLOATING
C1257 VDD.n617 VSS 0.07093f $ **FLOATING
C1258 VDD.n618 VSS 0.0703f $ **FLOATING
C1259 VDD.n619 VSS 0.0703f $ **FLOATING
C1260 VDD.n620 VSS 0.36944f $ **FLOATING
C1261 VDD.t53 VSS 0.02783f $ **FLOATING
C1262 VDD.n621 VSS 0.41282f $ **FLOATING
C1263 VDD.t65 VSS 0.028f $ **FLOATING
C1264 VDD.n623 VSS 0.7913f $ **FLOATING
C1265 VDD.t48 VSS 0.54534f $ **FLOATING
C1266 VDD.n624 VSS 0.07093f $ **FLOATING
C1267 VDD.n625 VSS 0.07093f $ **FLOATING
C1268 VDD.n626 VSS 0.07093f $ **FLOATING
C1269 VDD.t46 VSS 0.35235f $ **FLOATING
C1270 VDD.n627 VSS 0.07093f $ **FLOATING
C1271 VDD.n628 VSS 0.07093f $ **FLOATING
C1272 VDD.n629 VSS 0.07093f $ **FLOATING
C1273 VDD.n631 VSS 0.25766f $ **FLOATING
C1274 VDD.n632 VSS 0.0703f $ **FLOATING
C1275 VDD.n633 VSS 0.07093f $ **FLOATING
C1276 VDD.n634 VSS 0.0703f $ **FLOATING
C1277 VDD.n635 VSS 0.0703f $ **FLOATING
C1278 VDD.n636 VSS 0.26396f $ **FLOATING
C1279 VDD.n637 VSS 0.28244f $ **FLOATING
C1280 VDD.n638 VSS 0.0703f $ **FLOATING
C1281 VDD.n639 VSS 0.0703f $ **FLOATING
C1282 VDD.n640 VSS 0.07093f $ **FLOATING
C1283 VDD.n641 VSS 0.0703f $ **FLOATING
C1284 VDD.n642 VSS 0.0703f $ **FLOATING
C1285 VDD.n643 VSS 0.36944f $ **FLOATING
C1286 VDD.t49 VSS 0.02783f $ **FLOATING
C1287 VDD.n644 VSS 0.41282f $ **FLOATING
C1288 VDD.t47 VSS 0.028f $ **FLOATING
C1289 VDD.n646 VSS 0.7913f $ **FLOATING
C1290 VDD.t50 VSS 0.54534f $ **FLOATING
C1291 VDD.n647 VSS 0.07093f $ **FLOATING
C1292 VDD.n648 VSS 0.07093f $ **FLOATING
C1293 VDD.n649 VSS 0.07093f $ **FLOATING
C1294 VDD.t26 VSS 0.35235f $ **FLOATING
C1295 VDD.n650 VSS 0.07093f $ **FLOATING
C1296 VDD.n651 VSS 0.07093f $ **FLOATING
C1297 VDD.n652 VSS 0.07093f $ **FLOATING
C1298 VDD.n654 VSS 0.25766f $ **FLOATING
C1299 VDD.n655 VSS 0.0703f $ **FLOATING
C1300 VDD.n656 VSS 0.07093f $ **FLOATING
C1301 VDD.n657 VSS 0.0703f $ **FLOATING
C1302 VDD.n658 VSS 0.0703f $ **FLOATING
C1303 VDD.n659 VSS 0.26396f $ **FLOATING
C1304 VDD.n660 VSS 0.28244f $ **FLOATING
C1305 VDD.n661 VSS 0.0703f $ **FLOATING
C1306 VDD.n662 VSS 0.0703f $ **FLOATING
C1307 VDD.n663 VSS 0.07093f $ **FLOATING
C1308 VDD.n664 VSS 0.0703f $ **FLOATING
C1309 VDD.n665 VSS 0.0703f $ **FLOATING
C1310 VDD.n666 VSS 0.36944f $ **FLOATING
C1311 VDD.t51 VSS 0.02783f $ **FLOATING
C1312 VDD.n667 VSS 0.41282f $ **FLOATING
C1313 VDD.t27 VSS 0.028f $ **FLOATING
C1314 VDD.n669 VSS 0.7913f $ **FLOATING
C1315 VDD.t96 VSS 0.54534f $ **FLOATING
C1316 VDD.n670 VSS 0.07093f $ **FLOATING
C1317 VDD.n671 VSS 0.07093f $ **FLOATING
C1318 VDD.n672 VSS 0.07093f $ **FLOATING
C1319 VDD.t12 VSS 0.35235f $ **FLOATING
C1320 VDD.n673 VSS 0.07093f $ **FLOATING
C1321 VDD.n674 VSS 0.07093f $ **FLOATING
C1322 VDD.n675 VSS 0.07093f $ **FLOATING
C1323 VDD.n677 VSS 0.25766f $ **FLOATING
C1324 VDD.n678 VSS 0.0703f $ **FLOATING
C1325 VDD.n679 VSS 0.07093f $ **FLOATING
C1326 VDD.n680 VSS 0.0703f $ **FLOATING
C1327 VDD.n681 VSS 0.0703f $ **FLOATING
C1328 VDD.n682 VSS 0.26396f $ **FLOATING
C1329 VDD.n683 VSS 0.28244f $ **FLOATING
C1330 VDD.n684 VSS 0.0703f $ **FLOATING
C1331 VDD.n685 VSS 0.0703f $ **FLOATING
C1332 VDD.n686 VSS 0.07093f $ **FLOATING
C1333 VDD.n687 VSS 0.0703f $ **FLOATING
C1334 VDD.n688 VSS 0.0703f $ **FLOATING
C1335 VDD.n689 VSS 0.36944f $ **FLOATING
C1336 VDD.t97 VSS 0.02783f $ **FLOATING
C1337 VDD.n690 VSS 0.41282f $ **FLOATING
C1338 VDD.t13 VSS 0.028f $ **FLOATING
C1339 VDD.n692 VSS 0.7913f $ **FLOATING
C1340 VDD.t44 VSS 0.54534f $ **FLOATING
C1341 VDD.n693 VSS 0.07093f $ **FLOATING
C1342 VDD.n694 VSS 0.07093f $ **FLOATING
C1343 VDD.n695 VSS 0.07093f $ **FLOATING
C1344 VDD.t0 VSS 0.35235f $ **FLOATING
C1345 VDD.n696 VSS 0.07093f $ **FLOATING
C1346 VDD.n697 VSS 0.07093f $ **FLOATING
C1347 VDD.n698 VSS 0.07093f $ **FLOATING
C1348 VDD.n700 VSS 0.25766f $ **FLOATING
C1349 VDD.n701 VSS 0.0703f $ **FLOATING
C1350 VDD.n702 VSS 0.07093f $ **FLOATING
C1351 VDD.n703 VSS 0.0703f $ **FLOATING
C1352 VDD.n704 VSS 0.0703f $ **FLOATING
C1353 VDD.n705 VSS 0.26396f $ **FLOATING
C1354 VDD.n706 VSS 0.28244f $ **FLOATING
C1355 VDD.n707 VSS 0.0703f $ **FLOATING
C1356 VDD.n708 VSS 0.0703f $ **FLOATING
C1357 VDD.n709 VSS 0.07093f $ **FLOATING
C1358 VDD.n710 VSS 0.0703f $ **FLOATING
C1359 VDD.n711 VSS 0.0703f $ **FLOATING
C1360 VDD.n712 VSS 0.36944f $ **FLOATING
C1361 VDD.t45 VSS 0.02783f $ **FLOATING
C1362 VDD.n713 VSS 0.41282f $ **FLOATING
C1363 VDD.t1 VSS 0.028f $ **FLOATING
C1364 VDD.n715 VSS 0.7913f $ **FLOATING
C1365 VDD.t6 VSS 0.54534f $ **FLOATING
C1366 VDD.n716 VSS 0.07093f $ **FLOATING
C1367 VDD.n717 VSS 0.07093f $ **FLOATING
C1368 VDD.n718 VSS 0.07093f $ **FLOATING
C1369 VDD.t80 VSS 0.35235f $ **FLOATING
C1370 VDD.n719 VSS 0.07093f $ **FLOATING
C1371 VDD.n720 VSS 0.07093f $ **FLOATING
C1372 VDD.n721 VSS 0.07093f $ **FLOATING
C1373 VDD.n723 VSS 0.25766f $ **FLOATING
C1374 VDD.n724 VSS 0.0703f $ **FLOATING
C1375 VDD.n725 VSS 0.07093f $ **FLOATING
C1376 VDD.n726 VSS 0.0703f $ **FLOATING
C1377 VDD.n727 VSS 0.0703f $ **FLOATING
C1378 VDD.n728 VSS 0.26396f $ **FLOATING
C1379 VDD.n729 VSS 0.28244f $ **FLOATING
C1380 VDD.n730 VSS 0.0703f $ **FLOATING
C1381 VDD.n731 VSS 0.0703f $ **FLOATING
C1382 VDD.n732 VSS 0.07093f $ **FLOATING
C1383 VDD.n733 VSS 0.0703f $ **FLOATING
C1384 VDD.n734 VSS 0.0703f $ **FLOATING
C1385 VDD.n735 VSS 0.36944f $ **FLOATING
C1386 VDD.t7 VSS 0.02783f $ **FLOATING
C1387 VDD.n736 VSS 0.41282f $ **FLOATING
C1388 VDD.t81 VSS 0.028f $ **FLOATING
C1389 VDD.n738 VSS 0.7913f $ **FLOATING
C1390 VDD.t135 VSS 0.54534f $ **FLOATING
C1391 VDD.n739 VSS 0.07093f $ **FLOATING
C1392 VDD.n740 VSS 0.07093f $ **FLOATING
C1393 VDD.n741 VSS 0.07093f $ **FLOATING
C1394 VDD.t42 VSS 0.35235f $ **FLOATING
C1395 VDD.n742 VSS 0.07093f $ **FLOATING
C1396 VDD.n743 VSS 0.07093f $ **FLOATING
C1397 VDD.n744 VSS 0.07093f $ **FLOATING
C1398 VDD.n746 VSS 0.25766f $ **FLOATING
C1399 VDD.n747 VSS 0.0703f $ **FLOATING
C1400 VDD.n748 VSS 0.07093f $ **FLOATING
C1401 VDD.n749 VSS 0.0703f $ **FLOATING
C1402 VDD.n750 VSS 0.0703f $ **FLOATING
C1403 VDD.n751 VSS 0.26396f $ **FLOATING
C1404 VDD.n752 VSS 0.28244f $ **FLOATING
C1405 VDD.n753 VSS 0.0703f $ **FLOATING
C1406 VDD.n754 VSS 0.0703f $ **FLOATING
C1407 VDD.n755 VSS 0.07093f $ **FLOATING
C1408 VDD.n756 VSS 0.0703f $ **FLOATING
C1409 VDD.n757 VSS 0.0703f $ **FLOATING
C1410 VDD.n758 VSS 0.36944f $ **FLOATING
C1411 VDD.t136 VSS 0.02783f $ **FLOATING
C1412 VDD.n759 VSS 0.41282f $ **FLOATING
C1413 VDD.t43 VSS 0.028f $ **FLOATING
C1414 VDD.n761 VSS 0.7913f $ **FLOATING
C1415 VDD.t40 VSS 0.54534f $ **FLOATING
C1416 VDD.n762 VSS 0.07093f $ **FLOATING
C1417 VDD.n763 VSS 0.07093f $ **FLOATING
C1418 VDD.n764 VSS 0.07093f $ **FLOATING
C1419 VDD.t4 VSS 0.35235f $ **FLOATING
C1420 VDD.n765 VSS 0.07093f $ **FLOATING
C1421 VDD.n766 VSS 0.07093f $ **FLOATING
C1422 VDD.n767 VSS 0.07093f $ **FLOATING
C1423 VDD.n769 VSS 0.25766f $ **FLOATING
C1424 VDD.n770 VSS 0.0703f $ **FLOATING
C1425 VDD.n771 VSS 0.07093f $ **FLOATING
C1426 VDD.n772 VSS 0.0703f $ **FLOATING
C1427 VDD.n773 VSS 0.0703f $ **FLOATING
C1428 VDD.n774 VSS 0.26396f $ **FLOATING
C1429 VDD.n775 VSS 0.28244f $ **FLOATING
C1430 VDD.n776 VSS 0.0703f $ **FLOATING
C1431 VDD.n777 VSS 0.0703f $ **FLOATING
C1432 VDD.n778 VSS 0.07093f $ **FLOATING
C1433 VDD.n779 VSS 0.0703f $ **FLOATING
C1434 VDD.n780 VSS 0.0703f $ **FLOATING
C1435 VDD.n781 VSS 0.36944f $ **FLOATING
C1436 VDD.t41 VSS 0.02783f $ **FLOATING
C1437 VDD.n782 VSS 0.41282f $ **FLOATING
C1438 VDD.t5 VSS 0.028f $ **FLOATING
C1439 VDD.n784 VSS 0.94421f $ **FLOATING
C1440 VDD.n785 VSS 0.0725f $ **FLOATING
C1441 VDD.n786 VSS 0.11317f $ **FLOATING
C1442 VDD.n787 VSS 0.11317f $ **FLOATING
C1443 VDD.n788 VSS 0.11317f $ **FLOATING
C1444 VDD.n789 VSS 0.11031f $ **FLOATING
C1445 VDD.n790 VSS 0.74597f $ **FLOATING
C1446 VDD.t146 VSS 0.99681f $ **FLOATING
C1447 VDD.n793 VSS 0.74597f $ **FLOATING
C1448 VDD.n794 VSS 0.08968f $ **FLOATING
C1449 VDD.n795 VSS 0.13867f $ **FLOATING
C1450 VDD.n796 VSS 0.0725f $ **FLOATING
C1451 VDD.n797 VSS 0.11317f $ **FLOATING
C1452 VDD.n798 VSS 0.11317f $ **FLOATING
C1453 VDD.n799 VSS 0.11317f $ **FLOATING
C1454 VDD.n800 VSS 0.11031f $ **FLOATING
C1455 VDD.n801 VSS 0.74597f $ **FLOATING
C1456 VDD.t142 VSS 0.99681f $ **FLOATING
C1457 VDD.n804 VSS 0.74597f $ **FLOATING
C1458 VDD.n805 VSS 0.08968f $ **FLOATING
C1459 VDD.n806 VSS 0.13296f $ **FLOATING
C1460 VDD.n807 VSS 0.77323f $ **FLOATING
C1461 VDD.t143 VSS 0.18803f $ **FLOATING
C1462 VDD.n808 VSS 0.62413f $ **FLOATING
C1463 VDD.t145 VSS 0.18803f $ **FLOATING
C1464 VDD.n809 VSS 0.64701f $ **FLOATING
C1465 VDD.n810 VSS 0.0725f $ **FLOATING
C1466 VDD.n811 VSS 0.11317f $ **FLOATING
C1467 VDD.n812 VSS 0.11317f $ **FLOATING
C1468 VDD.n813 VSS 0.11317f $ **FLOATING
C1469 VDD.n814 VSS 0.11031f $ **FLOATING
C1470 VDD.n815 VSS 0.74597f $ **FLOATING
C1471 VDD.t144 VSS 0.99681f $ **FLOATING
C1472 VDD.n818 VSS 0.74597f $ **FLOATING
C1473 VDD.n819 VSS 0.08968f $ **FLOATING
C1474 VDD.n820 VSS 0.13296f $ **FLOATING
C1475 VDD.n821 VSS 0.2141f $ **FLOATING
C1476 VDD.n822 VSS 0.11272f $ **FLOATING
C1477 VDD.n823 VSS 1.20047f $ **FLOATING
C1478 VDD.n824 VSS 0.08377f $ **FLOATING
C1479 VDD.n825 VSS 0.10013f $ **FLOATING
C1480 VDD.t126 VSS 0.89978f $ **FLOATING
C1481 VDD.n827 VSS 0.65938f $ **FLOATING
C1482 VDD.n828 VSS 0.10289f $ **FLOATING
C1483 VDD.n829 VSS 0.10289f $ **FLOATING
C1484 VDD.n831 VSS 0.65938f $ **FLOATING
C1485 VDD.n832 VSS 0.10289f $ **FLOATING
C1486 VDD.n833 VSS 0.07044f $ **FLOATING
C1487 VDD.n834 VSS 0.09986f $ **FLOATING
C1488 VDD.n835 VSS 0.08377f $ **FLOATING
C1489 VDD.n836 VSS 0.10013f $ **FLOATING
C1490 VDD.t125 VSS 0.89978f $ **FLOATING
C1491 VDD.n838 VSS 0.65938f $ **FLOATING
C1492 VDD.n839 VSS 0.10289f $ **FLOATING
C1493 VDD.n840 VSS 0.10289f $ **FLOATING
C1494 VDD.n842 VSS 0.65938f $ **FLOATING
C1495 VDD.n843 VSS 0.10289f $ **FLOATING
C1496 VDD.n844 VSS 0.07044f $ **FLOATING
C1497 VDD.n845 VSS 0.08945f $ **FLOATING
C1498 VDD.n846 VSS 0.72544f $ **FLOATING
C1499 VDD.n847 VSS 0.08165f $ **FLOATING
C1500 VDD.n848 VSS 0.09804f $ **FLOATING
C1501 VDD.t2 VSS 0.87289f $ **FLOATING
C1502 VDD.n850 VSS 0.64426f $ **FLOATING
C1503 VDD.n851 VSS 0.10071f $ **FLOATING
C1504 VDD.n852 VSS 0.10071f $ **FLOATING
C1505 VDD.n854 VSS 0.64426f $ **FLOATING
C1506 VDD.n855 VSS 0.10071f $ **FLOATING
C1507 VDD.n856 VSS 0.06935f $ **FLOATING
C1508 VDD.n857 VSS 0.08874f $ **FLOATING
C1509 VDD.n858 VSS 0.3387f $ **FLOATING
C1510 VDD.t3 VSS 0.13699f $ **FLOATING
C1511 VDD.n859 VSS 0.57254f $ **FLOATING
C1512 VDD.t128 VSS 0.13699f $ **FLOATING
C1513 VDD.n860 VSS 0.59543f $ **FLOATING
C1514 VDD.n861 VSS 0.08165f $ **FLOATING
C1515 VDD.n862 VSS 0.09804f $ **FLOATING
C1516 VDD.t127 VSS 0.87289f $ **FLOATING
C1517 VDD.n864 VSS 0.64426f $ **FLOATING
C1518 VDD.n865 VSS 0.10071f $ **FLOATING
C1519 VDD.n866 VSS 0.10071f $ **FLOATING
C1520 VDD.n868 VSS 0.64426f $ **FLOATING
C1521 VDD.n869 VSS 0.10071f $ **FLOATING
C1522 VDD.n870 VSS 0.06935f $ **FLOATING
C1523 VDD.n871 VSS 0.08874f $ **FLOATING
C1524 VDD.n872 VSS 0.21404f $ **FLOATING
C1525 VDD.n873 VSS 0.11715f $ **FLOATING
C1526 VDD.n874 VSS 3.67536f $ **FLOATING
C1527 VDD.n875 VSS 1.70093f $ **FLOATING
C1528 VDD.n876 VSS 0.06157f $ **FLOATING
C1529 VDD.n877 VSS 0.07824f $ **FLOATING
C1530 VDD.t140 VSS 0.66494f $ **FLOATING
C1531 VDD.n879 VSS 0.47561f $ **FLOATING
C1532 VDD.n880 VSS 0.07978f $ **FLOATING
C1533 VDD.n881 VSS 0.07978f $ **FLOATING
C1534 VDD.n883 VSS 0.47561f $ **FLOATING
C1535 VDD.n884 VSS 0.07978f $ **FLOATING
C1536 VDD.n885 VSS 0.05888f $ **FLOATING
C1537 VDD.n886 VSS 0.0864f $ **FLOATING
C1538 VDD.n887 VSS 0.2322f $ **FLOATING
C1539 VDD.t141 VSS 0.05799f $ **FLOATING
C1540 VDD.n888 VSS 0.50223f $ **FLOATING
C1541 WLOFF.t0 VSS 0.09287f $ **FLOATING
C1542 WLOFF.t1 VSS 0.09256f $ **FLOATING
C1543 WLOFF.n0 VSS 1.49997f $ **FLOATING
C1544 WLOFF.t62 VSS 0.09287f $ **FLOATING
C1545 WLOFF.t63 VSS 0.09256f $ **FLOATING
C1546 WLOFF.n1 VSS 1.49997f $ **FLOATING
C1547 WLOFF.n2 VSS 0.48523f $ **FLOATING
C1548 WLOFF.n3 VSS 1.09874f $ **FLOATING
C1549 WLOFF.t60 VSS 0.09287f $ **FLOATING
C1550 WLOFF.t61 VSS 0.09256f $ **FLOATING
C1551 WLOFF.n4 VSS 1.49997f $ **FLOATING
C1552 WLOFF.n5 VSS 0.48523f $ **FLOATING
C1553 WLOFF.n6 VSS 1.18428f $ **FLOATING
C1554 WLOFF.t58 VSS 0.09287f $ **FLOATING
C1555 WLOFF.t59 VSS 0.09256f $ **FLOATING
C1556 WLOFF.n7 VSS 1.49997f $ **FLOATING
C1557 WLOFF.n8 VSS 0.48523f $ **FLOATING
C1558 WLOFF.n9 VSS 1.18428f $ **FLOATING
C1559 WLOFF.t56 VSS 0.09287f $ **FLOATING
C1560 WLOFF.t57 VSS 0.09256f $ **FLOATING
C1561 WLOFF.n10 VSS 1.49997f $ **FLOATING
C1562 WLOFF.n11 VSS 0.48523f $ **FLOATING
C1563 WLOFF.n12 VSS 1.18428f $ **FLOATING
C1564 WLOFF.t54 VSS 0.09287f $ **FLOATING
C1565 WLOFF.t55 VSS 0.09256f $ **FLOATING
C1566 WLOFF.n13 VSS 1.49997f $ **FLOATING
C1567 WLOFF.n14 VSS 0.48523f $ **FLOATING
C1568 WLOFF.n15 VSS 1.18428f $ **FLOATING
C1569 WLOFF.t52 VSS 0.09287f $ **FLOATING
C1570 WLOFF.t53 VSS 0.09256f $ **FLOATING
C1571 WLOFF.n16 VSS 1.49997f $ **FLOATING
C1572 WLOFF.n17 VSS 0.48523f $ **FLOATING
C1573 WLOFF.n18 VSS 1.18428f $ **FLOATING
C1574 WLOFF.t50 VSS 0.09287f $ **FLOATING
C1575 WLOFF.t51 VSS 0.09256f $ **FLOATING
C1576 WLOFF.n19 VSS 1.49997f $ **FLOATING
C1577 WLOFF.n20 VSS 0.48523f $ **FLOATING
C1578 WLOFF.n21 VSS 1.18428f $ **FLOATING
C1579 WLOFF.t48 VSS 0.09287f $ **FLOATING
C1580 WLOFF.t49 VSS 0.09256f $ **FLOATING
C1581 WLOFF.n22 VSS 1.49997f $ **FLOATING
C1582 WLOFF.n23 VSS 0.48523f $ **FLOATING
C1583 WLOFF.n24 VSS 1.18428f $ **FLOATING
C1584 WLOFF.t46 VSS 0.09287f $ **FLOATING
C1585 WLOFF.t47 VSS 0.09256f $ **FLOATING
C1586 WLOFF.n25 VSS 1.49997f $ **FLOATING
C1587 WLOFF.n26 VSS 0.48523f $ **FLOATING
C1588 WLOFF.n27 VSS 1.18428f $ **FLOATING
C1589 WLOFF.t44 VSS 0.09287f $ **FLOATING
C1590 WLOFF.t45 VSS 0.09256f $ **FLOATING
C1591 WLOFF.n28 VSS 1.49997f $ **FLOATING
C1592 WLOFF.n29 VSS 0.48523f $ **FLOATING
C1593 WLOFF.n30 VSS 1.18428f $ **FLOATING
C1594 WLOFF.t42 VSS 0.09287f $ **FLOATING
C1595 WLOFF.t43 VSS 0.09256f $ **FLOATING
C1596 WLOFF.n31 VSS 1.49997f $ **FLOATING
C1597 WLOFF.n32 VSS 0.48523f $ **FLOATING
C1598 WLOFF.n33 VSS 1.18428f $ **FLOATING
C1599 WLOFF.t40 VSS 0.09287f $ **FLOATING
C1600 WLOFF.t41 VSS 0.09256f $ **FLOATING
C1601 WLOFF.n34 VSS 1.49997f $ **FLOATING
C1602 WLOFF.n35 VSS 0.48523f $ **FLOATING
C1603 WLOFF.n36 VSS 1.18428f $ **FLOATING
C1604 WLOFF.t38 VSS 0.09287f $ **FLOATING
C1605 WLOFF.t39 VSS 0.09256f $ **FLOATING
C1606 WLOFF.n37 VSS 1.49997f $ **FLOATING
C1607 WLOFF.n38 VSS 0.48523f $ **FLOATING
C1608 WLOFF.n39 VSS 1.18428f $ **FLOATING
C1609 WLOFF.t36 VSS 0.09287f $ **FLOATING
C1610 WLOFF.t37 VSS 0.09256f $ **FLOATING
C1611 WLOFF.n40 VSS 1.49997f $ **FLOATING
C1612 WLOFF.n41 VSS 0.48523f $ **FLOATING
C1613 WLOFF.n42 VSS 1.18428f $ **FLOATING
C1614 WLOFF.t34 VSS 0.09287f $ **FLOATING
C1615 WLOFF.t35 VSS 0.09256f $ **FLOATING
C1616 WLOFF.n43 VSS 1.49997f $ **FLOATING
C1617 WLOFF.n44 VSS 0.48523f $ **FLOATING
C1618 WLOFF.n45 VSS 1.18428f $ **FLOATING
C1619 WLOFF.t32 VSS 0.09287f $ **FLOATING
C1620 WLOFF.t33 VSS 0.09256f $ **FLOATING
C1621 WLOFF.n46 VSS 1.49997f $ **FLOATING
C1622 WLOFF.n47 VSS 0.48523f $ **FLOATING
C1623 WLOFF.n48 VSS 1.18428f $ **FLOATING
C1624 WLOFF.t30 VSS 0.09287f $ **FLOATING
C1625 WLOFF.t31 VSS 0.09256f $ **FLOATING
C1626 WLOFF.n49 VSS 1.49997f $ **FLOATING
C1627 WLOFF.n50 VSS 0.48523f $ **FLOATING
C1628 WLOFF.n51 VSS 1.18428f $ **FLOATING
C1629 WLOFF.t28 VSS 0.09287f $ **FLOATING
C1630 WLOFF.t29 VSS 0.09256f $ **FLOATING
C1631 WLOFF.n52 VSS 1.49997f $ **FLOATING
C1632 WLOFF.n53 VSS 0.48523f $ **FLOATING
C1633 WLOFF.n54 VSS 1.18428f $ **FLOATING
C1634 WLOFF.t26 VSS 0.09287f $ **FLOATING
C1635 WLOFF.t27 VSS 0.09256f $ **FLOATING
C1636 WLOFF.n55 VSS 1.49997f $ **FLOATING
C1637 WLOFF.n56 VSS 0.48523f $ **FLOATING
C1638 WLOFF.n57 VSS 1.18428f $ **FLOATING
C1639 WLOFF.t24 VSS 0.09287f $ **FLOATING
C1640 WLOFF.t25 VSS 0.09256f $ **FLOATING
C1641 WLOFF.n58 VSS 1.49997f $ **FLOATING
C1642 WLOFF.n59 VSS 0.48523f $ **FLOATING
C1643 WLOFF.n60 VSS 1.18428f $ **FLOATING
C1644 WLOFF.t22 VSS 0.09287f $ **FLOATING
C1645 WLOFF.t23 VSS 0.09256f $ **FLOATING
C1646 WLOFF.n61 VSS 1.49997f $ **FLOATING
C1647 WLOFF.n62 VSS 0.48523f $ **FLOATING
C1648 WLOFF.n63 VSS 1.18428f $ **FLOATING
C1649 WLOFF.t20 VSS 0.09287f $ **FLOATING
C1650 WLOFF.t21 VSS 0.09256f $ **FLOATING
C1651 WLOFF.n64 VSS 1.49997f $ **FLOATING
C1652 WLOFF.n65 VSS 0.48523f $ **FLOATING
C1653 WLOFF.n66 VSS 1.18428f $ **FLOATING
C1654 WLOFF.t18 VSS 0.09287f $ **FLOATING
C1655 WLOFF.t19 VSS 0.09256f $ **FLOATING
C1656 WLOFF.n67 VSS 1.49997f $ **FLOATING
C1657 WLOFF.n68 VSS 0.48523f $ **FLOATING
C1658 WLOFF.n69 VSS 1.18428f $ **FLOATING
C1659 WLOFF.t16 VSS 0.09287f $ **FLOATING
C1660 WLOFF.t17 VSS 0.09256f $ **FLOATING
C1661 WLOFF.n70 VSS 1.49997f $ **FLOATING
C1662 WLOFF.n71 VSS 0.48523f $ **FLOATING
C1663 WLOFF.n72 VSS 1.18428f $ **FLOATING
C1664 WLOFF.t14 VSS 0.09287f $ **FLOATING
C1665 WLOFF.t15 VSS 0.09256f $ **FLOATING
C1666 WLOFF.n73 VSS 1.49997f $ **FLOATING
C1667 WLOFF.n74 VSS 0.48523f $ **FLOATING
C1668 WLOFF.n75 VSS 1.18428f $ **FLOATING
C1669 WLOFF.t12 VSS 0.09287f $ **FLOATING
C1670 WLOFF.t13 VSS 0.09256f $ **FLOATING
C1671 WLOFF.n76 VSS 1.49997f $ **FLOATING
C1672 WLOFF.n77 VSS 0.48523f $ **FLOATING
C1673 WLOFF.n78 VSS 1.18428f $ **FLOATING
C1674 WLOFF.t10 VSS 0.09287f $ **FLOATING
C1675 WLOFF.t11 VSS 0.09256f $ **FLOATING
C1676 WLOFF.n79 VSS 1.49997f $ **FLOATING
C1677 WLOFF.n80 VSS 0.48523f $ **FLOATING
C1678 WLOFF.n81 VSS 1.18428f $ **FLOATING
C1679 WLOFF.t8 VSS 0.09287f $ **FLOATING
C1680 WLOFF.t9 VSS 0.09256f $ **FLOATING
C1681 WLOFF.n82 VSS 1.49997f $ **FLOATING
C1682 WLOFF.n83 VSS 0.48523f $ **FLOATING
C1683 WLOFF.n84 VSS 1.18428f $ **FLOATING
C1684 WLOFF.t6 VSS 0.09287f $ **FLOATING
C1685 WLOFF.t7 VSS 0.09256f $ **FLOATING
C1686 WLOFF.n85 VSS 1.49997f $ **FLOATING
C1687 WLOFF.n86 VSS 0.48523f $ **FLOATING
C1688 WLOFF.n87 VSS 1.18428f $ **FLOATING
C1689 WLOFF.t4 VSS 0.09287f $ **FLOATING
C1690 WLOFF.t5 VSS 0.09256f $ **FLOATING
C1691 WLOFF.n88 VSS 1.49997f $ **FLOATING
C1692 WLOFF.n89 VSS 0.48523f $ **FLOATING
C1693 WLOFF.n90 VSS 1.18428f $ **FLOATING
C1694 WLOFF.t2 VSS 0.09287f $ **FLOATING
C1695 WLOFF.t3 VSS 0.09256f $ **FLOATING
C1696 WLOFF.n91 VSS 1.49997f $ **FLOATING
C1697 WLOFF.n92 VSS 0.48523f $ **FLOATING
C1698 WLOFF.n93 VSS 1.81202f $ **FLOATING
C1699 WLOFF.n94 VSS 0.6799f $ **FLOATING
C1700 BL.t30 VSS 0.97064f $ **FLOATING
C1701 BL.t29 VSS 1.53866f $ **FLOATING
C1702 BL.n0 VSS 6.99145f $ **FLOATING
C1703 BL.t1 VSS 0.11022f $ **FLOATING
C1704 BL.n1 VSS 2.8397f $ **FLOATING
C1705 BL.n2 VSS 1.69962f $ **FLOATING
C1706 BL.t34 VSS 0.11022f $ **FLOATING
C1707 BL.n3 VSS 2.8397f $ **FLOATING
C1708 BL.n4 VSS 1.76839f $ **FLOATING
C1709 BL.t14 VSS 0.11022f $ **FLOATING
C1710 BL.n5 VSS 2.8397f $ **FLOATING
C1711 BL.n6 VSS 1.76839f $ **FLOATING
C1712 BL.t4 VSS 0.11022f $ **FLOATING
C1713 BL.n7 VSS 2.8397f $ **FLOATING
C1714 BL.n8 VSS 1.76839f $ **FLOATING
C1715 BL.t3 VSS 0.11022f $ **FLOATING
C1716 BL.n9 VSS 2.8397f $ **FLOATING
C1717 BL.n10 VSS 1.76839f $ **FLOATING
C1718 BL.t12 VSS 0.11022f $ **FLOATING
C1719 BL.n11 VSS 2.8397f $ **FLOATING
C1720 BL.n12 VSS 1.76839f $ **FLOATING
C1721 BL.t9 VSS 0.11022f $ **FLOATING
C1722 BL.n13 VSS 2.8397f $ **FLOATING
C1723 BL.n14 VSS 1.76839f $ **FLOATING
C1724 BL.t10 VSS 0.11022f $ **FLOATING
C1725 BL.n15 VSS 2.8397f $ **FLOATING
C1726 BL.n16 VSS 1.76839f $ **FLOATING
C1727 BL.t8 VSS 0.11022f $ **FLOATING
C1728 BL.n17 VSS 2.8397f $ **FLOATING
C1729 BL.n18 VSS 1.76839f $ **FLOATING
C1730 BL.t27 VSS 0.11022f $ **FLOATING
C1731 BL.n19 VSS 2.8397f $ **FLOATING
C1732 BL.n20 VSS 1.76839f $ **FLOATING
C1733 BL.t5 VSS 0.11022f $ **FLOATING
C1734 BL.n21 VSS 2.8397f $ **FLOATING
C1735 BL.n22 VSS 1.76839f $ **FLOATING
C1736 BL.t33 VSS 0.11022f $ **FLOATING
C1737 BL.n23 VSS 2.8397f $ **FLOATING
C1738 BL.n24 VSS 1.76839f $ **FLOATING
C1739 BL.t7 VSS 0.11022f $ **FLOATING
C1740 BL.n25 VSS 2.8397f $ **FLOATING
C1741 BL.n26 VSS 1.76839f $ **FLOATING
C1742 BL.t32 VSS 0.11022f $ **FLOATING
C1743 BL.n27 VSS 2.8397f $ **FLOATING
C1744 BL.n28 VSS 1.76839f $ **FLOATING
C1745 BL.t13 VSS 0.11022f $ **FLOATING
C1746 BL.n29 VSS 2.8397f $ **FLOATING
C1747 BL.n30 VSS 1.76839f $ **FLOATING
C1748 BL.t0 VSS 0.11022f $ **FLOATING
C1749 BL.n31 VSS 2.8397f $ **FLOATING
C1750 BL.n32 VSS 1.76839f $ **FLOATING
C1751 BL.t6 VSS 0.11022f $ **FLOATING
C1752 BL.n33 VSS 2.8397f $ **FLOATING
C1753 BL.n34 VSS 1.76839f $ **FLOATING
C1754 BL.t25 VSS 0.11022f $ **FLOATING
C1755 BL.n35 VSS 2.8397f $ **FLOATING
C1756 BL.n36 VSS 1.76839f $ **FLOATING
C1757 BL.t21 VSS 0.11022f $ **FLOATING
C1758 BL.n37 VSS 2.8397f $ **FLOATING
C1759 BL.n38 VSS 1.76839f $ **FLOATING
C1760 BL.t18 VSS 0.11022f $ **FLOATING
C1761 BL.n39 VSS 2.8397f $ **FLOATING
C1762 BL.n40 VSS 1.76839f $ **FLOATING
C1763 BL.t2 VSS 0.11022f $ **FLOATING
C1764 BL.n41 VSS 2.8397f $ **FLOATING
C1765 BL.n42 VSS 1.76839f $ **FLOATING
C1766 BL.t15 VSS 0.11022f $ **FLOATING
C1767 BL.n43 VSS 2.8397f $ **FLOATING
C1768 BL.n44 VSS 1.76839f $ **FLOATING
C1769 BL.t11 VSS 0.11022f $ **FLOATING
C1770 BL.n45 VSS 2.8397f $ **FLOATING
C1771 BL.n46 VSS 1.76839f $ **FLOATING
C1772 BL.t24 VSS 0.11022f $ **FLOATING
C1773 BL.n47 VSS 2.8397f $ **FLOATING
C1774 BL.n48 VSS 1.76839f $ **FLOATING
C1775 BL.t19 VSS 0.11022f $ **FLOATING
C1776 BL.n49 VSS 2.8397f $ **FLOATING
C1777 BL.n50 VSS 1.76839f $ **FLOATING
C1778 BL.t17 VSS 0.11022f $ **FLOATING
C1779 BL.n51 VSS 2.8397f $ **FLOATING
C1780 BL.n52 VSS 1.76839f $ **FLOATING
C1781 BL.t22 VSS 0.11022f $ **FLOATING
C1782 BL.n53 VSS 2.8397f $ **FLOATING
C1783 BL.n54 VSS 1.76839f $ **FLOATING
C1784 BL.t26 VSS 0.11022f $ **FLOATING
C1785 BL.n55 VSS 2.8397f $ **FLOATING
C1786 BL.n56 VSS 1.76839f $ **FLOATING
C1787 BL.t28 VSS 0.11022f $ **FLOATING
C1788 BL.n57 VSS 2.8397f $ **FLOATING
C1789 BL.n58 VSS 1.76839f $ **FLOATING
C1790 BL.t16 VSS 0.11022f $ **FLOATING
C1791 BL.n59 VSS 2.8397f $ **FLOATING
C1792 BL.n60 VSS 1.76839f $ **FLOATING
C1793 BL.t20 VSS 0.11022f $ **FLOATING
C1794 BL.n61 VSS 2.8397f $ **FLOATING
C1795 BL.n62 VSS 1.76839f $ **FLOATING
C1796 BL.t23 VSS 0.11022f $ **FLOATING
C1797 BL.n63 VSS 2.8397f $ **FLOATING
C1798 BL.n64 VSS 1.92067f $ **FLOATING
C1799 BL.t36 VSS 0.42111f $ **FLOATING
C1800 BL.t35 VSS 0.39609f $ **FLOATING
C1801 BL.n65 VSS 3.77056f $ **FLOATING
C1802 BL.n66 VSS 0.17471f $ **FLOATING
C1803 BL.n67 VSS 1.91576f $ **FLOATING
C1804 BL.t31 VSS 0.34063f $ **FLOATING
C1805 BL.n68 VSS 3.21276f $ **FLOATING
C1806 BL.n69 VSS 7.15828f $ **FLOATING
C1807 BL.n70 VSS 4.03743f $ **FLOATING
C1808 BLB.t33 VSS 0.87554f $ **FLOATING
C1809 BLB.t34 VSS 1.34441f $ **FLOATING
C1810 BLB.n0 VSS 5.64621f $ **FLOATING
C1811 BLB.t13 VSS 0.0988f $ **FLOATING
C1812 BLB.n1 VSS 2.49226f $ **FLOATING
C1813 BLB.n2 VSS 1.57183f $ **FLOATING
C1814 BLB.t24 VSS 0.0988f $ **FLOATING
C1815 BLB.n3 VSS 2.49226f $ **FLOATING
C1816 BLB.n4 VSS 1.58061f $ **FLOATING
C1817 BLB.t29 VSS 0.0988f $ **FLOATING
C1818 BLB.n5 VSS 2.49226f $ **FLOATING
C1819 BLB.n6 VSS 1.58061f $ **FLOATING
C1820 BLB.t14 VSS 0.0988f $ **FLOATING
C1821 BLB.n7 VSS 2.49226f $ **FLOATING
C1822 BLB.n8 VSS 1.58061f $ **FLOATING
C1823 BLB.t15 VSS 0.0988f $ **FLOATING
C1824 BLB.n9 VSS 2.49226f $ **FLOATING
C1825 BLB.n10 VSS 1.58061f $ **FLOATING
C1826 BLB.t11 VSS 0.0988f $ **FLOATING
C1827 BLB.n11 VSS 2.49226f $ **FLOATING
C1828 BLB.n12 VSS 1.58061f $ **FLOATING
C1829 BLB.t12 VSS 0.0988f $ **FLOATING
C1830 BLB.n13 VSS 2.49226f $ **FLOATING
C1831 BLB.n14 VSS 1.58061f $ **FLOATING
C1832 BLB.t25 VSS 0.0988f $ **FLOATING
C1833 BLB.n15 VSS 2.49226f $ **FLOATING
C1834 BLB.n16 VSS 1.58061f $ **FLOATING
C1835 BLB.t17 VSS 0.0988f $ **FLOATING
C1836 BLB.n17 VSS 2.49226f $ **FLOATING
C1837 BLB.n18 VSS 1.58061f $ **FLOATING
C1838 BLB.t19 VSS 0.0988f $ **FLOATING
C1839 BLB.n19 VSS 2.49226f $ **FLOATING
C1840 BLB.n20 VSS 1.58061f $ **FLOATING
C1841 BLB.t10 VSS 0.0988f $ **FLOATING
C1842 BLB.n21 VSS 2.49226f $ **FLOATING
C1843 BLB.n22 VSS 1.58061f $ **FLOATING
C1844 BLB.t9 VSS 0.0988f $ **FLOATING
C1845 BLB.n23 VSS 2.49226f $ **FLOATING
C1846 BLB.n24 VSS 1.58061f $ **FLOATING
C1847 BLB.t26 VSS 0.0988f $ **FLOATING
C1848 BLB.n25 VSS 2.49226f $ **FLOATING
C1849 BLB.n26 VSS 1.58061f $ **FLOATING
C1850 BLB.t8 VSS 0.0988f $ **FLOATING
C1851 BLB.n27 VSS 2.49226f $ **FLOATING
C1852 BLB.n28 VSS 1.58061f $ **FLOATING
C1853 BLB.t4 VSS 0.0988f $ **FLOATING
C1854 BLB.n29 VSS 2.49226f $ **FLOATING
C1855 BLB.n30 VSS 1.58061f $ **FLOATING
C1856 BLB.t3 VSS 0.0988f $ **FLOATING
C1857 BLB.n31 VSS 2.49226f $ **FLOATING
C1858 BLB.n32 VSS 1.58061f $ **FLOATING
C1859 BLB.t2 VSS 0.0988f $ **FLOATING
C1860 BLB.n33 VSS 2.49226f $ **FLOATING
C1861 BLB.n34 VSS 1.58061f $ **FLOATING
C1862 BLB.t32 VSS 0.0988f $ **FLOATING
C1863 BLB.n35 VSS 2.49226f $ **FLOATING
C1864 BLB.n36 VSS 1.58061f $ **FLOATING
C1865 BLB.t30 VSS 0.0988f $ **FLOATING
C1866 BLB.n37 VSS 2.49226f $ **FLOATING
C1867 BLB.n38 VSS 1.58061f $ **FLOATING
C1868 BLB.t1 VSS 0.0988f $ **FLOATING
C1869 BLB.n39 VSS 2.49226f $ **FLOATING
C1870 BLB.n40 VSS 1.58061f $ **FLOATING
C1871 BLB.t5 VSS 0.0988f $ **FLOATING
C1872 BLB.n41 VSS 2.49226f $ **FLOATING
C1873 BLB.n42 VSS 1.58061f $ **FLOATING
C1874 BLB.t21 VSS 0.0988f $ **FLOATING
C1875 BLB.n43 VSS 2.49226f $ **FLOATING
C1876 BLB.n44 VSS 1.58061f $ **FLOATING
C1877 BLB.t31 VSS 0.0988f $ **FLOATING
C1878 BLB.n45 VSS 2.49226f $ **FLOATING
C1879 BLB.n46 VSS 1.58061f $ **FLOATING
C1880 BLB.t7 VSS 0.0988f $ **FLOATING
C1881 BLB.n47 VSS 2.49226f $ **FLOATING
C1882 BLB.n48 VSS 1.58061f $ **FLOATING
C1883 BLB.t6 VSS 0.0988f $ **FLOATING
C1884 BLB.n49 VSS 2.49226f $ **FLOATING
C1885 BLB.n50 VSS 1.58061f $ **FLOATING
C1886 BLB.t23 VSS 0.0988f $ **FLOATING
C1887 BLB.n51 VSS 2.49226f $ **FLOATING
C1888 BLB.n52 VSS 1.58061f $ **FLOATING
C1889 BLB.t18 VSS 0.0988f $ **FLOATING
C1890 BLB.n53 VSS 2.49226f $ **FLOATING
C1891 BLB.n54 VSS 1.58061f $ **FLOATING
C1892 BLB.t0 VSS 0.0988f $ **FLOATING
C1893 BLB.n55 VSS 2.49226f $ **FLOATING
C1894 BLB.n56 VSS 1.58061f $ **FLOATING
C1895 BLB.t22 VSS 0.0988f $ **FLOATING
C1896 BLB.n57 VSS 2.49226f $ **FLOATING
C1897 BLB.n58 VSS 1.58061f $ **FLOATING
C1898 BLB.t16 VSS 0.0988f $ **FLOATING
C1899 BLB.n59 VSS 2.49226f $ **FLOATING
C1900 BLB.n60 VSS 1.58061f $ **FLOATING
C1901 BLB.t20 VSS 0.0988f $ **FLOATING
C1902 BLB.n61 VSS 2.49226f $ **FLOATING
C1903 BLB.n62 VSS 1.58061f $ **FLOATING
C1904 BLB.t28 VSS 0.0988f $ **FLOATING
C1905 BLB.n63 VSS 2.49226f $ **FLOATING
C1906 BLB.n64 VSS 1.72989f $ **FLOATING
C1907 BLB.t36 VSS 0.37249f $ **FLOATING
C1908 BLB.t35 VSS 0.35977f $ **FLOATING
C1909 BLB.n65 VSS 3.20337f $ **FLOATING
C1910 BLB.n66 VSS 0.42852f $ **FLOATING
C1911 BLB.n67 VSS 1.7255f $ **FLOATING
C1912 BLB.t27 VSS 0.30104f $ **FLOATING
C1913 BLB.n68 VSS 2.68605f $ **FLOATING
C1914 BLB.n69 VSS 6.33552f $ **FLOATING
C1915 BLB.n70 VSS 4.07517f $ **FLOATING
C1916 PRECH.t0 VSS 0.1872f $ **FLOATING
C1917 PRECH.n0 VSS 1.09833f $ **FLOATING
C1918 PRECH.t1 VSS 0.18654f $ **FLOATING
C1919 PRECH.n1 VSS 0.52957f $ **FLOATING
C1920 PRECH.t2 VSS 0.18654f $ **FLOATING
C1921 PRECH.n2 VSS 0.64843f $ **FLOATING
C1922 SCLK.t1 VSS 0.13994f $ **FLOATING
C1923 SCLK.t0 VSS 0.09906f $ **FLOATING
C1924 SCLK.n0 VSS 1.58086f $ **FLOATING
C1925 SCLK.t2 VSS 0.1395f $ **FLOATING
C1926 SCLK.n1 VSS 1.12458f $ **FLOATING
C1927 SCLK.n2 VSS 0.51931f $ **FLOATING
C1928 WE.t0 VSS 0.28779f $ **FLOATING
C1929 WE.t1 VSS 0.28478f $ **FLOATING
C1930 WE.n0 VSS 4.88781f $ **FLOATING
C1931 WE.n1 VSS 0.46138f $ **FLOATING
C1932 WE.t2 VSS 0.1424f $ **FLOATING
C1933 WE.n2 VSS 2.08308f $ **FLOATING
C1934 WE.t3 VSS 0.11811f $ **FLOATING
C1935 WE.n3 VSS 0.81226f $ **FLOATING
C1936 DATA_B.t1 VSS 0.42789f $ **FLOATING
C1937 DATA_B.n0 VSS 4.12738f $ **FLOATING
C1938 DATA_B.t0 VSS 0.42702f $ **FLOATING
C1939 DATA_B.n1 VSS 3.01556f $ **FLOATING
C1940 DATA.t1 VSS 0.42387f $ **FLOATING
C1941 DATA.t0 VSS 0.4212f $ **FLOATING
C1942 DATA.n0 VSS 5.55491f $ **FLOATING
C1943 DATA.n1 VSS 1.36867f $ **FLOATING
.ends
