* NGSPICE file created from column_32_full_g7_wpre2p52_flat.ext - technology: sky130A

.subckt column_32_full_g7_wpre2p52_flat BL BLB VSS VDD WLOFF PRECH SCLK WE DATA_B
+ DATA
X0 a_617_40688.t2 WLOFF.t30 BLB.t29 VSS.t114 sky130_fd_pr__nfet_01v8 ad=0.174 pd=1.78 as=0.174 ps=1.78 w=0.6 l=0.15
X1 a_617_6212.t2 WLOFF.t4 BLB.t12 VSS.t114 sky130_fd_pr__nfet_01v8 ad=0.174 pd=1.78 as=0.174 ps=1.78 w=0.6 l=0.15
X2 a_665_48732.t1 a_617_48644.t4 VDD.t124 VDD.t123 sky130_fd_pr__pfet_01v8 ad=0.1218 pd=1.42 as=0.1218 ps=1.42 w=0.42 l=0.15
X3 a_617_908.t0 a_665_996.t3 VSS.t5 VSS.t4 sky130_fd_pr__nfet_01v8 ad=0.3654 pd=3.1 as=0.3654 ps=3.1 w=1.26 l=0.15
X4 a_665_46080.t0 a_617_45992.t4 VDD.t113 VDD.t112 sky130_fd_pr__pfet_01v8 ad=0.1218 pd=1.42 as=0.1218 ps=1.42 w=0.42 l=0.15
X5 a_3077_n9274.t1 DATA.t1 BLB.t33 VDD.t139 sky130_fd_pr__pfet_01v8 ad=1.4616 pd=10.66 as=1.4616 ps=10.66 w=5.04 l=0.15
X6 a_665_77904.t2 WLOFF.t59 BL.t9 VSS.t113 sky130_fd_pr__nfet_01v8 ad=0.174 pd=1.78 as=0.174 ps=1.78 w=0.6 l=0.15
X7 a_617_67208.t2 WLOFF.t50 BLB.t7 VSS.t114 sky130_fd_pr__nfet_01v8 ad=0.174 pd=1.78 as=0.174 ps=1.78 w=0.6 l=0.15
X8 a_1065_n6268.t0 sense_amp_scale1p5_flat_0.SA_OUT.t3 sense_amp_scale1p5_flat_0.SA_OUTB.t0 VSS.t6 sky130_fd_pr__nfet_01v8 ad=0.2842 pd=2.54 as=0.2842 ps=2.54 w=0.98 l=0.15
X9 VDD.t143 PRECH.t1 BLB.t36 VDD.t142 sky130_fd_pr__pfet_01v8 ad=0.7308 pd=5.62 as=0.7308 ps=5.62 w=2.52 l=0.15
X10 a_617_8864.t2 WLOFF.t6 BLB.t31 VSS.t114 sky130_fd_pr__nfet_01v8 ad=0.174 pd=1.78 as=0.174 ps=1.78 w=0.6 l=0.15
X11 a_617_11516.t1 a_665_11604.t4 VDD.t5 VDD.t4 sky130_fd_pr__pfet_01v8 ad=0.1218 pd=1.42 as=0.1218 ps=1.42 w=0.42 l=0.15
X12 a_665_51384.t0 WLOFF.t39 BL.t20 VSS.t113 sky130_fd_pr__nfet_01v8 ad=0.174 pd=1.78 as=0.174 ps=1.78 w=0.6 l=0.15
X13 a_617_3560.t1 a_665_3648.t3 VSS.t24 VSS.t23 sky130_fd_pr__nfet_01v8 ad=0.3654 pd=3.1 as=0.3654 ps=3.1 w=1.26 l=0.15
X14 a_665_51384.t2 a_617_51296.t3 VSS.t119 VSS.t118 sky130_fd_pr__nfet_01v8 ad=0.3654 pd=3.1 as=0.3654 ps=3.1 w=1.26 l=0.15
X15 a_617_77816.t0 a_665_77904.t3 VSS.t36 VSS.t35 sky130_fd_pr__nfet_01v8 ad=0.3654 pd=3.1 as=0.3654 ps=3.1 w=1.26 l=0.15
X16 a_665_54036.t2 WLOFF.t41 BL.t21 VSS.t113 sky130_fd_pr__nfet_01v8 ad=0.174 pd=1.78 as=0.174 ps=1.78 w=0.6 l=0.15
X17 a_665_8952.t2 a_617_8864.t3 VSS.t122 VSS.t121 sky130_fd_pr__nfet_01v8 ad=0.3654 pd=3.1 as=0.3654 ps=3.1 w=1.26 l=0.15
X18 a_617_27428.t2 WLOFF.t20 BLB.t26 VSS.t114 sky130_fd_pr__nfet_01v8 ad=0.174 pd=1.78 as=0.174 ps=1.78 w=0.6 l=0.15
X19 a_617_75164.t0 a_665_75252.t3 VSS.t34 VSS.t33 sky130_fd_pr__nfet_01v8 ad=0.3654 pd=3.1 as=0.3654 ps=3.1 w=1.26 l=0.15
X20 a_617_59252.t1 a_665_59340.t4 VDD.t115 VDD.t114 sky130_fd_pr__pfet_01v8 ad=0.1218 pd=1.42 as=0.1218 ps=1.42 w=0.42 l=0.15
X21 a_665_54036.t1 a_617_53948.t3 VSS.t108 VSS.t107 sky130_fd_pr__nfet_01v8 ad=0.3654 pd=3.1 as=0.3654 ps=3.1 w=1.26 l=0.15
X22 VSS.t117 SCLK.t0 a_1065_n6268.t1 VSS.t116 sky130_fd_pr__nfet_01v8 ad=0.2842 pd=2.54 as=0.2842 ps=2.54 w=0.98 l=0.15
X23 a_617_8864.t1 a_665_8952.t4 VDD.t55 VDD.t54 sky130_fd_pr__pfet_01v8 ad=0.1218 pd=1.42 as=0.1218 ps=1.42 w=0.42 l=0.15
X24 a_665_11604.t2 WLOFF.t9 BL.t30 VSS.t113 sky130_fd_pr__nfet_01v8 ad=0.174 pd=1.78 as=0.174 ps=1.78 w=0.6 l=0.15
X25 a_617_83120.t1 a_665_83208.t4 VDD.t95 VDD.t94 sky130_fd_pr__pfet_01v8 ad=0.1218 pd=1.42 as=0.1218 ps=1.42 w=0.42 l=0.15
X26 a_665_6300.t2 WLOFF.t5 BL.t4 VSS.t113 sky130_fd_pr__nfet_01v8 ad=0.174 pd=1.78 as=0.174 ps=1.78 w=0.6 l=0.15
X27 a_617_6212.t1 a_665_6300.t4 VDD.t53 VDD.t52 sky130_fd_pr__pfet_01v8 ad=0.1218 pd=1.42 as=0.1218 ps=1.42 w=0.42 l=0.15
X28 a_665_61992.t2 WLOFF.t47 BL.t12 VSS.t113 sky130_fd_pr__nfet_01v8 ad=0.174 pd=1.78 as=0.174 ps=1.78 w=0.6 l=0.15
X29 a_665_38124.t2 WLOFF.t29 BL.t32 VSS.t113 sky130_fd_pr__nfet_01v8 ad=0.174 pd=1.78 as=0.174 ps=1.78 w=0.6 l=0.15
X30 a_665_14256.t2 WLOFF.t11 BL.t11 VSS.t113 sky130_fd_pr__nfet_01v8 ad=0.174 pd=1.78 as=0.174 ps=1.78 w=0.6 l=0.15
X31 a_665_54036.t0 a_617_53948.t4 VDD.t103 VDD.t102 sky130_fd_pr__pfet_01v8 ad=0.1218 pd=1.42 as=0.1218 ps=1.42 w=0.42 l=0.15
X32 a_665_16908.t0 a_617_16820.t3 VSS.t50 VSS.t49 sky130_fd_pr__nfet_01v8 ad=0.3654 pd=3.1 as=0.3654 ps=3.1 w=1.26 l=0.15
X33 VDD.t141 WE.t3 a_677_n8854.t1 VDD.t140 sky130_fd_pr__pfet_01v8 ad=0.2436 pd=2.26 as=0.2436 ps=2.26 w=0.84 l=0.15
X34 a_665_8952.t1 WLOFF.t7 BL.t8 VSS.t113 sky130_fd_pr__nfet_01v8 ad=0.174 pd=1.78 as=0.174 ps=1.78 w=0.6 l=0.15
X35 a_617_11516.t0 a_665_11604.t3 VSS.t124 VSS.t123 sky130_fd_pr__nfet_01v8 ad=0.3654 pd=3.1 as=0.3654 ps=3.1 w=1.26 l=0.15
X36 a_665_61992.t0 a_617_61904.t4 VDD.t77 VDD.t76 sky130_fd_pr__pfet_01v8 ad=0.1218 pd=1.42 as=0.1218 ps=1.42 w=0.42 l=0.15
X37 a_617_35384.t0 a_665_35472.t3 VSS.t12 VSS.t11 sky130_fd_pr__nfet_01v8 ad=0.3654 pd=3.1 as=0.3654 ps=3.1 w=1.26 l=0.15
X38 a_665_14256.t0 a_617_14168.t3 VSS.t48 VSS.t47 sky130_fd_pr__nfet_01v8 ad=0.3654 pd=3.1 as=0.3654 ps=3.1 w=1.26 l=0.15
X39 a_617_19472.t1 a_665_19560.t4 VDD.t87 VDD.t86 sky130_fd_pr__pfet_01v8 ad=0.1218 pd=1.42 as=0.1218 ps=1.42 w=0.42 l=0.15
X40 a_617_48644.t1 a_665_48732.t4 VDD.t121 VDD.t120 sky130_fd_pr__pfet_01v8 ad=0.1218 pd=1.42 as=0.1218 ps=1.42 w=0.42 l=0.15
X41 a_665_48732.t0 WLOFF.t37 BL.t1 VSS.t113 sky130_fd_pr__nfet_01v8 ad=0.174 pd=1.78 as=0.174 ps=1.78 w=0.6 l=0.15
X42 VSS.t137 WE.t2 a_677_n8854.t0 VSS.t136 sky130_fd_pr__nfet_01v8 ad=0.2436 pd=2.26 as=0.2436 ps=2.26 w=0.84 l=0.15
X43 a_665_64644.t0 a_617_64556.t4 VDD.t67 VDD.t66 sky130_fd_pr__pfet_01v8 ad=0.1218 pd=1.42 as=0.1218 ps=1.42 w=0.42 l=0.15
X44 a_617_38036.t0 a_665_38124.t3 VSS.t40 VSS.t39 sky130_fd_pr__nfet_01v8 ad=0.3654 pd=3.1 as=0.3654 ps=3.1 w=1.26 l=0.15
X45 BLB.t35 PRECH.t0 BL.t36 VDD.t146 sky130_fd_pr__pfet_01v8 ad=0.7308 pd=5.62 as=0.7308 ps=5.62 w=2.52 l=0.15
X46 a_617_45992.t1 a_665_46080.t4 VDD.t109 VDD.t108 sky130_fd_pr__pfet_01v8 ad=0.1218 pd=1.42 as=0.1218 ps=1.42 w=0.42 l=0.15
X47 a_665_14256.t1 a_617_14168.t4 VDD.t73 VDD.t72 sky130_fd_pr__pfet_01v8 ad=0.1218 pd=1.42 as=0.1218 ps=1.42 w=0.42 l=0.15
X48 a_665_22212.t1 WLOFF.t17 BL.t16 VSS.t113 sky130_fd_pr__nfet_01v8 ad=0.174 pd=1.78 as=0.174 ps=1.78 w=0.6 l=0.15
X49 a_1865_n13274.t0 DATA_B.t0 BL.t25 VSS.t115 sky130_fd_pr__nfet_01v8 ad=1.4616 pd=10.66 as=1.4616 ps=10.66 w=5.04 l=0.15
X50 a_617_83120.t2 WLOFF.t62 BLB.t13 VSS.t114 sky130_fd_pr__nfet_01v8 ad=0.174 pd=1.78 as=0.174 ps=1.78 w=0.6 l=0.15
X51 a_665_24864.t1 a_617_24776.t4 VDD.t61 VDD.t60 sky130_fd_pr__pfet_01v8 ad=0.1218 pd=1.42 as=0.1218 ps=1.42 w=0.42 l=0.15
X52 a_665_69948.t2 WLOFF.t53 BL.t15 VSS.t113 sky130_fd_pr__nfet_01v8 ad=0.174 pd=1.78 as=0.174 ps=1.78 w=0.6 l=0.15
X53 a_665_22212.t0 a_617_22124.t4 VDD.t51 VDD.t50 sky130_fd_pr__pfet_01v8 ad=0.1218 pd=1.42 as=0.1218 ps=1.42 w=0.42 l=0.15
X54 a_665_48732.t2 a_617_48644.t3 VSS.t132 VSS.t131 sky130_fd_pr__nfet_01v8 ad=0.3654 pd=3.1 as=0.3654 ps=3.1 w=1.26 l=0.15
X55 a_617_43340.t2 WLOFF.t32 BLB.t1 VSS.t114 sky130_fd_pr__nfet_01v8 ad=0.174 pd=1.78 as=0.174 ps=1.78 w=0.6 l=0.15
X56 a_665_69948.t0 a_617_69860.t4 VDD.t37 VDD.t36 sky130_fd_pr__pfet_01v8 ad=0.1218 pd=1.42 as=0.1218 ps=1.42 w=0.42 l=0.15
X57 a_665_22212.t2 a_617_22124.t3 VSS.t128 VSS.t127 sky130_fd_pr__nfet_01v8 ad=0.3654 pd=3.1 as=0.3654 ps=3.1 w=1.26 l=0.15
X58 a_665_46080.t1 a_617_45992.t3 VSS.t100 VSS.t99 sky130_fd_pr__nfet_01v8 ad=0.3654 pd=3.1 as=0.3654 ps=3.1 w=1.26 l=0.15
X59 a_665_56688.t2 WLOFF.t43 BL.t0 VSS.t113 sky130_fd_pr__nfet_01v8 ad=0.174 pd=1.78 as=0.174 ps=1.78 w=0.6 l=0.15
X60 a_617_45992.t2 WLOFF.t34 BLB.t9 VSS.t114 sky130_fd_pr__nfet_01v8 ad=0.174 pd=1.78 as=0.174 ps=1.78 w=0.6 l=0.15
X61 a_617_53948.t1 a_665_54036.t4 VDD.t132 VDD.t131 sky130_fd_pr__pfet_01v8 ad=0.1218 pd=1.42 as=0.1218 ps=1.42 w=0.42 l=0.15
X62 a_665_30168.t2 WLOFF.t23 BL.t6 VSS.t113 sky130_fd_pr__nfet_01v8 ad=0.174 pd=1.78 as=0.174 ps=1.78 w=0.6 l=0.15
X63 a_617_61904.t1 a_665_61992.t4 VDD.t93 VDD.t92 sky130_fd_pr__pfet_01v8 ad=0.1218 pd=1.42 as=0.1218 ps=1.42 w=0.42 l=0.15
X64 a_665_59340.t2 WLOFF.t45 BL.t22 VSS.t113 sky130_fd_pr__nfet_01v8 ad=0.174 pd=1.78 as=0.174 ps=1.78 w=0.6 l=0.15
X65 a_665_56688.t1 a_617_56600.t3 VSS.t60 VSS.t59 sky130_fd_pr__nfet_01v8 ad=0.3654 pd=3.1 as=0.3654 ps=3.1 w=1.26 l=0.15
X66 a_617_51296.t0 a_665_51384.t3 VSS.t112 VSS.t111 sky130_fd_pr__nfet_01v8 ad=0.3654 pd=3.1 as=0.3654 ps=3.1 w=1.26 l=0.15
X67 a_665_30168.t1 a_617_30080.t3 VSS.t56 VSS.t55 sky130_fd_pr__nfet_01v8 ad=0.3654 pd=3.1 as=0.3654 ps=3.1 w=1.26 l=0.15
X68 a_665_16908.t1 WLOFF.t13 BL.t17 VSS.t113 sky130_fd_pr__nfet_01v8 ad=0.174 pd=1.78 as=0.174 ps=1.78 w=0.6 l=0.15
X69 a_617_64556.t1 a_665_64644.t4 VDD.t45 VDD.t44 sky130_fd_pr__pfet_01v8 ad=0.1218 pd=1.42 as=0.1218 ps=1.42 w=0.42 l=0.15
X70 a_665_32820.t1 a_617_32732.t4 VDD.t97 VDD.t96 sky130_fd_pr__pfet_01v8 ad=0.1218 pd=1.42 as=0.1218 ps=1.42 w=0.42 l=0.15
X71 a_665_56688.t0 a_617_56600.t4 VDD.t69 VDD.t68 sky130_fd_pr__pfet_01v8 ad=0.1218 pd=1.42 as=0.1218 ps=1.42 w=0.42 l=0.15
X72 a_617_53948.t0 a_665_54036.t3 VSS.t135 VSS.t134 sky130_fd_pr__nfet_01v8 ad=0.3654 pd=3.1 as=0.3654 ps=3.1 w=1.26 l=0.15
X73 a_617_77816.t2 WLOFF.t58 BLB.t6 VSS.t114 sky130_fd_pr__nfet_01v8 ad=0.174 pd=1.78 as=0.174 ps=1.78 w=0.6 l=0.15
X74 a_617_14168.t1 a_665_14256.t4 VDD.t19 VDD.t18 sky130_fd_pr__pfet_01v8 ad=0.1218 pd=1.42 as=0.1218 ps=1.42 w=0.42 l=0.15
X75 a_665_30168.t0 a_617_30080.t4 VDD.t33 VDD.t32 sky130_fd_pr__pfet_01v8 ad=0.1218 pd=1.42 as=0.1218 ps=1.42 w=0.42 l=0.15
X76 a_617_51296.t2 WLOFF.t38 BLB.t15 VSS.t114 sky130_fd_pr__nfet_01v8 ad=0.174 pd=1.78 as=0.174 ps=1.78 w=0.6 l=0.15
X77 a_617_6212.t0 a_665_6300.t3 VSS.t66 VSS.t65 sky130_fd_pr__nfet_01v8 ad=0.3654 pd=3.1 as=0.3654 ps=3.1 w=1.26 l=0.15
X78 a_665_19560.t1 WLOFF.t15 BL.t7 VSS.t113 sky130_fd_pr__nfet_01v8 ad=0.174 pd=1.78 as=0.174 ps=1.78 w=0.6 l=0.15
X79 a_617_16820.t0 a_665_16908.t3 VSS.t92 VSS.t91 sky130_fd_pr__nfet_01v8 ad=0.3654 pd=3.1 as=0.3654 ps=3.1 w=1.26 l=0.15
X80 a_665_64644.t2 WLOFF.t49 BL.t3 VSS.t113 sky130_fd_pr__nfet_01v8 ad=0.174 pd=1.78 as=0.174 ps=1.78 w=0.6 l=0.15
X81 a_665_61992.t1 a_617_61904.t3 VSS.t102 VSS.t101 sky130_fd_pr__nfet_01v8 ad=0.3654 pd=3.1 as=0.3654 ps=3.1 w=1.26 l=0.15
X82 a_617_53948.t2 WLOFF.t40 BLB.t4 VSS.t114 sky130_fd_pr__nfet_01v8 ad=0.174 pd=1.78 as=0.174 ps=1.78 w=0.6 l=0.15
X83 a_617_24776.t1 a_665_24864.t4 VDD.t23 VDD.t22 sky130_fd_pr__pfet_01v8 ad=0.1218 pd=1.42 as=0.1218 ps=1.42 w=0.42 l=0.15
X84 a_617_14168.t0 a_665_14256.t3 VSS.t22 VSS.t21 sky130_fd_pr__nfet_01v8 ad=0.3654 pd=3.1 as=0.3654 ps=3.1 w=1.26 l=0.15
X85 a_665_16908.t2 a_617_16820.t4 VDD.t136 VDD.t135 sky130_fd_pr__pfet_01v8 ad=0.1218 pd=1.42 as=0.1218 ps=1.42 w=0.42 l=0.15
X86 VDD.t134 a_677_n8854.t3 a_1477_n9274.t1 VDD.t133 sky130_fd_pr__pfet_01v8 ad=1.4616 pd=10.66 as=1.4616 ps=10.66 w=5.04 l=0.15
X87 a_617_22124.t1 a_665_22212.t4 VDD.t49 VDD.t48 sky130_fd_pr__pfet_01v8 ad=0.1218 pd=1.42 as=0.1218 ps=1.42 w=0.42 l=0.15
X88 a_617_11516.t2 WLOFF.t8 BLB.t17 VSS.t114 sky130_fd_pr__nfet_01v8 ad=0.174 pd=1.78 as=0.174 ps=1.78 w=0.6 l=0.15
X89 a_617_69860.t1 a_665_69948.t4 VDD.t11 VDD.t10 sky130_fd_pr__pfet_01v8 ad=0.1218 pd=1.42 as=0.1218 ps=1.42 w=0.42 l=0.15
X90 a_665_64644.t1 a_617_64556.t3 VSS.t72 VSS.t71 sky130_fd_pr__nfet_01v8 ad=0.3654 pd=3.1 as=0.3654 ps=3.1 w=1.26 l=0.15
X91 VSS.t139 WE.t1 a_1865_n13274.t1 VSS.t138 sky130_fd_pr__nfet_01v8 ad=1.4616 pd=10.66 as=1.4616 ps=10.66 w=5.04 l=0.15
X92 a_617_14168.t2 WLOFF.t10 BLB.t11 VSS.t114 sky130_fd_pr__nfet_01v8 ad=0.174 pd=1.78 as=0.174 ps=1.78 w=0.6 l=0.15
X93 a_665_24864.t2 WLOFF.t19 BL.t10 VSS.t113 sky130_fd_pr__nfet_01v8 ad=0.174 pd=1.78 as=0.174 ps=1.78 w=0.6 l=0.15
X94 a_665_72600.t2 WLOFF.t55 BL.t31 VSS.t113 sky130_fd_pr__nfet_01v8 ad=0.174 pd=1.78 as=0.174 ps=1.78 w=0.6 l=0.15
X95 a_617_61904.t2 WLOFF.t46 BLB.t20 VSS.t114 sky130_fd_pr__nfet_01v8 ad=0.174 pd=1.78 as=0.174 ps=1.78 w=0.6 l=0.15
X96 a_617_38036.t2 WLOFF.t28 BLB.t25 VSS.t114 sky130_fd_pr__nfet_01v8 ad=0.174 pd=1.78 as=0.174 ps=1.78 w=0.6 l=0.15
X97 a_665_24864.t0 a_617_24776.t3 VSS.t3 VSS.t2 sky130_fd_pr__nfet_01v8 ad=0.3654 pd=3.1 as=0.3654 ps=3.1 w=1.26 l=0.15
X98 a_665_75252.t2 WLOFF.t57 BL.t34 VSS.t113 sky130_fd_pr__nfet_01v8 ad=0.174 pd=1.78 as=0.174 ps=1.78 w=0.6 l=0.15
X99 a_617_48644.t2 WLOFF.t36 BLB.t24 VSS.t114 sky130_fd_pr__nfet_01v8 ad=0.174 pd=1.78 as=0.174 ps=1.78 w=0.6 l=0.15
X100 a_617_48644.t0 a_665_48732.t3 VSS.t110 VSS.t109 sky130_fd_pr__nfet_01v8 ad=0.3654 pd=3.1 as=0.3654 ps=3.1 w=1.26 l=0.15
X101 a_617_32732.t1 a_665_32820.t4 VDD.t63 VDD.t62 sky130_fd_pr__pfet_01v8 ad=0.1218 pd=1.42 as=0.1218 ps=1.42 w=0.42 l=0.15
X102 VDD.t1 sense_amp_scale1p5_flat_0.SA_OUTB.t4 sense_amp_scale1p5_flat_0.SA_OUT.t0 VDD.t0 sky130_fd_pr__pfet_01v8 ad=0.5481 pd=4.36 as=0.5481 ps=4.36 w=1.89 l=0.15
X103 a_665_3648.t1 a_617_3560.t3 VSS.t78 VSS.t77 sky130_fd_pr__nfet_01v8 ad=0.3654 pd=3.1 as=0.3654 ps=3.1 w=1.26 l=0.15
X104 a_617_22124.t2 WLOFF.t16 BLB.t22 VSS.t114 sky130_fd_pr__nfet_01v8 ad=0.174 pd=1.78 as=0.174 ps=1.78 w=0.6 l=0.15
X105 a_665_27516.t0 a_617_27428.t3 VSS.t54 VSS.t53 sky130_fd_pr__nfet_01v8 ad=0.3654 pd=3.1 as=0.3654 ps=3.1 w=1.26 l=0.15
X106 a_665_32820.t2 WLOFF.t25 BL.t29 VSS.t113 sky130_fd_pr__nfet_01v8 ad=0.174 pd=1.78 as=0.174 ps=1.78 w=0.6 l=0.15
X107 a_617_56600.t1 a_665_56688.t4 VDD.t57 VDD.t56 sky130_fd_pr__pfet_01v8 ad=0.1218 pd=1.42 as=0.1218 ps=1.42 w=0.42 l=0.15
X108 a_665_996.t0 a_617_908.t4 VDD.t31 VDD.t30 sky130_fd_pr__pfet_01v8 ad=0.1218 pd=1.42 as=0.1218 ps=1.42 w=0.42 l=0.15
X109 a_617_22124.t0 a_665_22212.t3 VSS.t68 VSS.t67 sky130_fd_pr__nfet_01v8 ad=0.3654 pd=3.1 as=0.3654 ps=3.1 w=1.26 l=0.15
X110 a_665_72600.t1 a_617_72512.t4 VDD.t65 VDD.t64 sky130_fd_pr__pfet_01v8 ad=0.1218 pd=1.42 as=0.1218 ps=1.42 w=0.42 l=0.15
X111 a_617_45992.t0 a_665_46080.t3 VSS.t88 VSS.t87 sky130_fd_pr__nfet_01v8 ad=0.3654 pd=3.1 as=0.3654 ps=3.1 w=1.26 l=0.15
X112 a_617_30080.t1 a_665_30168.t4 VDD.t21 VDD.t20 sky130_fd_pr__pfet_01v8 ad=0.1218 pd=1.42 as=0.1218 ps=1.42 w=0.42 l=0.15
X113 a_665_72600.t0 a_617_72512.t3 VSS.t42 VSS.t41 sky130_fd_pr__nfet_01v8 ad=0.3654 pd=3.1 as=0.3654 ps=3.1 w=1.26 l=0.15
X114 a_665_35472.t2 WLOFF.t27 BL.t14 VSS.t113 sky130_fd_pr__nfet_01v8 ad=0.174 pd=1.78 as=0.174 ps=1.78 w=0.6 l=0.15
X115 a_665_3648.t0 a_617_3560.t4 VDD.t17 VDD.t16 sky130_fd_pr__pfet_01v8 ad=0.1218 pd=1.42 as=0.1218 ps=1.42 w=0.42 l=0.15
X116 a_665_27516.t1 a_617_27428.t4 VDD.t91 VDD.t90 sky130_fd_pr__pfet_01v8 ad=0.1218 pd=1.42 as=0.1218 ps=1.42 w=0.42 l=0.15
X117 a_665_75252.t1 a_617_75164.t4 VDD.t119 VDD.t118 sky130_fd_pr__pfet_01v8 ad=0.1218 pd=1.42 as=0.1218 ps=1.42 w=0.42 l=0.15
X118 a_617_56600.t0 a_665_56688.t3 VSS.t98 VSS.t97 sky130_fd_pr__nfet_01v8 ad=0.3654 pd=3.1 as=0.3654 ps=3.1 w=1.26 l=0.15
X119 a_665_80556.t2 WLOFF.t61 BL.t33 VSS.t113 sky130_fd_pr__nfet_01v8 ad=0.174 pd=1.78 as=0.174 ps=1.78 w=0.6 l=0.15
X120 a_617_69860.t2 WLOFF.t52 BLB.t18 VSS.t114 sky130_fd_pr__nfet_01v8 ad=0.174 pd=1.78 as=0.174 ps=1.78 w=0.6 l=0.15
X121 a_1477_n9274.t0 DATA_B.t1 BL.t26 VDD.t122 sky130_fd_pr__pfet_01v8 ad=1.4616 pd=10.66 as=1.4616 ps=10.66 w=5.04 l=0.15
X122 a_617_16820.t1 a_665_16908.t4 VDD.t35 VDD.t34 sky130_fd_pr__pfet_01v8 ad=0.1218 pd=1.42 as=0.1218 ps=1.42 w=0.42 l=0.15
X123 a_617_8864.t0 a_665_8952.t3 VSS.t16 VSS.t15 sky130_fd_pr__nfet_01v8 ad=0.3654 pd=3.1 as=0.3654 ps=3.1 w=1.26 l=0.15
X124 a_617_30080.t0 a_665_30168.t3 VSS.t28 VSS.t27 sky130_fd_pr__nfet_01v8 ad=0.3654 pd=3.1 as=0.3654 ps=3.1 w=1.26 l=0.15
X125 VDD.t15 sense_amp_scale1p5_flat_0.SA_OUT.t4 sense_amp_scale1p5_flat_0.SA_OUTB.t1 VDD.t14 sky130_fd_pr__pfet_01v8 ad=0.5481 pd=4.36 as=0.5481 ps=4.36 w=1.89 l=0.15
X126 a_665_32820.t0 a_617_32732.t3 VSS.t18 VSS.t17 sky130_fd_pr__nfet_01v8 ad=0.3654 pd=3.1 as=0.3654 ps=3.1 w=1.26 l=0.15
X127 a_665_80556.t0 a_617_80468.t3 VSS.t80 VSS.t79 sky130_fd_pr__nfet_01v8 ad=0.3654 pd=3.1 as=0.3654 ps=3.1 w=1.26 l=0.15
X128 a_665_35472.t1 a_617_35384.t4 VDD.t43 VDD.t42 sky130_fd_pr__pfet_01v8 ad=0.1218 pd=1.42 as=0.1218 ps=1.42 w=0.42 l=0.15
X129 a_617_56600.t2 WLOFF.t42 BLB.t19 VSS.t114 sky130_fd_pr__nfet_01v8 ad=0.174 pd=1.78 as=0.174 ps=1.78 w=0.6 l=0.15
X130 a_665_40776.t2 WLOFF.t31 BL.t19 VSS.t113 sky130_fd_pr__nfet_01v8 ad=0.174 pd=1.78 as=0.174 ps=1.78 w=0.6 l=0.15
X131 a_617_30080.t2 WLOFF.t22 BLB.t5 VSS.t114 sky130_fd_pr__nfet_01v8 ad=0.174 pd=1.78 as=0.174 ps=1.78 w=0.6 l=0.15
X132 a_665_83208.t1 a_617_83120.t3 VSS.t84 VSS.t83 sky130_fd_pr__nfet_01v8 ad=0.3654 pd=3.1 as=0.3654 ps=3.1 w=1.26 l=0.15
X133 a_665_59340.t0 a_617_59252.t3 VSS.t30 VSS.t29 sky130_fd_pr__nfet_01v8 ad=0.3654 pd=3.1 as=0.3654 ps=3.1 w=1.26 l=0.15
X134 a_665_80556.t1 a_617_80468.t4 VDD.t101 VDD.t100 sky130_fd_pr__pfet_01v8 ad=0.1218 pd=1.42 as=0.1218 ps=1.42 w=0.42 l=0.15
X135 a_665_38124.t0 a_617_38036.t4 VDD.t7 VDD.t6 sky130_fd_pr__pfet_01v8 ad=0.1218 pd=1.42 as=0.1218 ps=1.42 w=0.42 l=0.15
X136 a_617_59252.t2 WLOFF.t44 BLB.t0 VSS.t114 sky130_fd_pr__nfet_01v8 ad=0.174 pd=1.78 as=0.174 ps=1.78 w=0.6 l=0.15
X137 a_617_61904.t0 a_665_61992.t3 VSS.t52 VSS.t51 sky130_fd_pr__nfet_01v8 ad=0.3654 pd=3.1 as=0.3654 ps=3.1 w=1.26 l=0.15
X138 a_665_40776.t1 a_617_40688.t3 VSS.t90 VSS.t89 sky130_fd_pr__nfet_01v8 ad=0.3654 pd=3.1 as=0.3654 ps=3.1 w=1.26 l=0.15
X139 a_665_67296.t2 WLOFF.t51 BL.t24 VSS.t113 sky130_fd_pr__nfet_01v8 ad=0.174 pd=1.78 as=0.174 ps=1.78 w=0.6 l=0.15
X140 a_665_69948.t1 a_617_69860.t3 VSS.t58 VSS.t57 sky130_fd_pr__nfet_01v8 ad=0.3654 pd=3.1 as=0.3654 ps=3.1 w=1.26 l=0.15
X141 a_617_16820.t2 WLOFF.t12 BLB.t27 VSS.t114 sky130_fd_pr__nfet_01v8 ad=0.174 pd=1.78 as=0.174 ps=1.78 w=0.6 l=0.15
X142 a_3465_n13274.t0 DATA.t0 BLB.t34 VSS.t133 sky130_fd_pr__nfet_01v8 ad=1.4616 pd=10.66 as=1.4616 ps=10.66 w=5.04 l=0.15
X143 a_617_64556.t0 a_665_64644.t3 VSS.t38 VSS.t37 sky130_fd_pr__nfet_01v8 ad=0.3654 pd=3.1 as=0.3654 ps=3.1 w=1.26 l=0.15
X144 a_665_43428.t1 a_617_43340.t3 VSS.t94 VSS.t93 sky130_fd_pr__nfet_01v8 ad=0.3654 pd=3.1 as=0.3654 ps=3.1 w=1.26 l=0.15
X145 a_665_19560.t2 a_617_19472.t3 VSS.t126 VSS.t125 sky130_fd_pr__nfet_01v8 ad=0.3654 pd=3.1 as=0.3654 ps=3.1 w=1.26 l=0.15
X146 a_617_72512.t1 a_665_72600.t4 VDD.t47 VDD.t46 sky130_fd_pr__pfet_01v8 ad=0.1218 pd=1.42 as=0.1218 ps=1.42 w=0.42 l=0.15
X147 a_665_67296.t0 a_617_67208.t3 VSS.t10 VSS.t9 sky130_fd_pr__nfet_01v8 ad=0.3654 pd=3.1 as=0.3654 ps=3.1 w=1.26 l=0.15
X148 a_665_40776.t0 a_617_40688.t4 VDD.t107 VDD.t106 sky130_fd_pr__pfet_01v8 ad=0.1218 pd=1.42 as=0.1218 ps=1.42 w=0.42 l=0.15
X149 a_665_996.t1 a_617_908.t3 VSS.t44 VSS.t43 sky130_fd_pr__nfet_01v8 ad=0.3654 pd=3.1 as=0.3654 ps=3.1 w=1.26 l=0.15
X150 a_617_3560.t0 WLOFF.t2 BLB.t32 VSS.t114 sky130_fd_pr__nfet_01v8 ad=0.174 pd=1.78 as=0.174 ps=1.78 w=0.6 l=0.15
X151 a_617_19472.t2 WLOFF.t14 BLB.t30 VSS.t114 sky130_fd_pr__nfet_01v8 ad=0.174 pd=1.78 as=0.174 ps=1.78 w=0.6 l=0.15
X152 a_617_908.t2 WLOFF.t0 BLB.t28 VSS.t114 sky130_fd_pr__nfet_01v8 ad=0.174 pd=1.78 as=0.174 ps=1.78 w=0.6 l=0.15
X153 a_665_27516.t2 WLOFF.t21 BL.t5 VSS.t113 sky130_fd_pr__nfet_01v8 ad=0.174 pd=1.78 as=0.174 ps=1.78 w=0.6 l=0.15
X154 a_617_27428.t1 a_665_27516.t4 VDD.t39 VDD.t38 sky130_fd_pr__pfet_01v8 ad=0.1218 pd=1.42 as=0.1218 ps=1.42 w=0.42 l=0.15
X155 a_617_75164.t1 a_665_75252.t4 VDD.t27 VDD.t26 sky130_fd_pr__pfet_01v8 ad=0.1218 pd=1.42 as=0.1218 ps=1.42 w=0.42 l=0.15
X156 a_665_43428.t0 a_617_43340.t4 VDD.t111 VDD.t110 sky130_fd_pr__pfet_01v8 ad=0.1218 pd=1.42 as=0.1218 ps=1.42 w=0.42 l=0.15
X157 VDD.t75 a_677_n8854.t2 a_3077_n9274.t0 VDD.t74 sky130_fd_pr__pfet_01v8 ad=1.4616 pd=10.66 as=1.4616 ps=10.66 w=5.04 l=0.15
X158 a_665_67296.t1 a_617_67208.t4 VDD.t29 VDD.t28 sky130_fd_pr__pfet_01v8 ad=0.1218 pd=1.42 as=0.1218 ps=1.42 w=0.42 l=0.15
X159 a_617_64556.t2 WLOFF.t48 BLB.t14 VSS.t114 sky130_fd_pr__nfet_01v8 ad=0.174 pd=1.78 as=0.174 ps=1.78 w=0.6 l=0.15
X160 a_617_24776.t0 a_665_24864.t3 VSS.t70 VSS.t69 sky130_fd_pr__nfet_01v8 ad=0.3654 pd=3.1 as=0.3654 ps=3.1 w=1.26 l=0.15
X161 a_665_77904.t0 a_617_77816.t4 VDD.t83 VDD.t82 sky130_fd_pr__pfet_01v8 ad=0.1218 pd=1.42 as=0.1218 ps=1.42 w=0.42 l=0.15
X162 a_617_27428.t0 a_665_27516.t3 VSS.t96 VSS.t95 sky130_fd_pr__nfet_01v8 ad=0.3654 pd=3.1 as=0.3654 ps=3.1 w=1.26 l=0.15
X163 a_617_35384.t1 a_665_35472.t4 VDD.t41 VDD.t40 sky130_fd_pr__pfet_01v8 ad=0.1218 pd=1.42 as=0.1218 ps=1.42 w=0.42 l=0.15
X164 sense_amp_scale1p5_flat_0.SA_OUT.t1 SCLK.t2 BL.t27 VDD.t129 sky130_fd_pr__pfet_01v8 ad=0.58 pd=4.58 as=0.58 ps=4.58 w=2 l=0.15
X165 a_665_77904.t1 a_617_77816.t3 VSS.t74 VSS.t73 sky130_fd_pr__nfet_01v8 ad=0.3654 pd=3.1 as=0.3654 ps=3.1 w=1.26 l=0.15
X166 a_665_51384.t1 a_617_51296.t4 VDD.t128 VDD.t127 sky130_fd_pr__pfet_01v8 ad=0.1218 pd=1.42 as=0.1218 ps=1.42 w=0.42 l=0.15
X167 a_617_908.t1 a_665_996.t4 VDD.t3 VDD.t2 sky130_fd_pr__pfet_01v8 ad=0.1218 pd=1.42 as=0.1218 ps=1.42 w=0.42 l=0.15
X168 a_617_24776.t2 WLOFF.t18 BLB.t8 VSS.t114 sky130_fd_pr__nfet_01v8 ad=0.174 pd=1.78 as=0.174 ps=1.78 w=0.6 l=0.15
X169 a_617_72512.t2 WLOFF.t54 BLB.t23 VSS.t114 sky130_fd_pr__nfet_01v8 ad=0.174 pd=1.78 as=0.174 ps=1.78 w=0.6 l=0.15
X170 a_617_72512.t0 a_665_72600.t3 VSS.t32 VSS.t31 sky130_fd_pr__nfet_01v8 ad=0.3654 pd=3.1 as=0.3654 ps=3.1 w=1.26 l=0.15
X171 a_665_8952.t0 a_617_8864.t4 VDD.t13 VDD.t12 sky130_fd_pr__pfet_01v8 ad=0.1218 pd=1.42 as=0.1218 ps=1.42 w=0.42 l=0.15
X172 a_617_80468.t1 a_665_80556.t4 VDD.t85 VDD.t84 sky130_fd_pr__pfet_01v8 ad=0.1218 pd=1.42 as=0.1218 ps=1.42 w=0.42 l=0.15
X173 a_665_75252.t0 a_617_75164.t3 VSS.t104 VSS.t103 sky130_fd_pr__nfet_01v8 ad=0.3654 pd=3.1 as=0.3654 ps=3.1 w=1.26 l=0.15
X174 a_617_38036.t1 a_665_38124.t4 VDD.t89 VDD.t88 sky130_fd_pr__pfet_01v8 ad=0.1218 pd=1.42 as=0.1218 ps=1.42 w=0.42 l=0.15
X175 a_665_3648.t2 WLOFF.t3 BL.t23 VSS.t113 sky130_fd_pr__nfet_01v8 ad=0.174 pd=1.78 as=0.174 ps=1.78 w=0.6 l=0.15
X176 a_617_3560.t2 a_665_3648.t4 VDD.t71 VDD.t70 sky130_fd_pr__pfet_01v8 ad=0.1218 pd=1.42 as=0.1218 ps=1.42 w=0.42 l=0.15
X177 a_665_6300.t1 a_617_6212.t4 VDD.t9 VDD.t8 sky130_fd_pr__pfet_01v8 ad=0.1218 pd=1.42 as=0.1218 ps=1.42 w=0.42 l=0.15
X178 a_617_75164.t2 WLOFF.t56 BLB.t2 VSS.t114 sky130_fd_pr__nfet_01v8 ad=0.174 pd=1.78 as=0.174 ps=1.78 w=0.6 l=0.15
X179 a_1065_n6268.t2 sense_amp_scale1p5_flat_0.SA_OUTB.t3 sense_amp_scale1p5_flat_0.SA_OUT.t2 VSS.t120 sky130_fd_pr__nfet_01v8 ad=0.2842 pd=2.54 as=0.2842 ps=2.54 w=0.98 l=0.15
X180 a_665_996.t2 WLOFF.t1 BL.t2 VSS.t113 sky130_fd_pr__nfet_01v8 ad=0.174 pd=1.78 as=0.174 ps=1.78 w=0.6 l=0.15
X181 a_665_83208.t2 WLOFF.t63 BL.t18 VSS.t113 sky130_fd_pr__nfet_01v8 ad=0.174 pd=1.78 as=0.174 ps=1.78 w=0.6 l=0.15
X182 a_665_6300.t0 a_617_6212.t3 VSS.t1 VSS.t0 sky130_fd_pr__nfet_01v8 ad=0.3654 pd=3.1 as=0.3654 ps=3.1 w=1.26 l=0.15
X183 a_665_11604.t1 a_617_11516.t4 VDD.t59 VDD.t58 sky130_fd_pr__pfet_01v8 ad=0.1218 pd=1.42 as=0.1218 ps=1.42 w=0.42 l=0.15
X184 a_617_32732.t2 WLOFF.t24 BLB.t16 VSS.t114 sky130_fd_pr__nfet_01v8 ad=0.174 pd=1.78 as=0.174 ps=1.78 w=0.6 l=0.15
X185 a_665_11604.t0 a_617_11516.t3 VSS.t46 VSS.t45 sky130_fd_pr__nfet_01v8 ad=0.3654 pd=3.1 as=0.3654 ps=3.1 w=1.26 l=0.15
X186 a_617_32732.t0 a_665_32820.t3 VSS.t14 VSS.t13 sky130_fd_pr__nfet_01v8 ad=0.3654 pd=3.1 as=0.3654 ps=3.1 w=1.26 l=0.15
X187 a_617_80468.t0 a_665_80556.t3 VSS.t76 VSS.t75 sky130_fd_pr__nfet_01v8 ad=0.3654 pd=3.1 as=0.3654 ps=3.1 w=1.26 l=0.15
X188 a_617_40688.t1 a_665_40776.t4 VDD.t99 VDD.t98 sky130_fd_pr__pfet_01v8 ad=0.1218 pd=1.42 as=0.1218 ps=1.42 w=0.42 l=0.15
X189 a_665_35472.t0 a_617_35384.t3 VSS.t20 VSS.t19 sky130_fd_pr__nfet_01v8 ad=0.3654 pd=3.1 as=0.3654 ps=3.1 w=1.26 l=0.15
X190 a_617_35384.t2 WLOFF.t26 BLB.t10 VSS.t114 sky130_fd_pr__nfet_01v8 ad=0.174 pd=1.78 as=0.174 ps=1.78 w=0.6 l=0.15
X191 a_617_83120.t0 a_665_83208.t3 VSS.t82 VSS.t81 sky130_fd_pr__nfet_01v8 ad=0.3654 pd=3.1 as=0.3654 ps=3.1 w=1.26 l=0.15
X192 a_617_59252.t0 a_665_59340.t3 VSS.t62 VSS.t61 sky130_fd_pr__nfet_01v8 ad=0.3654 pd=3.1 as=0.3654 ps=3.1 w=1.26 l=0.15
X193 a_617_43340.t1 a_665_43428.t4 VDD.t105 VDD.t104 sky130_fd_pr__pfet_01v8 ad=0.1218 pd=1.42 as=0.1218 ps=1.42 w=0.42 l=0.15
X194 a_665_43428.t2 WLOFF.t33 BL.t28 VSS.t113 sky130_fd_pr__nfet_01v8 ad=0.174 pd=1.78 as=0.174 ps=1.78 w=0.6 l=0.15
X195 a_665_38124.t1 a_617_38036.t3 VSS.t8 VSS.t7 sky130_fd_pr__nfet_01v8 ad=0.3654 pd=3.1 as=0.3654 ps=3.1 w=1.26 l=0.15
X196 a_617_67208.t1 a_665_67296.t4 VDD.t138 VDD.t137 sky130_fd_pr__pfet_01v8 ad=0.1218 pd=1.42 as=0.1218 ps=1.42 w=0.42 l=0.15
X197 a_665_59340.t1 a_617_59252.t4 VDD.t117 VDD.t116 sky130_fd_pr__pfet_01v8 ad=0.1218 pd=1.42 as=0.1218 ps=1.42 w=0.42 l=0.15
X198 a_665_83208.t0 a_617_83120.t4 VDD.t79 VDD.t78 sky130_fd_pr__pfet_01v8 ad=0.1218 pd=1.42 as=0.1218 ps=1.42 w=0.42 l=0.15
X199 a_617_80468.t2 WLOFF.t60 BLB.t3 VSS.t114 sky130_fd_pr__nfet_01v8 ad=0.174 pd=1.78 as=0.174 ps=1.78 w=0.6 l=0.15
X200 a_617_40688.t0 a_665_40776.t3 VSS.t64 VSS.t63 sky130_fd_pr__nfet_01v8 ad=0.3654 pd=3.1 as=0.3654 ps=3.1 w=1.26 l=0.15
X201 VDD.t145 PRECH.t2 BL.t35 VDD.t144 sky130_fd_pr__pfet_01v8 ad=0.7308 pd=5.62 as=0.7308 ps=5.62 w=2.52 l=0.15
X202 a_665_46080.t2 WLOFF.t35 BL.t13 VSS.t113 sky130_fd_pr__nfet_01v8 ad=0.174 pd=1.78 as=0.174 ps=1.78 w=0.6 l=0.15
X203 VSS.t141 WE.t0 a_3465_n13274.t1 VSS.t140 sky130_fd_pr__nfet_01v8 ad=1.4616 pd=10.66 as=1.4616 ps=10.66 w=5.04 l=0.15
X204 a_617_69860.t0 a_665_69948.t3 VSS.t130 VSS.t129 sky130_fd_pr__nfet_01v8 ad=0.3654 pd=3.1 as=0.3654 ps=3.1 w=1.26 l=0.15
X205 BLB.t21 SCLK.t1 sense_amp_scale1p5_flat_0.SA_OUTB.t2 VDD.t130 sky130_fd_pr__pfet_01v8 ad=0.58 pd=4.58 as=0.58 ps=4.58 w=2 l=0.15
X206 a_617_77816.t1 a_665_77904.t4 VDD.t81 VDD.t80 sky130_fd_pr__pfet_01v8 ad=0.1218 pd=1.42 as=0.1218 ps=1.42 w=0.42 l=0.15
X207 a_617_43340.t0 a_665_43428.t3 VSS.t106 VSS.t105 sky130_fd_pr__nfet_01v8 ad=0.3654 pd=3.1 as=0.3654 ps=3.1 w=1.26 l=0.15
X208 a_617_19472.t0 a_665_19560.t3 VSS.t26 VSS.t25 sky130_fd_pr__nfet_01v8 ad=0.3654 pd=3.1 as=0.3654 ps=3.1 w=1.26 l=0.15
X209 a_617_67208.t0 a_665_67296.t3 VSS.t86 VSS.t85 sky130_fd_pr__nfet_01v8 ad=0.3654 pd=3.1 as=0.3654 ps=3.1 w=1.26 l=0.15
X210 a_617_51296.t1 a_665_51384.t4 VDD.t126 VDD.t125 sky130_fd_pr__pfet_01v8 ad=0.1218 pd=1.42 as=0.1218 ps=1.42 w=0.42 l=0.15
X211 a_665_19560.t0 a_617_19472.t4 VDD.t25 VDD.t24 sky130_fd_pr__pfet_01v8 ad=0.1218 pd=1.42 as=0.1218 ps=1.42 w=0.42 l=0.15
C0 BL sense_amp_scale1p5_flat_0.SA_OUTB 0.01272f
C1 SCLK BL 0.40546f
C2 BLB VDD 63.7485f
C3 VDD sense_amp_scale1p5_flat_0.SA_OUT 1.64084f
C4 DATA_B VDD 0.57634f
C5 WE VDD 1.19893f
C6 PRECH BLB 0.26536f
C7 BLB BL 98.489f
C8 BL sense_amp_scale1p5_flat_0.SA_OUT 0.33863f
C9 DATA_B BL 1.88803f
C10 WE BL 0.78144f
C11 SCLK sense_amp_scale1p5_flat_0.SA_OUTB 1.57418f
C12 DATA VDD 0.52855f
C13 BLB WLOFF 10.5653f
C14 DATA BL 2.72162f
C15 BLB sense_amp_scale1p5_flat_0.SA_OUTB 0.43591f
C16 sense_amp_scale1p5_flat_0.SA_OUTB sense_amp_scale1p5_flat_0.SA_OUT 2.66016f
C17 SCLK BLB 0.47605f
C18 SCLK sense_amp_scale1p5_flat_0.SA_OUT 1.49829f
C19 PRECH VDD 3.33538f
C20 BL VDD 9.26963f
C21 BLB sense_amp_scale1p5_flat_0.SA_OUT 0.23119f
C22 DATA_B BLB 0.17241f
C23 WE BLB 0.35986f
C24 WE DATA_B 0.6312f
C25 PRECH BL 0.50541f
C26 VDD WLOFF 29.4358f
C27 PRECH WLOFF 0
C28 BL WLOFF 65.4669f
C29 BLB DATA 1.35016f
C30 VDD sense_amp_scale1p5_flat_0.SA_OUTB 1.62972f
C31 DATA_B DATA 2.64476f
C32 SCLK VDD 0.83308f
C33 WE DATA 0.29298f
R0 DATA.n0 DATA.t1 1056.08
R1 DATA.n0 DATA.t0 1043.98
R2 DATA.n1 DATA 3.42519
R3 DATA DATA.n1 1.11899
R4 DATA.n1 DATA.n0 0.332857
R5 DATA_B.n0 DATA_B.t1 1055.43
R6 DATA_B.n1 DATA_B.t0 1042.99
R7 DATA_B.n0 DATA_B 3.42519
R8 DATA_B DATA_B.n1 0.758655
R9 DATA_B.n1 DATA_B.n0 0.220952
R10 WE.n0 WE.t0 1044.61
R11 WE.n0 WE.t1 1044.31
R12 WE.n3 WE.t3 379.339
R13 WE.n2 WE.t2 368.916
R14 WE.n1 WE 3.42519
R15 WE WE.n3 0.311036
R16 WE.n3 WE.n2 0.280262
R17 WE.n2 WE.n1 0.248929
R18 WE.n1 WE.n0 0.220952
R19 SCLK.n0 SCLK.t1 567.159
R20 SCLK.n1 SCLK.t2 566.852
R21 SCLK.n0 SCLK.t0 387.618
R22 SCLK.n2 SCLK 3.42519
R23 SCLK SCLK.n2 0.839226
R24 SCLK.n2 SCLK.n1 0.360833
R25 SCLK.n1 SCLK.n0 0.140381
R26 PRECH.n0 PRECH.t0 648.631
R27 PRECH.n2 PRECH.t2 648.271
R28 PRECH.n1 PRECH.t1 648.271
R29 PRECH.n0 PRECH 3.42519
R30 PRECH.n2 PRECH.n1 0.448119
R31 PRECH PRECH.n2 0.311036
R32 PRECH.n1 PRECH.n0 0.0810714
R33 BLB.n1 BLB.t13 233.731
R34 BLB.n3 BLB.t3 233.731
R35 BLB.n5 BLB.t6 233.731
R36 BLB.n7 BLB.t2 233.731
R37 BLB.n9 BLB.t23 233.731
R38 BLB.n11 BLB.t18 233.731
R39 BLB.n13 BLB.t7 233.731
R40 BLB.n15 BLB.t14 233.731
R41 BLB.n17 BLB.t20 233.731
R42 BLB.n19 BLB.t0 233.731
R43 BLB.n21 BLB.t19 233.731
R44 BLB.n23 BLB.t4 233.731
R45 BLB.n25 BLB.t15 233.731
R46 BLB.n27 BLB.t24 233.731
R47 BLB.n29 BLB.t9 233.731
R48 BLB.n31 BLB.t1 233.731
R49 BLB.n33 BLB.t29 233.731
R50 BLB.n35 BLB.t25 233.731
R51 BLB.n37 BLB.t10 233.731
R52 BLB.n39 BLB.t16 233.731
R53 BLB.n41 BLB.t5 233.731
R54 BLB.n43 BLB.t26 233.731
R55 BLB.n45 BLB.t8 233.731
R56 BLB.n47 BLB.t22 233.731
R57 BLB.n49 BLB.t30 233.731
R58 BLB.n51 BLB.t27 233.731
R59 BLB.n53 BLB.t11 233.731
R60 BLB.n55 BLB.t17 233.731
R61 BLB.n57 BLB.t31 233.731
R62 BLB.n59 BLB.t12 233.731
R63 BLB.n61 BLB.t32 233.731
R64 BLB.n63 BLB.t28 233.731
R65 BLB.n68 BLB.t21 123.787
R66 BLB.n65 BLB.t35 105.877
R67 BLB.n65 BLB.t36 105.281
R68 BLB.n0 BLB.t33 58.6317
R69 BLB.n0 BLB.t34 29.2021
R70 BLB.n70 BLB.n69 7.1517
R71 BLB.n69 BLB.n68 3.4105
R72 BLB.n67 BLB.n66 3.4105
R73 BLB.n64 BLB.n63 3.4105
R74 BLB.n62 BLB.n61 3.4105
R75 BLB.n60 BLB.n59 3.4105
R76 BLB.n58 BLB.n57 3.4105
R77 BLB.n56 BLB.n55 3.4105
R78 BLB.n54 BLB.n53 3.4105
R79 BLB.n52 BLB.n51 3.4105
R80 BLB.n50 BLB.n49 3.4105
R81 BLB.n48 BLB.n47 3.4105
R82 BLB.n46 BLB.n45 3.4105
R83 BLB.n44 BLB.n43 3.4105
R84 BLB.n42 BLB.n41 3.4105
R85 BLB.n40 BLB.n39 3.4105
R86 BLB.n38 BLB.n37 3.4105
R87 BLB.n36 BLB.n35 3.4105
R88 BLB.n34 BLB.n33 3.4105
R89 BLB.n32 BLB.n31 3.4105
R90 BLB.n30 BLB.n29 3.4105
R91 BLB.n28 BLB.n27 3.4105
R92 BLB.n26 BLB.n25 3.4105
R93 BLB.n24 BLB.n23 3.4105
R94 BLB.n22 BLB.n21 3.4105
R95 BLB.n20 BLB.n19 3.4105
R96 BLB.n18 BLB.n17 3.4105
R97 BLB.n16 BLB.n15 3.4105
R98 BLB.n14 BLB.n13 3.4105
R99 BLB.n12 BLB.n11 3.4105
R100 BLB.n10 BLB.n9 3.4105
R101 BLB.n8 BLB.n7 3.4105
R102 BLB.n6 BLB.n5 3.4105
R103 BLB.n4 BLB.n3 3.4105
R104 BLB.n2 BLB.n1 3.4105
R105 BLB.n70 BLB.n0 1.56269
R106 BLB.n64 BLB.n62 1.54915
R107 BLB.n62 BLB.n60 1.54915
R108 BLB.n60 BLB.n58 1.54915
R109 BLB.n58 BLB.n56 1.54915
R110 BLB.n56 BLB.n54 1.54915
R111 BLB.n54 BLB.n52 1.54915
R112 BLB.n52 BLB.n50 1.54915
R113 BLB.n50 BLB.n48 1.54915
R114 BLB.n48 BLB.n46 1.54915
R115 BLB.n46 BLB.n44 1.54915
R116 BLB.n44 BLB.n42 1.54915
R117 BLB.n42 BLB.n40 1.54915
R118 BLB.n40 BLB.n38 1.54915
R119 BLB.n38 BLB.n36 1.54915
R120 BLB.n36 BLB.n34 1.54915
R121 BLB.n34 BLB.n32 1.54915
R122 BLB.n32 BLB.n30 1.54915
R123 BLB.n30 BLB.n28 1.54915
R124 BLB.n28 BLB.n26 1.54915
R125 BLB.n26 BLB.n24 1.54915
R126 BLB.n24 BLB.n22 1.54915
R127 BLB.n22 BLB.n20 1.54915
R128 BLB.n20 BLB.n18 1.54915
R129 BLB.n18 BLB.n16 1.54915
R130 BLB.n16 BLB.n14 1.54915
R131 BLB.n14 BLB.n12 1.54915
R132 BLB.n12 BLB.n10 1.54915
R133 BLB.n10 BLB.n8 1.54915
R134 BLB.n8 BLB.n6 1.54915
R135 BLB.n6 BLB.n4 1.54915
R136 BLB.n4 BLB.n2 1.54915
R137 BLB.n2 BLB 1.53505
R138 BLB.n67 BLB.n64 1.2507
R139 BLB.n69 BLB.n67 1.03332
R140 BLB.n66 BLB.n65 0.499595
R141 BLB.n1 BLB 0.178988
R142 BLB.n3 BLB 0.178988
R143 BLB.n5 BLB 0.178988
R144 BLB.n7 BLB 0.178988
R145 BLB.n9 BLB 0.178988
R146 BLB.n11 BLB 0.178988
R147 BLB.n13 BLB 0.178988
R148 BLB.n15 BLB 0.178988
R149 BLB.n17 BLB 0.178988
R150 BLB.n19 BLB 0.178988
R151 BLB.n21 BLB 0.178988
R152 BLB.n23 BLB 0.178988
R153 BLB.n25 BLB 0.178988
R154 BLB.n27 BLB 0.178988
R155 BLB.n29 BLB 0.178988
R156 BLB.n31 BLB 0.178988
R157 BLB.n33 BLB 0.178988
R158 BLB.n35 BLB 0.178988
R159 BLB.n37 BLB 0.178988
R160 BLB.n39 BLB 0.178988
R161 BLB.n41 BLB 0.178988
R162 BLB.n43 BLB 0.178988
R163 BLB.n45 BLB 0.178988
R164 BLB.n47 BLB 0.178988
R165 BLB.n49 BLB 0.178988
R166 BLB.n51 BLB 0.178988
R167 BLB.n53 BLB 0.178988
R168 BLB.n55 BLB 0.178988
R169 BLB.n57 BLB 0.178988
R170 BLB.n59 BLB 0.178988
R171 BLB.n61 BLB 0.178988
R172 BLB.n63 BLB 0.178988
R173 BLB.n66 BLB 0.178988
R174 BLB.n68 BLB 0.178988
R175 BLB BLB.n70 0.178988
R176 BL.n1 BL.t18 233.578
R177 BL.n3 BL.t33 233.578
R178 BL.n5 BL.t9 233.578
R179 BL.n7 BL.t34 233.578
R180 BL.n9 BL.t31 233.578
R181 BL.n11 BL.t15 233.578
R182 BL.n13 BL.t24 233.578
R183 BL.n15 BL.t3 233.578
R184 BL.n17 BL.t12 233.578
R185 BL.n19 BL.t22 233.578
R186 BL.n21 BL.t0 233.578
R187 BL.n23 BL.t21 233.578
R188 BL.n25 BL.t20 233.578
R189 BL.n27 BL.t1 233.578
R190 BL.n29 BL.t13 233.578
R191 BL.n31 BL.t28 233.578
R192 BL.n33 BL.t19 233.578
R193 BL.n35 BL.t32 233.578
R194 BL.n37 BL.t14 233.578
R195 BL.n39 BL.t29 233.578
R196 BL.n41 BL.t6 233.578
R197 BL.n43 BL.t5 233.578
R198 BL.n45 BL.t10 233.578
R199 BL.n47 BL.t16 233.578
R200 BL.n49 BL.t7 233.578
R201 BL.n51 BL.t17 233.578
R202 BL.n53 BL.t11 233.578
R203 BL.n55 BL.t30 233.578
R204 BL.n57 BL.t8 233.578
R205 BL.n59 BL.t4 233.578
R206 BL.n61 BL.t23 233.578
R207 BL.n63 BL.t2 233.578
R208 BL.n68 BL.t27 123.582
R209 BL.n65 BL.t36 105.954
R210 BL.n65 BL.t35 105.058
R211 BL.n0 BL.t26 58.4085
R212 BL.n0 BL.t25 29.4254
R213 BL.n70 BL.n69 7.1517
R214 BL.n69 BL.n68 3.4105
R215 BL.n67 BL.n66 3.4105
R216 BL.n64 BL.n63 3.4105
R217 BL.n62 BL.n61 3.4105
R218 BL.n60 BL.n59 3.4105
R219 BL.n58 BL.n57 3.4105
R220 BL.n56 BL.n55 3.4105
R221 BL.n54 BL.n53 3.4105
R222 BL.n52 BL.n51 3.4105
R223 BL.n50 BL.n49 3.4105
R224 BL.n48 BL.n47 3.4105
R225 BL.n46 BL.n45 3.4105
R226 BL.n44 BL.n43 3.4105
R227 BL.n42 BL.n41 3.4105
R228 BL.n40 BL.n39 3.4105
R229 BL.n38 BL.n37 3.4105
R230 BL.n36 BL.n35 3.4105
R231 BL.n34 BL.n33 3.4105
R232 BL.n32 BL.n31 3.4105
R233 BL.n30 BL.n29 3.4105
R234 BL.n28 BL.n27 3.4105
R235 BL.n26 BL.n25 3.4105
R236 BL.n24 BL.n23 3.4105
R237 BL.n22 BL.n21 3.4105
R238 BL.n20 BL.n19 3.4105
R239 BL.n18 BL.n17 3.4105
R240 BL.n16 BL.n15 3.4105
R241 BL.n14 BL.n13 3.4105
R242 BL.n12 BL.n11 3.4105
R243 BL.n10 BL.n9 3.4105
R244 BL.n8 BL.n7 3.4105
R245 BL.n6 BL.n5 3.4105
R246 BL.n4 BL.n3 3.4105
R247 BL.n2 BL.n1 3.4105
R248 BL.n64 BL.n62 1.54915
R249 BL.n62 BL.n60 1.54915
R250 BL.n60 BL.n58 1.54915
R251 BL.n58 BL.n56 1.54915
R252 BL.n56 BL.n54 1.54915
R253 BL.n54 BL.n52 1.54915
R254 BL.n52 BL.n50 1.54915
R255 BL.n50 BL.n48 1.54915
R256 BL.n48 BL.n46 1.54915
R257 BL.n46 BL.n44 1.54915
R258 BL.n44 BL.n42 1.54915
R259 BL.n42 BL.n40 1.54915
R260 BL.n40 BL.n38 1.54915
R261 BL.n38 BL.n36 1.54915
R262 BL.n36 BL.n34 1.54915
R263 BL.n34 BL.n32 1.54915
R264 BL.n32 BL.n30 1.54915
R265 BL.n30 BL.n28 1.54915
R266 BL.n28 BL.n26 1.54915
R267 BL.n26 BL.n24 1.54915
R268 BL.n24 BL.n22 1.54915
R269 BL.n22 BL.n20 1.54915
R270 BL.n20 BL.n18 1.54915
R271 BL.n18 BL.n16 1.54915
R272 BL.n16 BL.n14 1.54915
R273 BL.n14 BL.n12 1.54915
R274 BL.n12 BL.n10 1.54915
R275 BL.n10 BL.n8 1.54915
R276 BL.n8 BL.n6 1.54915
R277 BL.n6 BL.n4 1.54915
R278 BL.n4 BL.n2 1.54915
R279 BL.n2 BL 1.44693
R280 BL.n67 BL.n64 1.2507
R281 BL.n69 BL.n67 1.03332
R282 BL.n70 BL.n0 0.835309
R283 BL.n66 BL.n65 0.219833
R284 BL.n1 BL 0.0127396
R285 BL.n3 BL 0.0127396
R286 BL.n5 BL 0.0127396
R287 BL.n7 BL 0.0127396
R288 BL.n9 BL 0.0127396
R289 BL.n11 BL 0.0127396
R290 BL.n13 BL 0.0127396
R291 BL.n15 BL 0.0127396
R292 BL.n17 BL 0.0127396
R293 BL.n19 BL 0.0127396
R294 BL.n21 BL 0.0127396
R295 BL.n23 BL 0.0127396
R296 BL.n25 BL 0.0127396
R297 BL.n27 BL 0.0127396
R298 BL.n29 BL 0.0127396
R299 BL.n31 BL 0.0127396
R300 BL.n33 BL 0.0127396
R301 BL.n35 BL 0.0127396
R302 BL.n37 BL 0.0127396
R303 BL.n39 BL 0.0127396
R304 BL.n41 BL 0.0127396
R305 BL.n43 BL 0.0127396
R306 BL.n45 BL 0.0127396
R307 BL.n47 BL 0.0127396
R308 BL.n49 BL 0.0127396
R309 BL.n51 BL 0.0127396
R310 BL.n53 BL 0.0127396
R311 BL.n55 BL 0.0127396
R312 BL.n57 BL 0.0127396
R313 BL.n59 BL 0.0127396
R314 BL.n61 BL 0.0127396
R315 BL.n63 BL 0.0127396
R316 BL.n66 BL 0.0127396
R317 BL.n68 BL 0.0127396
R318 BL BL.n70 0.0127396
R319 WLOFF.n1 WLOFF.t63 319.156
R320 WLOFF.n4 WLOFF.t61 319.156
R321 WLOFF.n7 WLOFF.t59 319.156
R322 WLOFF.n10 WLOFF.t57 319.156
R323 WLOFF.n13 WLOFF.t55 319.156
R324 WLOFF.n16 WLOFF.t53 319.156
R325 WLOFF.n19 WLOFF.t51 319.156
R326 WLOFF.n22 WLOFF.t49 319.156
R327 WLOFF.n25 WLOFF.t47 319.156
R328 WLOFF.n28 WLOFF.t45 319.156
R329 WLOFF.n31 WLOFF.t43 319.156
R330 WLOFF.n34 WLOFF.t41 319.156
R331 WLOFF.n37 WLOFF.t39 319.156
R332 WLOFF.n40 WLOFF.t37 319.156
R333 WLOFF.n43 WLOFF.t35 319.156
R334 WLOFF.n46 WLOFF.t33 319.156
R335 WLOFF.n49 WLOFF.t31 319.156
R336 WLOFF.n52 WLOFF.t29 319.156
R337 WLOFF.n55 WLOFF.t27 319.156
R338 WLOFF.n58 WLOFF.t25 319.156
R339 WLOFF.n61 WLOFF.t23 319.156
R340 WLOFF.n64 WLOFF.t21 319.156
R341 WLOFF.n67 WLOFF.t19 319.156
R342 WLOFF.n70 WLOFF.t17 319.156
R343 WLOFF.n73 WLOFF.t15 319.156
R344 WLOFF.n76 WLOFF.t13 319.156
R345 WLOFF.n79 WLOFF.t11 319.156
R346 WLOFF.n82 WLOFF.t9 319.156
R347 WLOFF.n85 WLOFF.t7 319.156
R348 WLOFF.n88 WLOFF.t5 319.156
R349 WLOFF.n91 WLOFF.t3 319.156
R350 WLOFF.n0 WLOFF.t1 319.156
R351 WLOFF.n1 WLOFF.t62 317.147
R352 WLOFF.n4 WLOFF.t60 317.147
R353 WLOFF.n7 WLOFF.t58 317.147
R354 WLOFF.n10 WLOFF.t56 317.147
R355 WLOFF.n13 WLOFF.t54 317.147
R356 WLOFF.n16 WLOFF.t52 317.147
R357 WLOFF.n19 WLOFF.t50 317.147
R358 WLOFF.n22 WLOFF.t48 317.147
R359 WLOFF.n25 WLOFF.t46 317.147
R360 WLOFF.n28 WLOFF.t44 317.147
R361 WLOFF.n31 WLOFF.t42 317.147
R362 WLOFF.n34 WLOFF.t40 317.147
R363 WLOFF.n37 WLOFF.t38 317.147
R364 WLOFF.n40 WLOFF.t36 317.147
R365 WLOFF.n43 WLOFF.t34 317.147
R366 WLOFF.n46 WLOFF.t32 317.147
R367 WLOFF.n49 WLOFF.t30 317.147
R368 WLOFF.n52 WLOFF.t28 317.147
R369 WLOFF.n55 WLOFF.t26 317.147
R370 WLOFF.n58 WLOFF.t24 317.147
R371 WLOFF.n61 WLOFF.t22 317.147
R372 WLOFF.n64 WLOFF.t20 317.147
R373 WLOFF.n67 WLOFF.t18 317.147
R374 WLOFF.n70 WLOFF.t16 317.147
R375 WLOFF.n73 WLOFF.t14 317.147
R376 WLOFF.n76 WLOFF.t12 317.147
R377 WLOFF.n79 WLOFF.t10 317.147
R378 WLOFF.n82 WLOFF.t8 317.147
R379 WLOFF.n85 WLOFF.t6 317.147
R380 WLOFF.n88 WLOFF.t4 317.147
R381 WLOFF.n91 WLOFF.t2 317.147
R382 WLOFF.n0 WLOFF.t0 317.147
R383 WLOFF.n2 WLOFF.n1 12.8214
R384 WLOFF.n5 WLOFF.n4 12.8214
R385 WLOFF.n8 WLOFF.n7 12.8214
R386 WLOFF.n11 WLOFF.n10 12.8214
R387 WLOFF.n14 WLOFF.n13 12.8214
R388 WLOFF.n17 WLOFF.n16 12.8214
R389 WLOFF.n20 WLOFF.n19 12.8214
R390 WLOFF.n23 WLOFF.n22 12.8214
R391 WLOFF.n26 WLOFF.n25 12.8214
R392 WLOFF.n29 WLOFF.n28 12.8214
R393 WLOFF.n32 WLOFF.n31 12.8214
R394 WLOFF.n35 WLOFF.n34 12.8214
R395 WLOFF.n38 WLOFF.n37 12.8214
R396 WLOFF.n41 WLOFF.n40 12.8214
R397 WLOFF.n44 WLOFF.n43 12.8214
R398 WLOFF.n47 WLOFF.n46 12.8214
R399 WLOFF.n50 WLOFF.n49 12.8214
R400 WLOFF.n53 WLOFF.n52 12.8214
R401 WLOFF.n56 WLOFF.n55 12.8214
R402 WLOFF.n59 WLOFF.n58 12.8214
R403 WLOFF.n62 WLOFF.n61 12.8214
R404 WLOFF.n65 WLOFF.n64 12.8214
R405 WLOFF.n68 WLOFF.n67 12.8214
R406 WLOFF.n71 WLOFF.n70 12.8214
R407 WLOFF.n74 WLOFF.n73 12.8214
R408 WLOFF.n77 WLOFF.n76 12.8214
R409 WLOFF.n80 WLOFF.n79 12.8214
R410 WLOFF.n83 WLOFF.n82 12.8214
R411 WLOFF.n86 WLOFF.n85 12.8214
R412 WLOFF.n89 WLOFF.n88 12.8214
R413 WLOFF.n92 WLOFF.n91 12.8214
R414 WLOFF.n94 WLOFF.n0 12.8214
R415 WLOFF.n94 WLOFF.n93 4.95915
R416 WLOFF.n93 WLOFF.n92 3.4105
R417 WLOFF.n90 WLOFF.n89 3.4105
R418 WLOFF.n87 WLOFF.n86 3.4105
R419 WLOFF.n84 WLOFF.n83 3.4105
R420 WLOFF.n81 WLOFF.n80 3.4105
R421 WLOFF.n78 WLOFF.n77 3.4105
R422 WLOFF.n75 WLOFF.n74 3.4105
R423 WLOFF.n72 WLOFF.n71 3.4105
R424 WLOFF.n69 WLOFF.n68 3.4105
R425 WLOFF.n66 WLOFF.n65 3.4105
R426 WLOFF.n63 WLOFF.n62 3.4105
R427 WLOFF.n60 WLOFF.n59 3.4105
R428 WLOFF.n57 WLOFF.n56 3.4105
R429 WLOFF.n54 WLOFF.n53 3.4105
R430 WLOFF.n51 WLOFF.n50 3.4105
R431 WLOFF.n48 WLOFF.n47 3.4105
R432 WLOFF.n45 WLOFF.n44 3.4105
R433 WLOFF.n42 WLOFF.n41 3.4105
R434 WLOFF.n39 WLOFF.n38 3.4105
R435 WLOFF.n36 WLOFF.n35 3.4105
R436 WLOFF.n33 WLOFF.n32 3.4105
R437 WLOFF.n30 WLOFF.n29 3.4105
R438 WLOFF.n27 WLOFF.n26 3.4105
R439 WLOFF.n24 WLOFF.n23 3.4105
R440 WLOFF.n21 WLOFF.n20 3.4105
R441 WLOFF.n18 WLOFF.n17 3.4105
R442 WLOFF.n15 WLOFF.n14 3.4105
R443 WLOFF.n12 WLOFF.n11 3.4105
R444 WLOFF.n9 WLOFF.n8 3.4105
R445 WLOFF.n6 WLOFF.n5 3.4105
R446 WLOFF.n3 WLOFF.n2 3.4105
R447 WLOFF.n93 WLOFF.n90 1.54915
R448 WLOFF.n90 WLOFF.n87 1.54915
R449 WLOFF.n87 WLOFF.n84 1.54915
R450 WLOFF.n84 WLOFF.n81 1.54915
R451 WLOFF.n81 WLOFF.n78 1.54915
R452 WLOFF.n78 WLOFF.n75 1.54915
R453 WLOFF.n75 WLOFF.n72 1.54915
R454 WLOFF.n72 WLOFF.n69 1.54915
R455 WLOFF.n69 WLOFF.n66 1.54915
R456 WLOFF.n66 WLOFF.n63 1.54915
R457 WLOFF.n63 WLOFF.n60 1.54915
R458 WLOFF.n60 WLOFF.n57 1.54915
R459 WLOFF.n57 WLOFF.n54 1.54915
R460 WLOFF.n54 WLOFF.n51 1.54915
R461 WLOFF.n51 WLOFF.n48 1.54915
R462 WLOFF.n48 WLOFF.n45 1.54915
R463 WLOFF.n45 WLOFF.n42 1.54915
R464 WLOFF.n42 WLOFF.n39 1.54915
R465 WLOFF.n39 WLOFF.n36 1.54915
R466 WLOFF.n36 WLOFF.n33 1.54915
R467 WLOFF.n33 WLOFF.n30 1.54915
R468 WLOFF.n30 WLOFF.n27 1.54915
R469 WLOFF.n27 WLOFF.n24 1.54915
R470 WLOFF.n24 WLOFF.n21 1.54915
R471 WLOFF.n21 WLOFF.n18 1.54915
R472 WLOFF.n18 WLOFF.n15 1.54915
R473 WLOFF.n15 WLOFF.n12 1.54915
R474 WLOFF.n12 WLOFF.n9 1.54915
R475 WLOFF.n9 WLOFF.n6 1.54915
R476 WLOFF.n6 WLOFF.n3 1.54915
R477 WLOFF.n3 WLOFF 1.3588
R478 WLOFF.n2 WLOFF 0.68256
R479 WLOFF.n5 WLOFF 0.68256
R480 WLOFF.n8 WLOFF 0.68256
R481 WLOFF.n11 WLOFF 0.68256
R482 WLOFF.n14 WLOFF 0.68256
R483 WLOFF.n17 WLOFF 0.68256
R484 WLOFF.n20 WLOFF 0.68256
R485 WLOFF.n23 WLOFF 0.68256
R486 WLOFF.n26 WLOFF 0.68256
R487 WLOFF.n29 WLOFF 0.68256
R488 WLOFF.n32 WLOFF 0.68256
R489 WLOFF.n35 WLOFF 0.68256
R490 WLOFF.n38 WLOFF 0.68256
R491 WLOFF.n41 WLOFF 0.68256
R492 WLOFF.n44 WLOFF 0.68256
R493 WLOFF.n47 WLOFF 0.68256
R494 WLOFF.n50 WLOFF 0.68256
R495 WLOFF.n53 WLOFF 0.68256
R496 WLOFF.n56 WLOFF 0.68256
R497 WLOFF.n59 WLOFF 0.68256
R498 WLOFF.n62 WLOFF 0.68256
R499 WLOFF.n65 WLOFF 0.68256
R500 WLOFF.n68 WLOFF 0.68256
R501 WLOFF.n71 WLOFF 0.68256
R502 WLOFF.n74 WLOFF 0.68256
R503 WLOFF.n77 WLOFF 0.68256
R504 WLOFF.n80 WLOFF 0.68256
R505 WLOFF.n83 WLOFF 0.68256
R506 WLOFF.n86 WLOFF 0.68256
R507 WLOFF.n89 WLOFF 0.68256
R508 WLOFF.n92 WLOFF 0.68256
R509 WLOFF WLOFF.n94 0.68256
R510 VDD.n7 VDD.t95 671.755
R511 VDD.n12 VDD.t85 671.755
R512 VDD.n17 VDD.t81 671.755
R513 VDD.n22 VDD.t27 671.755
R514 VDD.n27 VDD.t47 671.755
R515 VDD.n32 VDD.t11 671.755
R516 VDD.n37 VDD.t138 671.755
R517 VDD.n42 VDD.t45 671.755
R518 VDD.n47 VDD.t93 671.755
R519 VDD.n52 VDD.t115 671.755
R520 VDD.n57 VDD.t57 671.755
R521 VDD.n62 VDD.t132 671.755
R522 VDD.n67 VDD.t126 671.755
R523 VDD.n72 VDD.t121 671.755
R524 VDD.n77 VDD.t109 671.755
R525 VDD.n82 VDD.t105 671.755
R526 VDD.n87 VDD.t99 671.755
R527 VDD.n92 VDD.t89 671.755
R528 VDD.n97 VDD.t41 671.755
R529 VDD.n102 VDD.t63 671.755
R530 VDD.n107 VDD.t21 671.755
R531 VDD.n112 VDD.t39 671.755
R532 VDD.n117 VDD.t23 671.755
R533 VDD.n122 VDD.t49 671.755
R534 VDD.n127 VDD.t87 671.755
R535 VDD.n132 VDD.t35 671.755
R536 VDD.n137 VDD.t19 671.755
R537 VDD.n142 VDD.t5 671.755
R538 VDD.n147 VDD.t55 671.755
R539 VDD.n152 VDD.t53 671.755
R540 VDD.n157 VDD.t71 671.755
R541 VDD.n162 VDD.t3 671.755
R542 VDD.n5 VDD.t79 671.547
R543 VDD.n10 VDD.t101 671.547
R544 VDD.n15 VDD.t83 671.547
R545 VDD.n20 VDD.t119 671.547
R546 VDD.n25 VDD.t65 671.547
R547 VDD.n30 VDD.t37 671.547
R548 VDD.n35 VDD.t29 671.547
R549 VDD.n40 VDD.t67 671.547
R550 VDD.n45 VDD.t77 671.547
R551 VDD.n50 VDD.t117 671.547
R552 VDD.n55 VDD.t69 671.547
R553 VDD.n60 VDD.t103 671.547
R554 VDD.n65 VDD.t128 671.547
R555 VDD.n70 VDD.t124 671.547
R556 VDD.n75 VDD.t113 671.547
R557 VDD.n80 VDD.t111 671.547
R558 VDD.n85 VDD.t107 671.547
R559 VDD.n90 VDD.t7 671.547
R560 VDD.n95 VDD.t43 671.547
R561 VDD.n100 VDD.t97 671.547
R562 VDD.n105 VDD.t33 671.547
R563 VDD.n110 VDD.t91 671.547
R564 VDD.n115 VDD.t61 671.547
R565 VDD.n120 VDD.t51 671.547
R566 VDD.n125 VDD.t25 671.547
R567 VDD.n130 VDD.t136 671.547
R568 VDD.n135 VDD.t73 671.547
R569 VDD.n140 VDD.t59 671.547
R570 VDD.n145 VDD.t13 671.547
R571 VDD.n150 VDD.t9 671.547
R572 VDD.n155 VDD.t17 671.547
R573 VDD.n160 VDD.t31 671.547
R574 VDD.n180 VDD.t141 340.288
R575 VDD.n0 VDD.t139 191.141
R576 VDD.n3 VDD.t133 190.694
R577 VDD.n2 VDD.t122 190.694
R578 VDD.n0 VDD.t74 190.694
R579 VDD.n165 VDD.t146 189.672
R580 VDD.n168 VDD.t144 189.224
R581 VDD.n165 VDD.t142 189.224
R582 VDD.n171 VDD.t130 188.915
R583 VDD.n171 VDD.t129 188.668
R584 VDD.n175 VDD.t0 188.554
R585 VDD.n172 VDD.t14 188.554
R586 VDD.n179 VDD.t140 187.156
R587 VDD.n8 VDD.t94 185.983
R588 VDD.n13 VDD.t84 185.983
R589 VDD.n18 VDD.t80 185.983
R590 VDD.n23 VDD.t26 185.983
R591 VDD.n28 VDD.t46 185.983
R592 VDD.n33 VDD.t10 185.983
R593 VDD.n38 VDD.t137 185.983
R594 VDD.n43 VDD.t44 185.983
R595 VDD.n48 VDD.t92 185.983
R596 VDD.n53 VDD.t114 185.983
R597 VDD.n58 VDD.t56 185.983
R598 VDD.n63 VDD.t131 185.983
R599 VDD.n68 VDD.t125 185.983
R600 VDD.n73 VDD.t120 185.983
R601 VDD.n78 VDD.t108 185.983
R602 VDD.n83 VDD.t104 185.983
R603 VDD.n88 VDD.t98 185.983
R604 VDD.n93 VDD.t88 185.983
R605 VDD.n98 VDD.t40 185.983
R606 VDD.n103 VDD.t62 185.983
R607 VDD.n108 VDD.t20 185.983
R608 VDD.n113 VDD.t38 185.983
R609 VDD.n118 VDD.t22 185.983
R610 VDD.n123 VDD.t48 185.983
R611 VDD.n128 VDD.t86 185.983
R612 VDD.n133 VDD.t34 185.983
R613 VDD.n138 VDD.t18 185.983
R614 VDD.n143 VDD.t4 185.983
R615 VDD.n148 VDD.t54 185.983
R616 VDD.n153 VDD.t52 185.983
R617 VDD.n158 VDD.t70 185.983
R618 VDD.n163 VDD.t2 185.983
R619 VDD.n6 VDD.t78 185.75
R620 VDD.n11 VDD.t100 185.75
R621 VDD.n16 VDD.t82 185.75
R622 VDD.n21 VDD.t118 185.75
R623 VDD.n26 VDD.t64 185.75
R624 VDD.n31 VDD.t36 185.75
R625 VDD.n36 VDD.t28 185.75
R626 VDD.n41 VDD.t66 185.75
R627 VDD.n46 VDD.t76 185.75
R628 VDD.n51 VDD.t116 185.75
R629 VDD.n56 VDD.t68 185.75
R630 VDD.n61 VDD.t102 185.75
R631 VDD.n66 VDD.t127 185.75
R632 VDD.n71 VDD.t123 185.75
R633 VDD.n76 VDD.t112 185.75
R634 VDD.n81 VDD.t110 185.75
R635 VDD.n86 VDD.t106 185.75
R636 VDD.n91 VDD.t6 185.75
R637 VDD.n96 VDD.t42 185.75
R638 VDD.n101 VDD.t96 185.75
R639 VDD.n106 VDD.t32 185.75
R640 VDD.n111 VDD.t90 185.75
R641 VDD.n116 VDD.t60 185.75
R642 VDD.n121 VDD.t50 185.75
R643 VDD.n126 VDD.t24 185.75
R644 VDD.n131 VDD.t135 185.75
R645 VDD.n136 VDD.t72 185.75
R646 VDD.n141 VDD.t58 185.75
R647 VDD.n146 VDD.t12 185.75
R648 VDD.n151 VDD.t8 185.75
R649 VDD.n156 VDD.t16 185.75
R650 VDD.n161 VDD.t30 185.75
R651 VDD.n174 VDD.t1 143.096
R652 VDD.n173 VDD.t15 143.096
R653 VDD.n167 VDD.t145 105.356
R654 VDD.n166 VDD.t143 105.356
R655 VDD.n4 VDD.t134 57.2359
R656 VDD.n1 VDD.t75 57.2359
R657 VDD.n178 VDD.n177 6.0942
R658 VDD.n177 VDD.n176 3.4105
R659 VDD.n170 VDD.n169 3.4105
R660 VDD.n164 VDD.n163 3.4105
R661 VDD.n159 VDD.n158 3.4105
R662 VDD.n154 VDD.n153 3.4105
R663 VDD.n149 VDD.n148 3.4105
R664 VDD.n144 VDD.n143 3.4105
R665 VDD.n139 VDD.n138 3.4105
R666 VDD.n134 VDD.n133 3.4105
R667 VDD.n129 VDD.n128 3.4105
R668 VDD.n124 VDD.n123 3.4105
R669 VDD.n119 VDD.n118 3.4105
R670 VDD.n114 VDD.n113 3.4105
R671 VDD.n109 VDD.n108 3.4105
R672 VDD.n104 VDD.n103 3.4105
R673 VDD.n99 VDD.n98 3.4105
R674 VDD.n94 VDD.n93 3.4105
R675 VDD.n89 VDD.n88 3.4105
R676 VDD.n84 VDD.n83 3.4105
R677 VDD.n79 VDD.n78 3.4105
R678 VDD.n74 VDD.n73 3.4105
R679 VDD.n69 VDD.n68 3.4105
R680 VDD.n64 VDD.n63 3.4105
R681 VDD.n59 VDD.n58 3.4105
R682 VDD.n54 VDD.n53 3.4105
R683 VDD.n49 VDD.n48 3.4105
R684 VDD.n44 VDD.n43 3.4105
R685 VDD.n39 VDD.n38 3.4105
R686 VDD.n34 VDD.n33 3.4105
R687 VDD.n29 VDD.n28 3.4105
R688 VDD.n24 VDD.n23 3.4105
R689 VDD.n19 VDD.n18 3.4105
R690 VDD.n14 VDD.n13 3.4105
R691 VDD.n9 VDD.n8 3.4105
R692 VDD.n170 VDD.n164 1.92633
R693 VDD.n177 VDD.n170 1.62083
R694 VDD.n164 VDD.n159 1.54915
R695 VDD.n159 VDD.n154 1.54915
R696 VDD.n154 VDD.n149 1.54915
R697 VDD.n149 VDD.n144 1.54915
R698 VDD.n144 VDD.n139 1.54915
R699 VDD.n139 VDD.n134 1.54915
R700 VDD.n134 VDD.n129 1.54915
R701 VDD.n129 VDD.n124 1.54915
R702 VDD.n124 VDD.n119 1.54915
R703 VDD.n119 VDD.n114 1.54915
R704 VDD.n114 VDD.n109 1.54915
R705 VDD.n109 VDD.n104 1.54915
R706 VDD.n104 VDD.n99 1.54915
R707 VDD.n99 VDD.n94 1.54915
R708 VDD.n94 VDD.n89 1.54915
R709 VDD.n89 VDD.n84 1.54915
R710 VDD.n84 VDD.n79 1.54915
R711 VDD.n79 VDD.n74 1.54915
R712 VDD.n74 VDD.n69 1.54915
R713 VDD.n69 VDD.n64 1.54915
R714 VDD.n64 VDD.n59 1.54915
R715 VDD.n59 VDD.n54 1.54915
R716 VDD.n54 VDD.n49 1.54915
R717 VDD.n49 VDD.n44 1.54915
R718 VDD.n44 VDD.n39 1.54915
R719 VDD.n39 VDD.n34 1.54915
R720 VDD.n34 VDD.n29 1.54915
R721 VDD.n29 VDD.n24 1.54915
R722 VDD.n24 VDD.n19 1.54915
R723 VDD.n19 VDD.n14 1.54915
R724 VDD.n14 VDD.n9 1.54915
R725 VDD.n172 VDD.n171 0.448119
R726 VDD.n3 VDD.n2 0.448119
R727 VDD.n167 VDD 0.384893
R728 VDD.n174 VDD 0.384893
R729 VDD VDD.n180 0.384893
R730 VDD.n2 VDD.n1 0.320548
R731 VDD.n169 VDD.n166 0.311595
R732 VDD.n176 VDD.n173 0.311595
R733 VDD.n178 VDD.n4 0.311595
R734 VDD.n7 VDD.n6 0.267812
R735 VDD.n12 VDD.n11 0.267812
R736 VDD.n17 VDD.n16 0.267812
R737 VDD.n22 VDD.n21 0.267812
R738 VDD.n27 VDD.n26 0.267812
R739 VDD.n32 VDD.n31 0.267812
R740 VDD.n37 VDD.n36 0.267812
R741 VDD.n42 VDD.n41 0.267812
R742 VDD.n47 VDD.n46 0.267812
R743 VDD.n52 VDD.n51 0.267812
R744 VDD.n57 VDD.n56 0.267812
R745 VDD.n62 VDD.n61 0.267812
R746 VDD.n67 VDD.n66 0.267812
R747 VDD.n72 VDD.n71 0.267812
R748 VDD.n77 VDD.n76 0.267812
R749 VDD.n82 VDD.n81 0.267812
R750 VDD.n87 VDD.n86 0.267812
R751 VDD.n92 VDD.n91 0.267812
R752 VDD.n97 VDD.n96 0.267812
R753 VDD.n102 VDD.n101 0.267812
R754 VDD.n107 VDD.n106 0.267812
R755 VDD.n112 VDD.n111 0.267812
R756 VDD.n117 VDD.n116 0.267812
R757 VDD.n122 VDD.n121 0.267812
R758 VDD.n127 VDD.n126 0.267812
R759 VDD.n132 VDD.n131 0.267812
R760 VDD.n137 VDD.n136 0.267812
R761 VDD.n142 VDD.n141 0.267812
R762 VDD.n147 VDD.n146 0.267812
R763 VDD.n152 VDD.n151 0.267812
R764 VDD.n157 VDD.n156 0.267812
R765 VDD.n162 VDD.n161 0.267812
R766 VDD.n5 VDD 0.143179
R767 VDD.n10 VDD 0.143179
R768 VDD.n15 VDD 0.143179
R769 VDD.n20 VDD 0.143179
R770 VDD.n25 VDD 0.143179
R771 VDD.n30 VDD 0.143179
R772 VDD.n35 VDD 0.143179
R773 VDD.n40 VDD 0.143179
R774 VDD.n45 VDD 0.143179
R775 VDD.n50 VDD 0.143179
R776 VDD.n55 VDD 0.143179
R777 VDD.n60 VDD 0.143179
R778 VDD.n65 VDD 0.143179
R779 VDD.n70 VDD 0.143179
R780 VDD.n75 VDD 0.143179
R781 VDD.n80 VDD 0.143179
R782 VDD.n85 VDD 0.143179
R783 VDD.n90 VDD 0.143179
R784 VDD.n95 VDD 0.143179
R785 VDD.n100 VDD 0.143179
R786 VDD.n105 VDD 0.143179
R787 VDD.n110 VDD 0.143179
R788 VDD.n115 VDD 0.143179
R789 VDD.n120 VDD 0.143179
R790 VDD.n125 VDD 0.143179
R791 VDD.n130 VDD 0.143179
R792 VDD.n135 VDD 0.143179
R793 VDD.n140 VDD 0.143179
R794 VDD.n145 VDD 0.143179
R795 VDD.n150 VDD 0.143179
R796 VDD.n155 VDD 0.143179
R797 VDD.n160 VDD 0.143179
R798 VDD.n1 VDD.n0 0.128071
R799 VDD.n4 VDD.n3 0.128071
R800 VDD.n168 VDD.n167 0.10569
R801 VDD.n166 VDD.n165 0.10569
R802 VDD.n175 VDD.n174 0.0945
R803 VDD.n173 VDD.n172 0.0945
R804 VDD.n6 VDD.n5 0.0900238
R805 VDD.n11 VDD.n10 0.0900238
R806 VDD.n16 VDD.n15 0.0900238
R807 VDD.n21 VDD.n20 0.0900238
R808 VDD.n26 VDD.n25 0.0900238
R809 VDD.n31 VDD.n30 0.0900238
R810 VDD.n36 VDD.n35 0.0900238
R811 VDD.n41 VDD.n40 0.0900238
R812 VDD.n46 VDD.n45 0.0900238
R813 VDD.n51 VDD.n50 0.0900238
R814 VDD.n56 VDD.n55 0.0900238
R815 VDD.n61 VDD.n60 0.0900238
R816 VDD.n66 VDD.n65 0.0900238
R817 VDD.n71 VDD.n70 0.0900238
R818 VDD.n76 VDD.n75 0.0900238
R819 VDD.n81 VDD.n80 0.0900238
R820 VDD.n86 VDD.n85 0.0900238
R821 VDD.n91 VDD.n90 0.0900238
R822 VDD.n96 VDD.n95 0.0900238
R823 VDD.n101 VDD.n100 0.0900238
R824 VDD.n106 VDD.n105 0.0900238
R825 VDD.n111 VDD.n110 0.0900238
R826 VDD.n116 VDD.n115 0.0900238
R827 VDD.n121 VDD.n120 0.0900238
R828 VDD.n126 VDD.n125 0.0900238
R829 VDD.n131 VDD.n130 0.0900238
R830 VDD.n136 VDD.n135 0.0900238
R831 VDD.n141 VDD.n140 0.0900238
R832 VDD.n146 VDD.n145 0.0900238
R833 VDD.n151 VDD.n150 0.0900238
R834 VDD.n156 VDD.n155 0.0900238
R835 VDD.n161 VDD.n160 0.0900238
R836 VDD.n180 VDD.n179 0.072119
R837 VDD.n9 VDD 0.0663
R838 VDD.n179 VDD.n178 0.0586905
R839 VDD.n176 VDD.n175 0.0363095
R840 VDD.n169 VDD.n168 0.025119
R841 VDD.n8 VDD.n7 0.0151875
R842 VDD.n13 VDD.n12 0.0151875
R843 VDD.n18 VDD.n17 0.0151875
R844 VDD.n23 VDD.n22 0.0151875
R845 VDD.n28 VDD.n27 0.0151875
R846 VDD.n33 VDD.n32 0.0151875
R847 VDD.n38 VDD.n37 0.0151875
R848 VDD.n43 VDD.n42 0.0151875
R849 VDD.n48 VDD.n47 0.0151875
R850 VDD.n53 VDD.n52 0.0151875
R851 VDD.n58 VDD.n57 0.0151875
R852 VDD.n63 VDD.n62 0.0151875
R853 VDD.n68 VDD.n67 0.0151875
R854 VDD.n73 VDD.n72 0.0151875
R855 VDD.n78 VDD.n77 0.0151875
R856 VDD.n83 VDD.n82 0.0151875
R857 VDD.n88 VDD.n87 0.0151875
R858 VDD.n93 VDD.n92 0.0151875
R859 VDD.n98 VDD.n97 0.0151875
R860 VDD.n103 VDD.n102 0.0151875
R861 VDD.n108 VDD.n107 0.0151875
R862 VDD.n113 VDD.n112 0.0151875
R863 VDD.n118 VDD.n117 0.0151875
R864 VDD.n123 VDD.n122 0.0151875
R865 VDD.n128 VDD.n127 0.0151875
R866 VDD.n133 VDD.n132 0.0151875
R867 VDD.n138 VDD.n137 0.0151875
R868 VDD.n143 VDD.n142 0.0151875
R869 VDD.n148 VDD.n147 0.0151875
R870 VDD.n153 VDD.n152 0.0151875
R871 VDD.n158 VDD.n157 0.0151875
R872 VDD.n163 VDD.n162 0.0151875
R873 VSS.n951 VSS.n6 38902.9
R874 VSS.n992 VSS.t6 16831.7
R875 VSS.n957 VSS.n10 16831.7
R876 VSS.n980 VSS.n14 16831.7
R877 VSS.n152 VSS.n19 11727.9
R878 VSS.n950 VSS.n15 10965.1
R879 VSS.n950 VSS.n949 10965.1
R880 VSS.n953 VSS.n10 9754.5
R881 VSS.n979 VSS.n978 8731.1
R882 VSS.n558 VSS.n17 8261.87
R883 VSS.n583 VSS.n522 8261.87
R884 VSS.n558 VSS.n522 8261.87
R885 VSS.n592 VSS.n493 8261.87
R886 VSS.n592 VSS.n583 8261.87
R887 VSS.n626 VSS.n617 8261.87
R888 VSS.n617 VSS.n493 8261.87
R889 VSS.n651 VSS.n464 8261.87
R890 VSS.n626 VSS.n464 8261.87
R891 VSS.n660 VSS.n435 8261.87
R892 VSS.n660 VSS.n651 8261.87
R893 VSS.n694 VSS.n685 8261.87
R894 VSS.n685 VSS.n435 8261.87
R895 VSS.n719 VSS.n406 8261.87
R896 VSS.n694 VSS.n406 8261.87
R897 VSS.n728 VSS.n377 8261.87
R898 VSS.n728 VSS.n719 8261.87
R899 VSS.n762 VSS.n753 8261.87
R900 VSS.n753 VSS.n377 8261.87
R901 VSS.n787 VSS.n348 8261.87
R902 VSS.n762 VSS.n348 8261.87
R903 VSS.n796 VSS.n319 8261.87
R904 VSS.n796 VSS.n787 8261.87
R905 VSS.n830 VSS.n821 8261.87
R906 VSS.n821 VSS.n319 8261.87
R907 VSS.n855 VSS.n299 8261.87
R908 VSS.n830 VSS.n299 8261.87
R909 VSS.n929 VSS.n148 8261.87
R910 VSS.n855 VSS.n148 8261.87
R911 VSS.n881 VSS.n149 8261.87
R912 VSS.n929 VSS.n149 8261.87
R913 VSS.n881 VSS.n19 8261.87
R914 VSS.n1003 VSS.n1002 8020.04
R915 VSS.n950 VSS.n16 7689.8
R916 VSS.n536 VSS.n16 5314.29
R917 VSS.n577 VSS.n576 5231.89
R918 VSS.n576 VSS.n536 5231.89
R919 VSS.n610 VSS.n507 5231.89
R920 VSS.n577 VSS.n507 5231.89
R921 VSS.n611 VSS.n478 5231.89
R922 VSS.n611 VSS.n610 5231.89
R923 VSS.n645 VSS.n644 5231.89
R924 VSS.n644 VSS.n478 5231.89
R925 VSS.n678 VSS.n449 5231.89
R926 VSS.n645 VSS.n449 5231.89
R927 VSS.n679 VSS.n420 5231.89
R928 VSS.n679 VSS.n678 5231.89
R929 VSS.n713 VSS.n712 5231.89
R930 VSS.n712 VSS.n420 5231.89
R931 VSS.n746 VSS.n391 5231.89
R932 VSS.n713 VSS.n391 5231.89
R933 VSS.n747 VSS.n362 5231.89
R934 VSS.n747 VSS.n746 5231.89
R935 VSS.n781 VSS.n780 5231.89
R936 VSS.n780 VSS.n362 5231.89
R937 VSS.n814 VSS.n333 5231.89
R938 VSS.n781 VSS.n333 5231.89
R939 VSS.n815 VSS.n304 5231.89
R940 VSS.n815 VSS.n814 5231.89
R941 VSS.n849 VSS.n848 5231.89
R942 VSS.n848 VSS.n304 5231.89
R943 VSS.n923 VSS.n151 5231.89
R944 VSS.n849 VSS.n151 5231.89
R945 VSS.n922 VSS.n152 5231.89
R946 VSS.n923 VSS.n922 5231.89
R947 VSS.n943 VSS.n19 4666.16
R948 VSS.n994 VSS.n8 4646.88
R949 VSS.n996 VSS.n8 4646.88
R950 VSS.n995 VSS.n994 4646.88
R951 VSS.n996 VSS.n995 4646.88
R952 VSS.n968 VSS.n965 4646.88
R953 VSS.n966 VSS.n965 4646.88
R954 VSS.n968 VSS.n967 4646.88
R955 VSS.n967 VSS.n966 4646.88
R956 VSS.n972 VSS.n955 4646.88
R957 VSS.n956 VSS.n955 4646.88
R958 VSS.n972 VSS.n971 4646.88
R959 VSS.n971 VSS.n956 4646.88
R960 VSS.n975 VSS.n954 4646.88
R961 VSS.n976 VSS.n975 4646.88
R962 VSS.n977 VSS.n976 4646.88
R963 VSS.n977 VSS.n954 4646.88
R964 VSS.n158 VSS.n0 2860.07
R965 VSS.n879 VSS.n875 2456.71
R966 VSS.n877 VSS.n875 2456.71
R967 VSS.n879 VSS.n878 2456.71
R968 VSS.n878 VSS.n877 2456.71
R969 VSS.n884 VSS.n870 2456.71
R970 VSS.n884 VSS.n871 2456.71
R971 VSS.n883 VSS.n870 2456.71
R972 VSS.n883 VSS.n871 2456.71
R973 VSS.n927 VSS.n150 2456.71
R974 VSS.n925 VSS.n150 2456.71
R975 VSS.n927 VSS.n926 2456.71
R976 VSS.n926 VSS.n925 2456.71
R977 VSS.n932 VSS.n146 2456.71
R978 VSS.n932 VSS.n147 2456.71
R979 VSS.n931 VSS.n146 2456.71
R980 VSS.n931 VSS.n147 2456.71
R981 VSS.n853 VSS.n303 2456.71
R982 VSS.n851 VSS.n303 2456.71
R983 VSS.n853 VSS.n852 2456.71
R984 VSS.n852 VSS.n851 2456.71
R985 VSS.n858 VSS.n297 2456.71
R986 VSS.n858 VSS.n298 2456.71
R987 VSS.n857 VSS.n297 2456.71
R988 VSS.n857 VSS.n298 2456.71
R989 VSS.n834 VSS.n317 2456.71
R990 VSS.n834 VSS.n318 2456.71
R991 VSS.n833 VSS.n317 2456.71
R992 VSS.n833 VSS.n318 2456.71
R993 VSS.n826 VSS.n825 2456.71
R994 VSS.n828 VSS.n825 2456.71
R995 VSS.n827 VSS.n826 2456.71
R996 VSS.n828 VSS.n827 2456.71
R997 VSS.n810 VSS.n808 2456.71
R998 VSS.n812 VSS.n808 2456.71
R999 VSS.n811 VSS.n810 2456.71
R1000 VSS.n812 VSS.n811 2456.71
R1001 VSS.n340 VSS.n336 2456.71
R1002 VSS.n340 VSS.n337 2456.71
R1003 VSS.n339 VSS.n336 2456.71
R1004 VSS.n339 VSS.n337 2456.71
R1005 VSS.n785 VSS.n361 2456.71
R1006 VSS.n783 VSS.n361 2456.71
R1007 VSS.n785 VSS.n784 2456.71
R1008 VSS.n784 VSS.n783 2456.71
R1009 VSS.n355 VSS.n352 2456.71
R1010 VSS.n355 VSS.n353 2456.71
R1011 VSS.n354 VSS.n352 2456.71
R1012 VSS.n354 VSS.n353 2456.71
R1013 VSS.n766 VSS.n375 2456.71
R1014 VSS.n766 VSS.n376 2456.71
R1015 VSS.n765 VSS.n375 2456.71
R1016 VSS.n765 VSS.n376 2456.71
R1017 VSS.n758 VSS.n757 2456.71
R1018 VSS.n760 VSS.n757 2456.71
R1019 VSS.n759 VSS.n758 2456.71
R1020 VSS.n760 VSS.n759 2456.71
R1021 VSS.n742 VSS.n740 2456.71
R1022 VSS.n744 VSS.n740 2456.71
R1023 VSS.n743 VSS.n742 2456.71
R1024 VSS.n744 VSS.n743 2456.71
R1025 VSS.n398 VSS.n394 2456.71
R1026 VSS.n398 VSS.n395 2456.71
R1027 VSS.n397 VSS.n394 2456.71
R1028 VSS.n397 VSS.n395 2456.71
R1029 VSS.n717 VSS.n419 2456.71
R1030 VSS.n715 VSS.n419 2456.71
R1031 VSS.n717 VSS.n716 2456.71
R1032 VSS.n716 VSS.n715 2456.71
R1033 VSS.n413 VSS.n410 2456.71
R1034 VSS.n413 VSS.n411 2456.71
R1035 VSS.n412 VSS.n410 2456.71
R1036 VSS.n412 VSS.n411 2456.71
R1037 VSS.n698 VSS.n433 2456.71
R1038 VSS.n698 VSS.n434 2456.71
R1039 VSS.n697 VSS.n433 2456.71
R1040 VSS.n697 VSS.n434 2456.71
R1041 VSS.n690 VSS.n689 2456.71
R1042 VSS.n692 VSS.n689 2456.71
R1043 VSS.n691 VSS.n690 2456.71
R1044 VSS.n692 VSS.n691 2456.71
R1045 VSS.n674 VSS.n672 2456.71
R1046 VSS.n676 VSS.n672 2456.71
R1047 VSS.n675 VSS.n674 2456.71
R1048 VSS.n676 VSS.n675 2456.71
R1049 VSS.n456 VSS.n452 2456.71
R1050 VSS.n456 VSS.n453 2456.71
R1051 VSS.n455 VSS.n452 2456.71
R1052 VSS.n455 VSS.n453 2456.71
R1053 VSS.n649 VSS.n477 2456.71
R1054 VSS.n647 VSS.n477 2456.71
R1055 VSS.n649 VSS.n648 2456.71
R1056 VSS.n648 VSS.n647 2456.71
R1057 VSS.n471 VSS.n468 2456.71
R1058 VSS.n471 VSS.n469 2456.71
R1059 VSS.n470 VSS.n468 2456.71
R1060 VSS.n470 VSS.n469 2456.71
R1061 VSS.n630 VSS.n491 2456.71
R1062 VSS.n630 VSS.n492 2456.71
R1063 VSS.n629 VSS.n491 2456.71
R1064 VSS.n629 VSS.n492 2456.71
R1065 VSS.n622 VSS.n621 2456.71
R1066 VSS.n624 VSS.n621 2456.71
R1067 VSS.n623 VSS.n622 2456.71
R1068 VSS.n624 VSS.n623 2456.71
R1069 VSS.n606 VSS.n604 2456.71
R1070 VSS.n608 VSS.n604 2456.71
R1071 VSS.n607 VSS.n606 2456.71
R1072 VSS.n608 VSS.n607 2456.71
R1073 VSS.n514 VSS.n510 2456.71
R1074 VSS.n514 VSS.n511 2456.71
R1075 VSS.n513 VSS.n510 2456.71
R1076 VSS.n513 VSS.n511 2456.71
R1077 VSS.n581 VSS.n535 2456.71
R1078 VSS.n579 VSS.n535 2456.71
R1079 VSS.n581 VSS.n580 2456.71
R1080 VSS.n580 VSS.n579 2456.71
R1081 VSS.n529 VSS.n526 2456.71
R1082 VSS.n529 VSS.n527 2456.71
R1083 VSS.n528 VSS.n526 2456.71
R1084 VSS.n528 VSS.n527 2456.71
R1085 VSS.n562 VSS.n548 2456.71
R1086 VSS.n562 VSS.n549 2456.71
R1087 VSS.n561 VSS.n548 2456.71
R1088 VSS.n561 VSS.n549 2456.71
R1089 VSS.n554 VSS.n553 2456.71
R1090 VSS.n556 VSS.n553 2456.71
R1091 VSS.n555 VSS.n554 2456.71
R1092 VSS.n556 VSS.n555 2456.71
R1093 VSS.n230 VSS.n225 2456.71
R1094 VSS.n230 VSS.n226 2456.71
R1095 VSS.n229 VSS.n225 2456.71
R1096 VSS.n229 VSS.n226 2456.71
R1097 VSS.n945 VSS.n18 2456.71
R1098 VSS.n947 VSS.n18 2456.71
R1099 VSS.n946 VSS.n945 2456.71
R1100 VSS.n947 VSS.n946 2456.71
R1101 VSS.n572 VSS.n570 2456.71
R1102 VSS.n574 VSS.n570 2456.71
R1103 VSS.n573 VSS.n572 2456.71
R1104 VSS.n574 VSS.n573 2456.71
R1105 VSS.n543 VSS.n539 2456.71
R1106 VSS.n543 VSS.n540 2456.71
R1107 VSS.n542 VSS.n539 2456.71
R1108 VSS.n542 VSS.n540 2456.71
R1109 VSS.n596 VSS.n520 2456.71
R1110 VSS.n596 VSS.n521 2456.71
R1111 VSS.n595 VSS.n520 2456.71
R1112 VSS.n595 VSS.n521 2456.71
R1113 VSS.n588 VSS.n587 2456.71
R1114 VSS.n590 VSS.n587 2456.71
R1115 VSS.n589 VSS.n588 2456.71
R1116 VSS.n590 VSS.n589 2456.71
R1117 VSS.n615 VSS.n506 2456.71
R1118 VSS.n613 VSS.n506 2456.71
R1119 VSS.n615 VSS.n614 2456.71
R1120 VSS.n614 VSS.n613 2456.71
R1121 VSS.n500 VSS.n497 2456.71
R1122 VSS.n500 VSS.n498 2456.71
R1123 VSS.n499 VSS.n497 2456.71
R1124 VSS.n499 VSS.n498 2456.71
R1125 VSS.n640 VSS.n638 2456.71
R1126 VSS.n642 VSS.n638 2456.71
R1127 VSS.n641 VSS.n640 2456.71
R1128 VSS.n642 VSS.n641 2456.71
R1129 VSS.n485 VSS.n481 2456.71
R1130 VSS.n485 VSS.n482 2456.71
R1131 VSS.n484 VSS.n481 2456.71
R1132 VSS.n484 VSS.n482 2456.71
R1133 VSS.n664 VSS.n462 2456.71
R1134 VSS.n664 VSS.n463 2456.71
R1135 VSS.n663 VSS.n462 2456.71
R1136 VSS.n663 VSS.n463 2456.71
R1137 VSS.n656 VSS.n655 2456.71
R1138 VSS.n658 VSS.n655 2456.71
R1139 VSS.n657 VSS.n656 2456.71
R1140 VSS.n658 VSS.n657 2456.71
R1141 VSS.n683 VSS.n448 2456.71
R1142 VSS.n681 VSS.n448 2456.71
R1143 VSS.n683 VSS.n682 2456.71
R1144 VSS.n682 VSS.n681 2456.71
R1145 VSS.n442 VSS.n439 2456.71
R1146 VSS.n442 VSS.n440 2456.71
R1147 VSS.n441 VSS.n439 2456.71
R1148 VSS.n441 VSS.n440 2456.71
R1149 VSS.n708 VSS.n706 2456.71
R1150 VSS.n710 VSS.n706 2456.71
R1151 VSS.n709 VSS.n708 2456.71
R1152 VSS.n710 VSS.n709 2456.71
R1153 VSS.n427 VSS.n423 2456.71
R1154 VSS.n427 VSS.n424 2456.71
R1155 VSS.n426 VSS.n423 2456.71
R1156 VSS.n426 VSS.n424 2456.71
R1157 VSS.n732 VSS.n404 2456.71
R1158 VSS.n732 VSS.n405 2456.71
R1159 VSS.n731 VSS.n404 2456.71
R1160 VSS.n731 VSS.n405 2456.71
R1161 VSS.n724 VSS.n723 2456.71
R1162 VSS.n726 VSS.n723 2456.71
R1163 VSS.n725 VSS.n724 2456.71
R1164 VSS.n726 VSS.n725 2456.71
R1165 VSS.n751 VSS.n390 2456.71
R1166 VSS.n749 VSS.n390 2456.71
R1167 VSS.n751 VSS.n750 2456.71
R1168 VSS.n750 VSS.n749 2456.71
R1169 VSS.n384 VSS.n381 2456.71
R1170 VSS.n384 VSS.n382 2456.71
R1171 VSS.n383 VSS.n381 2456.71
R1172 VSS.n383 VSS.n382 2456.71
R1173 VSS.n776 VSS.n774 2456.71
R1174 VSS.n778 VSS.n774 2456.71
R1175 VSS.n777 VSS.n776 2456.71
R1176 VSS.n778 VSS.n777 2456.71
R1177 VSS.n369 VSS.n365 2456.71
R1178 VSS.n369 VSS.n366 2456.71
R1179 VSS.n368 VSS.n365 2456.71
R1180 VSS.n368 VSS.n366 2456.71
R1181 VSS.n800 VSS.n346 2456.71
R1182 VSS.n800 VSS.n347 2456.71
R1183 VSS.n799 VSS.n346 2456.71
R1184 VSS.n799 VSS.n347 2456.71
R1185 VSS.n792 VSS.n791 2456.71
R1186 VSS.n794 VSS.n791 2456.71
R1187 VSS.n793 VSS.n792 2456.71
R1188 VSS.n794 VSS.n793 2456.71
R1189 VSS.n819 VSS.n332 2456.71
R1190 VSS.n817 VSS.n332 2456.71
R1191 VSS.n819 VSS.n818 2456.71
R1192 VSS.n818 VSS.n817 2456.71
R1193 VSS.n326 VSS.n323 2456.71
R1194 VSS.n326 VSS.n324 2456.71
R1195 VSS.n325 VSS.n323 2456.71
R1196 VSS.n325 VSS.n324 2456.71
R1197 VSS.n844 VSS.n842 2456.71
R1198 VSS.n846 VSS.n842 2456.71
R1199 VSS.n845 VSS.n844 2456.71
R1200 VSS.n846 VSS.n845 2456.71
R1201 VSS.n311 VSS.n307 2456.71
R1202 VSS.n311 VSS.n308 2456.71
R1203 VSS.n310 VSS.n307 2456.71
R1204 VSS.n310 VSS.n308 2456.71
R1205 VSS.n904 VSS.n899 2456.71
R1206 VSS.n904 VSS.n900 2456.71
R1207 VSS.n903 VSS.n899 2456.71
R1208 VSS.n903 VSS.n900 2456.71
R1209 VSS.n895 VSS.n891 2456.71
R1210 VSS.n895 VSS.n892 2456.71
R1211 VSS.n894 VSS.n891 2456.71
R1212 VSS.n894 VSS.n892 2456.71
R1213 VSS.n918 VSS.n916 2456.71
R1214 VSS.n920 VSS.n916 2456.71
R1215 VSS.n919 VSS.n918 2456.71
R1216 VSS.n920 VSS.n919 2456.71
R1217 VSS.n163 VSS.n159 2456.71
R1218 VSS.n163 VSS.n160 2456.71
R1219 VSS.n162 VSS.n159 2456.71
R1220 VSS.n162 VSS.n160 2456.71
R1221 VSS.n979 VSS.n953 2320.45
R1222 VSS.n1005 VSS.n4 2294.47
R1223 VSS.n1005 VSS.n5 2294.47
R1224 VSS.n1004 VSS.n4 2294.47
R1225 VSS.n1004 VSS.n5 2294.47
R1226 VSS.n991 VSS.n989 2294.47
R1227 VSS.n991 VSS.n990 2294.47
R1228 VSS.n989 VSS.n988 2294.47
R1229 VSS.n990 VSS.n988 2294.47
R1230 VSS.n13 VSS.n12 2294.47
R1231 VSS.n983 VSS.n12 2294.47
R1232 VSS.n982 VSS.n13 2294.47
R1233 VSS.n983 VSS.n982 2294.47
R1234 VSS.n999 VSS.n7 2213.35
R1235 VSS.n1001 VSS.n7 2213.35
R1236 VSS.n1000 VSS.n999 2213.35
R1237 VSS.n1001 VSS.n1000 2213.35
R1238 VSS.n939 VSS.n82 2074.29
R1239 VSS.n941 VSS.n82 2074.29
R1240 VSS.n940 VSS.n939 2074.29
R1241 VSS.n941 VSS.n940 2074.29
R1242 VSS.n887 VSS.n867 2074.29
R1243 VSS.n887 VSS.n868 2074.29
R1244 VSS.n867 VSS.n866 2074.29
R1245 VSS.n868 VSS.n866 2074.29
R1246 VSS.n165 VSS.n85 2074.29
R1247 VSS.n165 VSS.n51 2074.29
R1248 VSS.n85 VSS.n84 2074.29
R1249 VSS.n84 VSS.n51 2074.29
R1250 VSS.n168 VSS.n167 2074.29
R1251 VSS.n169 VSS.n167 2074.29
R1252 VSS.n170 VSS.n168 2074.29
R1253 VSS.n170 VSS.n169 2074.29
R1254 VSS.n937 VSS.n935 2074.29
R1255 VSS.n935 VSS.n81 2074.29
R1256 VSS.n937 VSS.n936 2074.29
R1257 VSS.n936 VSS.n81 2074.29
R1258 VSS.n863 VSS.n144 2074.29
R1259 VSS.n864 VSS.n144 2074.29
R1260 VSS.n865 VSS.n863 2074.29
R1261 VSS.n865 VSS.n864 2074.29
R1262 VSS.n889 VSS.n87 2074.29
R1263 VSS.n889 VSS.n52 2074.29
R1264 VSS.n87 VSS.n86 2074.29
R1265 VSS.n86 VSS.n52 2074.29
R1266 VSS.n888 VSS.n156 2074.29
R1267 VSS.n888 VSS.n157 2074.29
R1268 VSS.n171 VSS.n156 2074.29
R1269 VSS.n171 VSS.n157 2074.29
R1270 VSS.n860 VSS.n143 2074.29
R1271 VSS.n860 VSS.n80 2074.29
R1272 VSS.n143 VSS.n142 2074.29
R1273 VSS.n142 VSS.n80 2074.29
R1274 VSS.n862 VSS.n294 2074.29
R1275 VSS.n862 VSS.n295 2074.29
R1276 VSS.n294 VSS.n293 2074.29
R1277 VSS.n295 VSS.n293 2074.29
R1278 VSS.n305 VSS.n89 2074.29
R1279 VSS.n305 VSS.n53 2074.29
R1280 VSS.n89 VSS.n88 2074.29
R1281 VSS.n88 VSS.n53 2074.29
R1282 VSS.n173 VSS.n172 2074.29
R1283 VSS.n174 VSS.n172 2074.29
R1284 VSS.n175 VSS.n173 2074.29
R1285 VSS.n175 VSS.n174 2074.29
R1286 VSS.n822 VSS.n141 2074.29
R1287 VSS.n822 VSS.n79 2074.29
R1288 VSS.n141 VSS.n140 2074.29
R1289 VSS.n140 VSS.n79 2074.29
R1290 VSS.n292 VSS.n290 2074.29
R1291 VSS.n292 VSS.n291 2074.29
R1292 VSS.n290 VSS.n289 2074.29
R1293 VSS.n291 VSS.n289 2074.29
R1294 VSS.n321 VSS.n91 2074.29
R1295 VSS.n321 VSS.n54 2074.29
R1296 VSS.n91 VSS.n90 2074.29
R1297 VSS.n90 VSS.n54 2074.29
R1298 VSS.n177 VSS.n176 2074.29
R1299 VSS.n178 VSS.n176 2074.29
R1300 VSS.n179 VSS.n177 2074.29
R1301 VSS.n179 VSS.n178 2074.29
R1302 VSS.n334 VSS.n139 2074.29
R1303 VSS.n334 VSS.n78 2074.29
R1304 VSS.n139 VSS.n138 2074.29
R1305 VSS.n138 VSS.n78 2074.29
R1306 VSS.n288 VSS.n286 2074.29
R1307 VSS.n288 VSS.n287 2074.29
R1308 VSS.n286 VSS.n285 2074.29
R1309 VSS.n287 VSS.n285 2074.29
R1310 VSS.n788 VSS.n93 2074.29
R1311 VSS.n788 VSS.n55 2074.29
R1312 VSS.n93 VSS.n92 2074.29
R1313 VSS.n92 VSS.n55 2074.29
R1314 VSS.n181 VSS.n180 2074.29
R1315 VSS.n182 VSS.n180 2074.29
R1316 VSS.n183 VSS.n181 2074.29
R1317 VSS.n183 VSS.n182 2074.29
R1318 VSS.n350 VSS.n137 2074.29
R1319 VSS.n350 VSS.n77 2074.29
R1320 VSS.n137 VSS.n136 2074.29
R1321 VSS.n136 VSS.n77 2074.29
R1322 VSS.n284 VSS.n282 2074.29
R1323 VSS.n284 VSS.n283 2074.29
R1324 VSS.n282 VSS.n281 2074.29
R1325 VSS.n283 VSS.n281 2074.29
R1326 VSS.n363 VSS.n95 2074.29
R1327 VSS.n363 VSS.n56 2074.29
R1328 VSS.n95 VSS.n94 2074.29
R1329 VSS.n94 VSS.n56 2074.29
R1330 VSS.n185 VSS.n184 2074.29
R1331 VSS.n186 VSS.n184 2074.29
R1332 VSS.n187 VSS.n185 2074.29
R1333 VSS.n187 VSS.n186 2074.29
R1334 VSS.n754 VSS.n135 2074.29
R1335 VSS.n754 VSS.n76 2074.29
R1336 VSS.n135 VSS.n134 2074.29
R1337 VSS.n134 VSS.n76 2074.29
R1338 VSS.n280 VSS.n278 2074.29
R1339 VSS.n280 VSS.n279 2074.29
R1340 VSS.n278 VSS.n277 2074.29
R1341 VSS.n279 VSS.n277 2074.29
R1342 VSS.n379 VSS.n97 2074.29
R1343 VSS.n379 VSS.n57 2074.29
R1344 VSS.n97 VSS.n96 2074.29
R1345 VSS.n96 VSS.n57 2074.29
R1346 VSS.n189 VSS.n188 2074.29
R1347 VSS.n190 VSS.n188 2074.29
R1348 VSS.n191 VSS.n189 2074.29
R1349 VSS.n191 VSS.n190 2074.29
R1350 VSS.n392 VSS.n133 2074.29
R1351 VSS.n392 VSS.n75 2074.29
R1352 VSS.n133 VSS.n132 2074.29
R1353 VSS.n132 VSS.n75 2074.29
R1354 VSS.n276 VSS.n274 2074.29
R1355 VSS.n276 VSS.n275 2074.29
R1356 VSS.n274 VSS.n273 2074.29
R1357 VSS.n275 VSS.n273 2074.29
R1358 VSS.n720 VSS.n99 2074.29
R1359 VSS.n720 VSS.n58 2074.29
R1360 VSS.n99 VSS.n98 2074.29
R1361 VSS.n98 VSS.n58 2074.29
R1362 VSS.n193 VSS.n192 2074.29
R1363 VSS.n194 VSS.n192 2074.29
R1364 VSS.n195 VSS.n193 2074.29
R1365 VSS.n195 VSS.n194 2074.29
R1366 VSS.n408 VSS.n131 2074.29
R1367 VSS.n408 VSS.n74 2074.29
R1368 VSS.n131 VSS.n130 2074.29
R1369 VSS.n130 VSS.n74 2074.29
R1370 VSS.n272 VSS.n270 2074.29
R1371 VSS.n272 VSS.n271 2074.29
R1372 VSS.n270 VSS.n269 2074.29
R1373 VSS.n271 VSS.n269 2074.29
R1374 VSS.n421 VSS.n101 2074.29
R1375 VSS.n421 VSS.n59 2074.29
R1376 VSS.n101 VSS.n100 2074.29
R1377 VSS.n100 VSS.n59 2074.29
R1378 VSS.n197 VSS.n196 2074.29
R1379 VSS.n198 VSS.n196 2074.29
R1380 VSS.n199 VSS.n197 2074.29
R1381 VSS.n199 VSS.n198 2074.29
R1382 VSS.n686 VSS.n129 2074.29
R1383 VSS.n686 VSS.n73 2074.29
R1384 VSS.n129 VSS.n128 2074.29
R1385 VSS.n128 VSS.n73 2074.29
R1386 VSS.n268 VSS.n266 2074.29
R1387 VSS.n268 VSS.n267 2074.29
R1388 VSS.n266 VSS.n265 2074.29
R1389 VSS.n267 VSS.n265 2074.29
R1390 VSS.n437 VSS.n103 2074.29
R1391 VSS.n437 VSS.n60 2074.29
R1392 VSS.n103 VSS.n102 2074.29
R1393 VSS.n102 VSS.n60 2074.29
R1394 VSS.n201 VSS.n200 2074.29
R1395 VSS.n202 VSS.n200 2074.29
R1396 VSS.n203 VSS.n201 2074.29
R1397 VSS.n203 VSS.n202 2074.29
R1398 VSS.n450 VSS.n127 2074.29
R1399 VSS.n450 VSS.n72 2074.29
R1400 VSS.n127 VSS.n126 2074.29
R1401 VSS.n126 VSS.n72 2074.29
R1402 VSS.n264 VSS.n262 2074.29
R1403 VSS.n264 VSS.n263 2074.29
R1404 VSS.n262 VSS.n261 2074.29
R1405 VSS.n263 VSS.n261 2074.29
R1406 VSS.n652 VSS.n105 2074.29
R1407 VSS.n652 VSS.n61 2074.29
R1408 VSS.n105 VSS.n104 2074.29
R1409 VSS.n104 VSS.n61 2074.29
R1410 VSS.n205 VSS.n204 2074.29
R1411 VSS.n206 VSS.n204 2074.29
R1412 VSS.n207 VSS.n205 2074.29
R1413 VSS.n207 VSS.n206 2074.29
R1414 VSS.n466 VSS.n125 2074.29
R1415 VSS.n466 VSS.n71 2074.29
R1416 VSS.n125 VSS.n124 2074.29
R1417 VSS.n124 VSS.n71 2074.29
R1418 VSS.n260 VSS.n258 2074.29
R1419 VSS.n260 VSS.n259 2074.29
R1420 VSS.n258 VSS.n257 2074.29
R1421 VSS.n259 VSS.n257 2074.29
R1422 VSS.n479 VSS.n107 2074.29
R1423 VSS.n479 VSS.n62 2074.29
R1424 VSS.n107 VSS.n106 2074.29
R1425 VSS.n106 VSS.n62 2074.29
R1426 VSS.n209 VSS.n208 2074.29
R1427 VSS.n210 VSS.n208 2074.29
R1428 VSS.n211 VSS.n209 2074.29
R1429 VSS.n211 VSS.n210 2074.29
R1430 VSS.n618 VSS.n123 2074.29
R1431 VSS.n618 VSS.n70 2074.29
R1432 VSS.n123 VSS.n122 2074.29
R1433 VSS.n122 VSS.n70 2074.29
R1434 VSS.n256 VSS.n254 2074.29
R1435 VSS.n256 VSS.n255 2074.29
R1436 VSS.n254 VSS.n253 2074.29
R1437 VSS.n255 VSS.n253 2074.29
R1438 VSS.n495 VSS.n109 2074.29
R1439 VSS.n495 VSS.n63 2074.29
R1440 VSS.n109 VSS.n108 2074.29
R1441 VSS.n108 VSS.n63 2074.29
R1442 VSS.n213 VSS.n212 2074.29
R1443 VSS.n214 VSS.n212 2074.29
R1444 VSS.n215 VSS.n213 2074.29
R1445 VSS.n215 VSS.n214 2074.29
R1446 VSS.n508 VSS.n121 2074.29
R1447 VSS.n508 VSS.n69 2074.29
R1448 VSS.n121 VSS.n120 2074.29
R1449 VSS.n120 VSS.n69 2074.29
R1450 VSS.n252 VSS.n250 2074.29
R1451 VSS.n252 VSS.n251 2074.29
R1452 VSS.n250 VSS.n249 2074.29
R1453 VSS.n251 VSS.n249 2074.29
R1454 VSS.n584 VSS.n111 2074.29
R1455 VSS.n584 VSS.n64 2074.29
R1456 VSS.n111 VSS.n110 2074.29
R1457 VSS.n110 VSS.n64 2074.29
R1458 VSS.n217 VSS.n216 2074.29
R1459 VSS.n218 VSS.n216 2074.29
R1460 VSS.n219 VSS.n217 2074.29
R1461 VSS.n219 VSS.n218 2074.29
R1462 VSS.n524 VSS.n119 2074.29
R1463 VSS.n524 VSS.n68 2074.29
R1464 VSS.n119 VSS.n118 2074.29
R1465 VSS.n118 VSS.n68 2074.29
R1466 VSS.n248 VSS.n246 2074.29
R1467 VSS.n248 VSS.n247 2074.29
R1468 VSS.n246 VSS.n245 2074.29
R1469 VSS.n247 VSS.n245 2074.29
R1470 VSS.n537 VSS.n113 2074.29
R1471 VSS.n537 VSS.n65 2074.29
R1472 VSS.n113 VSS.n112 2074.29
R1473 VSS.n112 VSS.n65 2074.29
R1474 VSS.n221 VSS.n220 2074.29
R1475 VSS.n222 VSS.n220 2074.29
R1476 VSS.n223 VSS.n221 2074.29
R1477 VSS.n223 VSS.n222 2074.29
R1478 VSS.n550 VSS.n117 2074.29
R1479 VSS.n550 VSS.n67 2074.29
R1480 VSS.n117 VSS.n116 2074.29
R1481 VSS.n116 VSS.n67 2074.29
R1482 VSS.n244 VSS.n242 2074.29
R1483 VSS.n244 VSS.n243 2074.29
R1484 VSS.n242 VSS.n241 2074.29
R1485 VSS.n243 VSS.n241 2074.29
R1486 VSS.n235 VSS.n115 2074.29
R1487 VSS.n235 VSS.n66 2074.29
R1488 VSS.n115 VSS.n114 2074.29
R1489 VSS.n114 VSS.n66 2074.29
R1490 VSS.n238 VSS.n237 2074.29
R1491 VSS.n239 VSS.n237 2074.29
R1492 VSS.n240 VSS.n238 2074.29
R1493 VSS.n240 VSS.n239 2074.29
R1494 VSS.n951 VSS.n950 1954.18
R1495 VSS.n953 VSS.n952 1749.69
R1496 VSS.n1010 VSS.n0 1205.7
R1497 VSS.n952 VSS.n951 977.264
R1498 VSS.n980 VSS.n979 769.809
R1499 VSS.n985 VSS.n984 743.09
R1500 VSS.n987 VSS.n986 743.09
R1501 VSS.n981 VSS.n980 689.648
R1502 VSS.n952 VSS.n0 683.298
R1503 VSS.n922 VSS.n921 563.944
R1504 VSS.n902 VSS.n151 563.944
R1505 VSS.n848 VSS.n847 563.944
R1506 VSS.n816 VSS.n815 563.944
R1507 VSS.n798 VSS.n333 563.944
R1508 VSS.n780 VSS.n779 563.944
R1509 VSS.n748 VSS.n747 563.944
R1510 VSS.n730 VSS.n391 563.944
R1511 VSS.n712 VSS.n711 563.944
R1512 VSS.n680 VSS.n679 563.944
R1513 VSS.n662 VSS.n449 563.944
R1514 VSS.n644 VSS.n643 563.944
R1515 VSS.n612 VSS.n611 563.944
R1516 VSS.n594 VSS.n507 563.944
R1517 VSS.n576 VSS.n575 563.944
R1518 VSS.n560 VSS.n536 563.944
R1519 VSS.n578 VSS.n577 563.944
R1520 VSS.n610 VSS.n609 563.944
R1521 VSS.n628 VSS.n478 563.944
R1522 VSS.n646 VSS.n645 563.944
R1523 VSS.n678 VSS.n677 563.944
R1524 VSS.n696 VSS.n420 563.944
R1525 VSS.n714 VSS.n713 563.944
R1526 VSS.n746 VSS.n745 563.944
R1527 VSS.n764 VSS.n362 563.944
R1528 VSS.n782 VSS.n781 563.944
R1529 VSS.n814 VSS.n813 563.944
R1530 VSS.n832 VSS.n304 563.944
R1531 VSS.n850 VSS.n849 563.944
R1532 VSS.n924 VSS.n923 563.944
R1533 VSS.n876 VSS.n152 563.944
R1534 VSS.n974 VSS.n973 521.067
R1535 VSS.n970 VSS.n969 521.067
R1536 VSS.n993 VSS.n9 521.067
R1537 VSS.n998 VSS.n997 521.067
R1538 VSS.n917 VSS.n149 396.62
R1539 VSS.n901 VSS.n148 396.62
R1540 VSS.n843 VSS.n299 396.62
R1541 VSS.n821 VSS.n820 396.62
R1542 VSS.n797 VSS.n796 396.62
R1543 VSS.n775 VSS.n348 396.62
R1544 VSS.n753 VSS.n752 396.62
R1545 VSS.n729 VSS.n728 396.62
R1546 VSS.n707 VSS.n406 396.62
R1547 VSS.n685 VSS.n684 396.62
R1548 VSS.n661 VSS.n660 396.62
R1549 VSS.n639 VSS.n464 396.62
R1550 VSS.n617 VSS.n616 396.62
R1551 VSS.n593 VSS.n592 396.62
R1552 VSS.n571 VSS.n522 396.62
R1553 VSS.n559 VSS.n558 396.62
R1554 VSS.n583 VSS.n582 396.62
R1555 VSS.n605 VSS.n493 396.62
R1556 VSS.n627 VSS.n626 396.62
R1557 VSS.n651 VSS.n650 396.62
R1558 VSS.n673 VSS.n435 396.62
R1559 VSS.n695 VSS.n694 396.62
R1560 VSS.n719 VSS.n718 396.62
R1561 VSS.n741 VSS.n377 396.62
R1562 VSS.n763 VSS.n762 396.62
R1563 VSS.n787 VSS.n786 396.62
R1564 VSS.n809 VSS.n319 396.62
R1565 VSS.n831 VSS.n830 396.62
R1566 VSS.n855 VSS.n854 396.62
R1567 VSS.n929 VSS.n928 396.62
R1568 VSS.n881 VSS.n880 396.62
R1569 VSS.n228 VSS.n16 367.491
R1570 VSS.t75 VSS.n20 326.385
R1571 VSS.t75 VSS.n161 326.385
R1572 VSS.n917 VSS.t79 326.385
R1573 VSS.n921 VSS.t79 326.385
R1574 VSS.t33 VSS.n21 326.385
R1575 VSS.t33 VSS.n893 326.385
R1576 VSS.t103 VSS.n901 326.385
R1577 VSS.t103 VSS.n902 326.385
R1578 VSS.t129 VSS.n22 326.385
R1579 VSS.t129 VSS.n309 326.385
R1580 VSS.n843 VSS.t57 326.385
R1581 VSS.n847 VSS.t57 326.385
R1582 VSS.t37 VSS.n23 326.385
R1583 VSS.t37 VSS.n320 326.385
R1584 VSS.n820 VSS.t71 326.385
R1585 VSS.n816 VSS.t71 326.385
R1586 VSS.t61 VSS.n24 326.385
R1587 VSS.n795 VSS.t61 326.385
R1588 VSS.t29 VSS.n797 326.385
R1589 VSS.t29 VSS.n798 326.385
R1590 VSS.t134 VSS.n25 326.385
R1591 VSS.t134 VSS.n367 326.385
R1592 VSS.n775 VSS.t107 326.385
R1593 VSS.n779 VSS.t107 326.385
R1594 VSS.t109 VSS.n26 326.385
R1595 VSS.t109 VSS.n378 326.385
R1596 VSS.n752 VSS.t131 326.385
R1597 VSS.n748 VSS.t131 326.385
R1598 VSS.t105 VSS.n27 326.385
R1599 VSS.n727 VSS.t105 326.385
R1600 VSS.t93 VSS.n729 326.385
R1601 VSS.t93 VSS.n730 326.385
R1602 VSS.t39 VSS.n28 326.385
R1603 VSS.t39 VSS.n425 326.385
R1604 VSS.n707 VSS.t7 326.385
R1605 VSS.n711 VSS.t7 326.385
R1606 VSS.t13 VSS.n29 326.385
R1607 VSS.t13 VSS.n436 326.385
R1608 VSS.n684 VSS.t17 326.385
R1609 VSS.n680 VSS.t17 326.385
R1610 VSS.t95 VSS.n30 326.385
R1611 VSS.n659 VSS.t95 326.385
R1612 VSS.t53 VSS.n661 326.385
R1613 VSS.t53 VSS.n662 326.385
R1614 VSS.t67 VSS.n31 326.385
R1615 VSS.t67 VSS.n483 326.385
R1616 VSS.n639 VSS.t127 326.385
R1617 VSS.n643 VSS.t127 326.385
R1618 VSS.t91 VSS.n32 326.385
R1619 VSS.t91 VSS.n494 326.385
R1620 VSS.n616 VSS.t49 326.385
R1621 VSS.n612 VSS.t49 326.385
R1622 VSS.t123 VSS.n33 326.385
R1623 VSS.n591 VSS.t123 326.385
R1624 VSS.t45 VSS.n593 326.385
R1625 VSS.t45 VSS.n594 326.385
R1626 VSS.t65 VSS.n34 326.385
R1627 VSS.t65 VSS.n541 326.385
R1628 VSS.n571 VSS.t0 326.385
R1629 VSS.n575 VSS.t0 326.385
R1630 VSS.t23 VSS.n35 326.385
R1631 VSS.n557 VSS.t23 326.385
R1632 VSS.t77 VSS.n559 326.385
R1633 VSS.t77 VSS.n560 326.385
R1634 VSS.t15 VSS.n36 326.385
R1635 VSS.t15 VSS.n523 326.385
R1636 VSS.n582 VSS.t121 326.385
R1637 VSS.n578 VSS.t121 326.385
R1638 VSS.t21 VSS.n37 326.385
R1639 VSS.t21 VSS.n512 326.385
R1640 VSS.n605 VSS.t47 326.385
R1641 VSS.n609 VSS.t47 326.385
R1642 VSS.t25 VSS.n38 326.385
R1643 VSS.n625 VSS.t25 326.385
R1644 VSS.t125 VSS.n627 326.385
R1645 VSS.t125 VSS.n628 326.385
R1646 VSS.t69 VSS.n39 326.385
R1647 VSS.t69 VSS.n465 326.385
R1648 VSS.n650 VSS.t2 326.385
R1649 VSS.n646 VSS.t2 326.385
R1650 VSS.t27 VSS.n40 326.385
R1651 VSS.t27 VSS.n454 326.385
R1652 VSS.n673 VSS.t55 326.385
R1653 VSS.n677 VSS.t55 326.385
R1654 VSS.t11 VSS.n41 326.385
R1655 VSS.n693 VSS.t11 326.385
R1656 VSS.t19 VSS.n695 326.385
R1657 VSS.t19 VSS.n696 326.385
R1658 VSS.t63 VSS.n42 326.385
R1659 VSS.t63 VSS.n407 326.385
R1660 VSS.n718 VSS.t89 326.385
R1661 VSS.n714 VSS.t89 326.385
R1662 VSS.t87 VSS.n43 326.385
R1663 VSS.t87 VSS.n396 326.385
R1664 VSS.n741 VSS.t99 326.385
R1665 VSS.n745 VSS.t99 326.385
R1666 VSS.t111 VSS.n44 326.385
R1667 VSS.n761 VSS.t111 326.385
R1668 VSS.t118 VSS.n763 326.385
R1669 VSS.t118 VSS.n764 326.385
R1670 VSS.t97 VSS.n45 326.385
R1671 VSS.t97 VSS.n349 326.385
R1672 VSS.n786 VSS.t59 326.385
R1673 VSS.n782 VSS.t59 326.385
R1674 VSS.t51 VSS.n46 326.385
R1675 VSS.t51 VSS.n338 326.385
R1676 VSS.n809 VSS.t101 326.385
R1677 VSS.n813 VSS.t101 326.385
R1678 VSS.t85 VSS.n47 326.385
R1679 VSS.n829 VSS.t85 326.385
R1680 VSS.t9 VSS.n831 326.385
R1681 VSS.t9 VSS.n832 326.385
R1682 VSS.t31 VSS.n48 326.385
R1683 VSS.t31 VSS.n856 326.385
R1684 VSS.n854 VSS.t41 326.385
R1685 VSS.n850 VSS.t41 326.385
R1686 VSS.t35 VSS.n49 326.385
R1687 VSS.t35 VSS.n930 326.385
R1688 VSS.n928 VSS.t73 326.385
R1689 VSS.n924 VSS.t73 326.385
R1690 VSS.t81 VSS.n50 326.385
R1691 VSS.t81 VSS.n882 326.385
R1692 VSS.n880 VSS.t83 326.385
R1693 VSS.n876 VSS.t83 326.385
R1694 VSS.n227 VSS.n17 316.406
R1695 VSS.n943 VSS.n20 316.057
R1696 VSS.n943 VSS.n21 316.057
R1697 VSS.n943 VSS.n22 316.057
R1698 VSS.n943 VSS.n23 316.057
R1699 VSS.n943 VSS.n24 316.057
R1700 VSS.n943 VSS.n25 316.057
R1701 VSS.n943 VSS.n26 316.057
R1702 VSS.n943 VSS.n27 316.057
R1703 VSS.n943 VSS.n28 316.057
R1704 VSS.n943 VSS.n29 316.057
R1705 VSS.n943 VSS.n30 316.057
R1706 VSS.n943 VSS.n31 316.057
R1707 VSS.n943 VSS.n32 316.057
R1708 VSS.n943 VSS.n33 316.057
R1709 VSS.n943 VSS.n34 316.057
R1710 VSS.n943 VSS.n35 316.057
R1711 VSS.n943 VSS.n36 316.057
R1712 VSS.n943 VSS.n37 316.057
R1713 VSS.n943 VSS.n38 316.057
R1714 VSS.n943 VSS.n39 316.057
R1715 VSS.n943 VSS.n40 316.057
R1716 VSS.n943 VSS.n41 316.057
R1717 VSS.n943 VSS.n42 316.057
R1718 VSS.n943 VSS.n43 316.057
R1719 VSS.n943 VSS.n44 316.057
R1720 VSS.n943 VSS.n45 316.057
R1721 VSS.n943 VSS.n46 316.057
R1722 VSS.n943 VSS.n47 316.057
R1723 VSS.n943 VSS.n48 316.057
R1724 VSS.n943 VSS.n49 316.057
R1725 VSS.n943 VSS.n50 316.057
R1726 VSS.n958 VSS.n954 306.122
R1727 VSS.n962 VSS.n8 305.971
R1728 VSS.n965 VSS.n964 305.625
R1729 VSS.n961 VSS.n7 305.521
R1730 VSS.n959 VSS.n955 305.486
R1731 VSS.n237 VSS.n236 305.445
R1732 VSS.n551 VSS.n244 305.445
R1733 VSS.n538 VSS.n220 305.445
R1734 VSS.n525 VSS.n248 305.445
R1735 VSS.n585 VSS.n216 305.445
R1736 VSS.n509 VSS.n252 305.445
R1737 VSS.n496 VSS.n212 305.445
R1738 VSS.n619 VSS.n256 305.445
R1739 VSS.n480 VSS.n208 305.445
R1740 VSS.n467 VSS.n260 305.445
R1741 VSS.n653 VSS.n204 305.445
R1742 VSS.n451 VSS.n264 305.445
R1743 VSS.n438 VSS.n200 305.445
R1744 VSS.n687 VSS.n268 305.445
R1745 VSS.n422 VSS.n196 305.445
R1746 VSS.n409 VSS.n272 305.445
R1747 VSS.n721 VSS.n192 305.445
R1748 VSS.n393 VSS.n276 305.445
R1749 VSS.n380 VSS.n188 305.445
R1750 VSS.n755 VSS.n280 305.445
R1751 VSS.n364 VSS.n184 305.445
R1752 VSS.n351 VSS.n284 305.445
R1753 VSS.n789 VSS.n180 305.445
R1754 VSS.n335 VSS.n288 305.445
R1755 VSS.n322 VSS.n176 305.445
R1756 VSS.n823 VSS.n292 305.445
R1757 VSS.n306 VSS.n172 305.445
R1758 VSS.n862 VSS.n861 305.445
R1759 VSS.n890 VSS.n888 305.445
R1760 VSS.n934 VSS.n144 305.445
R1761 VSS.n167 VSS.n166 305.445
R1762 VSS.n887 VSS.n886 305.445
R1763 VSS.n12 VSS.n11 305.411
R1764 VSS.n236 VSS.n235 304.949
R1765 VSS.n551 VSS.n550 304.949
R1766 VSS.n538 VSS.n537 304.949
R1767 VSS.n525 VSS.n524 304.949
R1768 VSS.n585 VSS.n584 304.949
R1769 VSS.n509 VSS.n508 304.949
R1770 VSS.n496 VSS.n495 304.949
R1771 VSS.n619 VSS.n618 304.949
R1772 VSS.n480 VSS.n479 304.949
R1773 VSS.n467 VSS.n466 304.949
R1774 VSS.n653 VSS.n652 304.949
R1775 VSS.n451 VSS.n450 304.949
R1776 VSS.n438 VSS.n437 304.949
R1777 VSS.n687 VSS.n686 304.949
R1778 VSS.n422 VSS.n421 304.949
R1779 VSS.n409 VSS.n408 304.949
R1780 VSS.n721 VSS.n720 304.949
R1781 VSS.n393 VSS.n392 304.949
R1782 VSS.n380 VSS.n379 304.949
R1783 VSS.n755 VSS.n754 304.949
R1784 VSS.n364 VSS.n363 304.949
R1785 VSS.n351 VSS.n350 304.949
R1786 VSS.n789 VSS.n788 304.949
R1787 VSS.n335 VSS.n334 304.949
R1788 VSS.n322 VSS.n321 304.949
R1789 VSS.n823 VSS.n822 304.949
R1790 VSS.n306 VSS.n305 304.949
R1791 VSS.n861 VSS.n860 304.949
R1792 VSS.n890 VSS.n889 304.949
R1793 VSS.n935 VSS.n934 304.949
R1794 VSS.n166 VSS.n165 304.949
R1795 VSS.n886 VSS.n82 304.949
R1796 VSS.n991 VSS.n3 304.697
R1797 VSS.n1006 VSS.n1005 304.697
R1798 VSS.n916 VSS.n915 304.048
R1799 VSS.n905 VSS.n904 304.048
R1800 VSS.n842 VSS.n841 304.048
R1801 VSS.n332 VSS.n331 304.048
R1802 VSS.n801 VSS.n800 304.048
R1803 VSS.n774 VSS.n773 304.048
R1804 VSS.n390 VSS.n389 304.048
R1805 VSS.n733 VSS.n732 304.048
R1806 VSS.n706 VSS.n705 304.048
R1807 VSS.n448 VSS.n447 304.048
R1808 VSS.n665 VSS.n664 304.048
R1809 VSS.n638 VSS.n637 304.048
R1810 VSS.n506 VSS.n505 304.048
R1811 VSS.n597 VSS.n596 304.048
R1812 VSS.n570 VSS.n569 304.048
R1813 VSS.n231 VSS.n230 304.048
R1814 VSS.n563 VSS.n562 304.048
R1815 VSS.n535 VSS.n534 304.048
R1816 VSS.n604 VSS.n603 304.048
R1817 VSS.n631 VSS.n630 304.048
R1818 VSS.n477 VSS.n476 304.048
R1819 VSS.n672 VSS.n671 304.048
R1820 VSS.n699 VSS.n698 304.048
R1821 VSS.n419 VSS.n418 304.048
R1822 VSS.n740 VSS.n739 304.048
R1823 VSS.n767 VSS.n766 304.048
R1824 VSS.n361 VSS.n360 304.048
R1825 VSS.n808 VSS.n807 304.048
R1826 VSS.n835 VSS.n834 304.048
R1827 VSS.n303 VSS.n302 304.048
R1828 VSS.n909 VSS.n150 304.048
R1829 VSS.n875 VSS.n874 304.048
R1830 VSS.n885 VSS.n884 303.976
R1831 VSS.n933 VSS.n932 303.976
R1832 VSS.n859 VSS.n858 303.976
R1833 VSS.n825 VSS.n824 303.976
R1834 VSS.n341 VSS.n340 303.976
R1835 VSS.n356 VSS.n355 303.976
R1836 VSS.n757 VSS.n756 303.976
R1837 VSS.n399 VSS.n398 303.976
R1838 VSS.n414 VSS.n413 303.976
R1839 VSS.n689 VSS.n688 303.976
R1840 VSS.n457 VSS.n456 303.976
R1841 VSS.n472 VSS.n471 303.976
R1842 VSS.n621 VSS.n620 303.976
R1843 VSS.n515 VSS.n514 303.976
R1844 VSS.n530 VSS.n529 303.976
R1845 VSS.n553 VSS.n552 303.976
R1846 VSS.n234 VSS.n18 303.976
R1847 VSS.n544 VSS.n543 303.976
R1848 VSS.n587 VSS.n586 303.976
R1849 VSS.n501 VSS.n500 303.976
R1850 VSS.n486 VSS.n485 303.976
R1851 VSS.n655 VSS.n654 303.976
R1852 VSS.n443 VSS.n442 303.976
R1853 VSS.n428 VSS.n427 303.976
R1854 VSS.n723 VSS.n722 303.976
R1855 VSS.n385 VSS.n384 303.976
R1856 VSS.n370 VSS.n369 303.976
R1857 VSS.n791 VSS.n790 303.976
R1858 VSS.n327 VSS.n326 303.976
R1859 VSS.n312 VSS.n311 303.976
R1860 VSS.n896 VSS.n895 303.976
R1861 VSS.n164 VSS.n163 303.976
R1862 VSS.t75 VSS.n162 292.5
R1863 VSS.n163 VSS.t75 292.5
R1864 VSS.n919 VSS.t79 292.5
R1865 VSS.n916 VSS.t79 292.5
R1866 VSS.t33 VSS.n894 292.5
R1867 VSS.n895 VSS.t33 292.5
R1868 VSS.t103 VSS.n903 292.5
R1869 VSS.n904 VSS.t103 292.5
R1870 VSS.t129 VSS.n310 292.5
R1871 VSS.n311 VSS.t129 292.5
R1872 VSS.n845 VSS.t57 292.5
R1873 VSS.n842 VSS.t57 292.5
R1874 VSS.t37 VSS.n325 292.5
R1875 VSS.n326 VSS.t37 292.5
R1876 VSS.n818 VSS.t71 292.5
R1877 VSS.n332 VSS.t71 292.5
R1878 VSS.n793 VSS.t61 292.5
R1879 VSS.n791 VSS.t61 292.5
R1880 VSS.t29 VSS.n799 292.5
R1881 VSS.n800 VSS.t29 292.5
R1882 VSS.t134 VSS.n368 292.5
R1883 VSS.n369 VSS.t134 292.5
R1884 VSS.n777 VSS.t107 292.5
R1885 VSS.n774 VSS.t107 292.5
R1886 VSS.t109 VSS.n383 292.5
R1887 VSS.n384 VSS.t109 292.5
R1888 VSS.n750 VSS.t131 292.5
R1889 VSS.n390 VSS.t131 292.5
R1890 VSS.n725 VSS.t105 292.5
R1891 VSS.n723 VSS.t105 292.5
R1892 VSS.t93 VSS.n731 292.5
R1893 VSS.n732 VSS.t93 292.5
R1894 VSS.t39 VSS.n426 292.5
R1895 VSS.n427 VSS.t39 292.5
R1896 VSS.n709 VSS.t7 292.5
R1897 VSS.n706 VSS.t7 292.5
R1898 VSS.t13 VSS.n441 292.5
R1899 VSS.n442 VSS.t13 292.5
R1900 VSS.n682 VSS.t17 292.5
R1901 VSS.n448 VSS.t17 292.5
R1902 VSS.n657 VSS.t95 292.5
R1903 VSS.n655 VSS.t95 292.5
R1904 VSS.t53 VSS.n663 292.5
R1905 VSS.n664 VSS.t53 292.5
R1906 VSS.t67 VSS.n484 292.5
R1907 VSS.n485 VSS.t67 292.5
R1908 VSS.n641 VSS.t127 292.5
R1909 VSS.n638 VSS.t127 292.5
R1910 VSS.t91 VSS.n499 292.5
R1911 VSS.n500 VSS.t91 292.5
R1912 VSS.n614 VSS.t49 292.5
R1913 VSS.n506 VSS.t49 292.5
R1914 VSS.n589 VSS.t123 292.5
R1915 VSS.n587 VSS.t123 292.5
R1916 VSS.t45 VSS.n595 292.5
R1917 VSS.n596 VSS.t45 292.5
R1918 VSS.t65 VSS.n542 292.5
R1919 VSS.n543 VSS.t65 292.5
R1920 VSS.n573 VSS.t0 292.5
R1921 VSS.n570 VSS.t0 292.5
R1922 VSS.n946 VSS.t4 292.5
R1923 VSS.n18 VSS.t4 292.5
R1924 VSS.t43 VSS.n229 292.5
R1925 VSS.n230 VSS.t43 292.5
R1926 VSS.n555 VSS.t23 292.5
R1927 VSS.n553 VSS.t23 292.5
R1928 VSS.t77 VSS.n561 292.5
R1929 VSS.n562 VSS.t77 292.5
R1930 VSS.t15 VSS.n528 292.5
R1931 VSS.n529 VSS.t15 292.5
R1932 VSS.n580 VSS.t121 292.5
R1933 VSS.n535 VSS.t121 292.5
R1934 VSS.t21 VSS.n513 292.5
R1935 VSS.n514 VSS.t21 292.5
R1936 VSS.n607 VSS.t47 292.5
R1937 VSS.n604 VSS.t47 292.5
R1938 VSS.n623 VSS.t25 292.5
R1939 VSS.n621 VSS.t25 292.5
R1940 VSS.t125 VSS.n629 292.5
R1941 VSS.n630 VSS.t125 292.5
R1942 VSS.t69 VSS.n470 292.5
R1943 VSS.n471 VSS.t69 292.5
R1944 VSS.n648 VSS.t2 292.5
R1945 VSS.n477 VSS.t2 292.5
R1946 VSS.t27 VSS.n455 292.5
R1947 VSS.n456 VSS.t27 292.5
R1948 VSS.n675 VSS.t55 292.5
R1949 VSS.n672 VSS.t55 292.5
R1950 VSS.n691 VSS.t11 292.5
R1951 VSS.n689 VSS.t11 292.5
R1952 VSS.t19 VSS.n697 292.5
R1953 VSS.n698 VSS.t19 292.5
R1954 VSS.t63 VSS.n412 292.5
R1955 VSS.n413 VSS.t63 292.5
R1956 VSS.n716 VSS.t89 292.5
R1957 VSS.n419 VSS.t89 292.5
R1958 VSS.t87 VSS.n397 292.5
R1959 VSS.n398 VSS.t87 292.5
R1960 VSS.n743 VSS.t99 292.5
R1961 VSS.n740 VSS.t99 292.5
R1962 VSS.n759 VSS.t111 292.5
R1963 VSS.n757 VSS.t111 292.5
R1964 VSS.t118 VSS.n765 292.5
R1965 VSS.n766 VSS.t118 292.5
R1966 VSS.t97 VSS.n354 292.5
R1967 VSS.n355 VSS.t97 292.5
R1968 VSS.n784 VSS.t59 292.5
R1969 VSS.n361 VSS.t59 292.5
R1970 VSS.t51 VSS.n339 292.5
R1971 VSS.n340 VSS.t51 292.5
R1972 VSS.n811 VSS.t101 292.5
R1973 VSS.n808 VSS.t101 292.5
R1974 VSS.n827 VSS.t85 292.5
R1975 VSS.n825 VSS.t85 292.5
R1976 VSS.t9 VSS.n833 292.5
R1977 VSS.n834 VSS.t9 292.5
R1978 VSS.t31 VSS.n857 292.5
R1979 VSS.n858 VSS.t31 292.5
R1980 VSS.n852 VSS.t41 292.5
R1981 VSS.n303 VSS.t41 292.5
R1982 VSS.t35 VSS.n931 292.5
R1983 VSS.n932 VSS.t35 292.5
R1984 VSS.n926 VSS.t73 292.5
R1985 VSS.n150 VSS.t73 292.5
R1986 VSS.t81 VSS.n883 292.5
R1987 VSS.n884 VSS.t81 292.5
R1988 VSS.n878 VSS.t83 292.5
R1989 VSS.n875 VSS.t83 292.5
R1990 VSS.t114 VSS.n240 292.5
R1991 VSS.t114 VSS.n237 292.5
R1992 VSS.n114 VSS.t113 292.5
R1993 VSS.n235 VSS.t113 292.5
R1994 VSS.t114 VSS.n241 292.5
R1995 VSS.t114 VSS.n244 292.5
R1996 VSS.n116 VSS.t113 292.5
R1997 VSS.n550 VSS.t113 292.5
R1998 VSS.t114 VSS.n223 292.5
R1999 VSS.t114 VSS.n220 292.5
R2000 VSS.n112 VSS.t113 292.5
R2001 VSS.n537 VSS.t113 292.5
R2002 VSS.t114 VSS.n245 292.5
R2003 VSS.t114 VSS.n248 292.5
R2004 VSS.n118 VSS.t113 292.5
R2005 VSS.n524 VSS.t113 292.5
R2006 VSS.t114 VSS.n219 292.5
R2007 VSS.t114 VSS.n216 292.5
R2008 VSS.n110 VSS.t113 292.5
R2009 VSS.n584 VSS.t113 292.5
R2010 VSS.t114 VSS.n249 292.5
R2011 VSS.t114 VSS.n252 292.5
R2012 VSS.n120 VSS.t113 292.5
R2013 VSS.n508 VSS.t113 292.5
R2014 VSS.t114 VSS.n215 292.5
R2015 VSS.t114 VSS.n212 292.5
R2016 VSS.n108 VSS.t113 292.5
R2017 VSS.n495 VSS.t113 292.5
R2018 VSS.t114 VSS.n253 292.5
R2019 VSS.t114 VSS.n256 292.5
R2020 VSS.n122 VSS.t113 292.5
R2021 VSS.n618 VSS.t113 292.5
R2022 VSS.t114 VSS.n211 292.5
R2023 VSS.t114 VSS.n208 292.5
R2024 VSS.n106 VSS.t113 292.5
R2025 VSS.n479 VSS.t113 292.5
R2026 VSS.t114 VSS.n257 292.5
R2027 VSS.t114 VSS.n260 292.5
R2028 VSS.n124 VSS.t113 292.5
R2029 VSS.n466 VSS.t113 292.5
R2030 VSS.t114 VSS.n207 292.5
R2031 VSS.t114 VSS.n204 292.5
R2032 VSS.n104 VSS.t113 292.5
R2033 VSS.n652 VSS.t113 292.5
R2034 VSS.t114 VSS.n261 292.5
R2035 VSS.t114 VSS.n264 292.5
R2036 VSS.n126 VSS.t113 292.5
R2037 VSS.n450 VSS.t113 292.5
R2038 VSS.t114 VSS.n203 292.5
R2039 VSS.t114 VSS.n200 292.5
R2040 VSS.n102 VSS.t113 292.5
R2041 VSS.n437 VSS.t113 292.5
R2042 VSS.t114 VSS.n265 292.5
R2043 VSS.t114 VSS.n268 292.5
R2044 VSS.n128 VSS.t113 292.5
R2045 VSS.n686 VSS.t113 292.5
R2046 VSS.t114 VSS.n199 292.5
R2047 VSS.t114 VSS.n196 292.5
R2048 VSS.n100 VSS.t113 292.5
R2049 VSS.n421 VSS.t113 292.5
R2050 VSS.t114 VSS.n269 292.5
R2051 VSS.t114 VSS.n272 292.5
R2052 VSS.n130 VSS.t113 292.5
R2053 VSS.n408 VSS.t113 292.5
R2054 VSS.t114 VSS.n195 292.5
R2055 VSS.t114 VSS.n192 292.5
R2056 VSS.n98 VSS.t113 292.5
R2057 VSS.n720 VSS.t113 292.5
R2058 VSS.t114 VSS.n273 292.5
R2059 VSS.t114 VSS.n276 292.5
R2060 VSS.n132 VSS.t113 292.5
R2061 VSS.n392 VSS.t113 292.5
R2062 VSS.t114 VSS.n191 292.5
R2063 VSS.t114 VSS.n188 292.5
R2064 VSS.n96 VSS.t113 292.5
R2065 VSS.n379 VSS.t113 292.5
R2066 VSS.t114 VSS.n277 292.5
R2067 VSS.t114 VSS.n280 292.5
R2068 VSS.n134 VSS.t113 292.5
R2069 VSS.n754 VSS.t113 292.5
R2070 VSS.t114 VSS.n187 292.5
R2071 VSS.t114 VSS.n184 292.5
R2072 VSS.n94 VSS.t113 292.5
R2073 VSS.n363 VSS.t113 292.5
R2074 VSS.t114 VSS.n281 292.5
R2075 VSS.t114 VSS.n284 292.5
R2076 VSS.n136 VSS.t113 292.5
R2077 VSS.n350 VSS.t113 292.5
R2078 VSS.t114 VSS.n183 292.5
R2079 VSS.t114 VSS.n180 292.5
R2080 VSS.n92 VSS.t113 292.5
R2081 VSS.n788 VSS.t113 292.5
R2082 VSS.t114 VSS.n285 292.5
R2083 VSS.t114 VSS.n288 292.5
R2084 VSS.n138 VSS.t113 292.5
R2085 VSS.n334 VSS.t113 292.5
R2086 VSS.t114 VSS.n179 292.5
R2087 VSS.t114 VSS.n176 292.5
R2088 VSS.n90 VSS.t113 292.5
R2089 VSS.n321 VSS.t113 292.5
R2090 VSS.t114 VSS.n289 292.5
R2091 VSS.t114 VSS.n292 292.5
R2092 VSS.n140 VSS.t113 292.5
R2093 VSS.n822 VSS.t113 292.5
R2094 VSS.t114 VSS.n175 292.5
R2095 VSS.t114 VSS.n172 292.5
R2096 VSS.n88 VSS.t113 292.5
R2097 VSS.n305 VSS.t113 292.5
R2098 VSS.t114 VSS.n293 292.5
R2099 VSS.t114 VSS.n862 292.5
R2100 VSS.n142 VSS.t113 292.5
R2101 VSS.n860 VSS.t113 292.5
R2102 VSS.t114 VSS.n171 292.5
R2103 VSS.n888 VSS.t114 292.5
R2104 VSS.n86 VSS.t113 292.5
R2105 VSS.n889 VSS.t113 292.5
R2106 VSS.t114 VSS.n865 292.5
R2107 VSS.t114 VSS.n144 292.5
R2108 VSS.n936 VSS.t113 292.5
R2109 VSS.n935 VSS.t113 292.5
R2110 VSS.t114 VSS.n170 292.5
R2111 VSS.t114 VSS.n167 292.5
R2112 VSS.n84 VSS.t113 292.5
R2113 VSS.n165 VSS.t113 292.5
R2114 VSS.t114 VSS.n866 292.5
R2115 VSS.t114 VSS.n887 292.5
R2116 VSS.n940 VSS.t113 292.5
R2117 VSS.n82 VSS.t113 292.5
R2118 VSS.n982 VSS.t116 292.5
R2119 VSS.t116 VSS.n12 292.5
R2120 VSS.t6 VSS.n988 292.5
R2121 VSS.t6 VSS.n991 292.5
R2122 VSS.t120 VSS.n1004 292.5
R2123 VSS.n1005 VSS.t120 292.5
R2124 VSS.n971 VSS.t133 292.5
R2125 VSS.t133 VSS.n955 292.5
R2126 VSS.n967 VSS.t138 292.5
R2127 VSS.t138 VSS.n965 292.5
R2128 VSS.n1000 VSS.t136 292.5
R2129 VSS.n7 VSS.t136 292.5
R2130 VSS.n995 VSS.t115 292.5
R2131 VSS.n8 VSS.t115 292.5
R2132 VSS.n976 VSS.t140 292.5
R2133 VSS.n954 VSS.t140 292.5
R2134 VSS.n944 VSS.t4 260.375
R2135 VSS.t43 VSS.n227 260.375
R2136 VSS.t43 VSS.n228 260.375
R2137 VSS.n944 VSS.n943 252.136
R2138 VSS.t116 VSS.n981 201.042
R2139 VSS.t6 VSS.n985 201.042
R2140 VSS.t6 VSS.n987 201.042
R2141 VSS.t120 VSS.n1003 201.042
R2142 VSS.n161 VSS.n149 190.048
R2143 VSS.n893 VSS.n148 190.048
R2144 VSS.n309 VSS.n299 190.048
R2145 VSS.n821 VSS.n320 190.048
R2146 VSS.n796 VSS.n795 190.048
R2147 VSS.n367 VSS.n348 190.048
R2148 VSS.n753 VSS.n378 190.048
R2149 VSS.n728 VSS.n727 190.048
R2150 VSS.n425 VSS.n406 190.048
R2151 VSS.n685 VSS.n436 190.048
R2152 VSS.n660 VSS.n659 190.048
R2153 VSS.n483 VSS.n464 190.048
R2154 VSS.n617 VSS.n494 190.048
R2155 VSS.n592 VSS.n591 190.048
R2156 VSS.n541 VSS.n522 190.048
R2157 VSS.n558 VSS.n557 190.048
R2158 VSS.n583 VSS.n523 190.048
R2159 VSS.n512 VSS.n493 190.048
R2160 VSS.n626 VSS.n625 190.048
R2161 VSS.n651 VSS.n465 190.048
R2162 VSS.n454 VSS.n435 190.048
R2163 VSS.n694 VSS.n693 190.048
R2164 VSS.n719 VSS.n407 190.048
R2165 VSS.n396 VSS.n377 190.048
R2166 VSS.n762 VSS.n761 190.048
R2167 VSS.n787 VSS.n349 190.048
R2168 VSS.n338 VSS.n319 190.048
R2169 VSS.n830 VSS.n829 190.048
R2170 VSS.n856 VSS.n855 190.048
R2171 VSS.n930 VSS.n929 190.048
R2172 VSS.n882 VSS.n881 190.048
R2173 VSS.n986 VSS.n6 176.865
R2174 VSS.n978 VSS.t140 170.101
R2175 VSS.n974 VSS.t140 170.101
R2176 VSS.t133 VSS.n970 170.101
R2177 VSS.t138 VSS.n9 170.101
R2178 VSS.n997 VSS.t115 170.101
R2179 VSS.n998 VSS.t136 170.101
R2180 VSS.n1002 VSS.t136 170.101
R2181 VSS.n949 VSS.t4 164.794
R2182 VSS.n948 VSS.n17 151.611
R2183 VSS.n239 VSS.n83 146.25
R2184 VSS.n238 VSS.n158 146.25
R2185 VSS.n942 VSS.n66 146.25
R2186 VSS.n938 VSS.n115 146.25
R2187 VSS.n243 VSS.n83 146.25
R2188 VSS.n242 VSS.n158 146.25
R2189 VSS.n942 VSS.n67 146.25
R2190 VSS.n938 VSS.n117 146.25
R2191 VSS.n222 VSS.n83 146.25
R2192 VSS.n221 VSS.n158 146.25
R2193 VSS.n942 VSS.n65 146.25
R2194 VSS.n938 VSS.n113 146.25
R2195 VSS.n247 VSS.n83 146.25
R2196 VSS.n246 VSS.n158 146.25
R2197 VSS.n942 VSS.n68 146.25
R2198 VSS.n938 VSS.n119 146.25
R2199 VSS.n218 VSS.n83 146.25
R2200 VSS.n217 VSS.n158 146.25
R2201 VSS.n942 VSS.n64 146.25
R2202 VSS.n938 VSS.n111 146.25
R2203 VSS.n251 VSS.n83 146.25
R2204 VSS.n250 VSS.n158 146.25
R2205 VSS.n942 VSS.n69 146.25
R2206 VSS.n938 VSS.n121 146.25
R2207 VSS.n214 VSS.n83 146.25
R2208 VSS.n213 VSS.n158 146.25
R2209 VSS.n942 VSS.n63 146.25
R2210 VSS.n938 VSS.n109 146.25
R2211 VSS.n255 VSS.n83 146.25
R2212 VSS.n254 VSS.n158 146.25
R2213 VSS.n942 VSS.n70 146.25
R2214 VSS.n938 VSS.n123 146.25
R2215 VSS.n210 VSS.n83 146.25
R2216 VSS.n209 VSS.n158 146.25
R2217 VSS.n942 VSS.n62 146.25
R2218 VSS.n938 VSS.n107 146.25
R2219 VSS.n259 VSS.n83 146.25
R2220 VSS.n258 VSS.n158 146.25
R2221 VSS.n942 VSS.n71 146.25
R2222 VSS.n938 VSS.n125 146.25
R2223 VSS.n206 VSS.n83 146.25
R2224 VSS.n205 VSS.n158 146.25
R2225 VSS.n942 VSS.n61 146.25
R2226 VSS.n938 VSS.n105 146.25
R2227 VSS.n263 VSS.n83 146.25
R2228 VSS.n262 VSS.n158 146.25
R2229 VSS.n942 VSS.n72 146.25
R2230 VSS.n938 VSS.n127 146.25
R2231 VSS.n202 VSS.n83 146.25
R2232 VSS.n201 VSS.n158 146.25
R2233 VSS.n942 VSS.n60 146.25
R2234 VSS.n938 VSS.n103 146.25
R2235 VSS.n267 VSS.n83 146.25
R2236 VSS.n266 VSS.n158 146.25
R2237 VSS.n942 VSS.n73 146.25
R2238 VSS.n938 VSS.n129 146.25
R2239 VSS.n198 VSS.n83 146.25
R2240 VSS.n197 VSS.n158 146.25
R2241 VSS.n942 VSS.n59 146.25
R2242 VSS.n938 VSS.n101 146.25
R2243 VSS.n271 VSS.n83 146.25
R2244 VSS.n270 VSS.n158 146.25
R2245 VSS.n942 VSS.n74 146.25
R2246 VSS.n938 VSS.n131 146.25
R2247 VSS.n194 VSS.n83 146.25
R2248 VSS.n193 VSS.n158 146.25
R2249 VSS.n942 VSS.n58 146.25
R2250 VSS.n938 VSS.n99 146.25
R2251 VSS.n275 VSS.n83 146.25
R2252 VSS.n274 VSS.n158 146.25
R2253 VSS.n942 VSS.n75 146.25
R2254 VSS.n938 VSS.n133 146.25
R2255 VSS.n190 VSS.n83 146.25
R2256 VSS.n189 VSS.n158 146.25
R2257 VSS.n942 VSS.n57 146.25
R2258 VSS.n938 VSS.n97 146.25
R2259 VSS.n279 VSS.n83 146.25
R2260 VSS.n278 VSS.n158 146.25
R2261 VSS.n942 VSS.n76 146.25
R2262 VSS.n938 VSS.n135 146.25
R2263 VSS.n186 VSS.n83 146.25
R2264 VSS.n185 VSS.n158 146.25
R2265 VSS.n942 VSS.n56 146.25
R2266 VSS.n938 VSS.n95 146.25
R2267 VSS.n283 VSS.n83 146.25
R2268 VSS.n282 VSS.n158 146.25
R2269 VSS.n942 VSS.n77 146.25
R2270 VSS.n938 VSS.n137 146.25
R2271 VSS.n182 VSS.n83 146.25
R2272 VSS.n181 VSS.n158 146.25
R2273 VSS.n942 VSS.n55 146.25
R2274 VSS.n938 VSS.n93 146.25
R2275 VSS.n287 VSS.n83 146.25
R2276 VSS.n286 VSS.n158 146.25
R2277 VSS.n942 VSS.n78 146.25
R2278 VSS.n938 VSS.n139 146.25
R2279 VSS.n178 VSS.n83 146.25
R2280 VSS.n177 VSS.n158 146.25
R2281 VSS.n942 VSS.n54 146.25
R2282 VSS.n938 VSS.n91 146.25
R2283 VSS.n291 VSS.n83 146.25
R2284 VSS.n290 VSS.n158 146.25
R2285 VSS.n942 VSS.n79 146.25
R2286 VSS.n938 VSS.n141 146.25
R2287 VSS.n174 VSS.n83 146.25
R2288 VSS.n173 VSS.n158 146.25
R2289 VSS.n942 VSS.n53 146.25
R2290 VSS.n938 VSS.n89 146.25
R2291 VSS.n295 VSS.n83 146.25
R2292 VSS.n294 VSS.n158 146.25
R2293 VSS.n942 VSS.n80 146.25
R2294 VSS.n938 VSS.n143 146.25
R2295 VSS.n157 VSS.n83 146.25
R2296 VSS.n158 VSS.n156 146.25
R2297 VSS.n942 VSS.n52 146.25
R2298 VSS.n938 VSS.n87 146.25
R2299 VSS.n864 VSS.n83 146.25
R2300 VSS.n863 VSS.n158 146.25
R2301 VSS.n942 VSS.n81 146.25
R2302 VSS.n938 VSS.n937 146.25
R2303 VSS.n169 VSS.n83 146.25
R2304 VSS.n168 VSS.n158 146.25
R2305 VSS.n942 VSS.n51 146.25
R2306 VSS.n938 VSS.n85 146.25
R2307 VSS.n868 VSS.n83 146.25
R2308 VSS.n867 VSS.n158 146.25
R2309 VSS.n942 VSS.n941 146.25
R2310 VSS.n939 VSS.n938 146.25
R2311 VSS.t116 VSS.n10 127.242
R2312 VSS.n960 VSS.t137 126.996
R2313 VSS.n984 VSS.n983 117.001
R2314 VSS.n981 VSS.n13 117.001
R2315 VSS.n990 VSS.n987 117.001
R2316 VSS.n989 VSS.n985 117.001
R2317 VSS.n1003 VSS.n5 117.001
R2318 VSS.n986 VSS.n4 117.001
R2319 VSS.n1002 VSS.n1001 117.001
R2320 VSS.n999 VSS.n998 117.001
R2321 VSS.t133 VSS.n14 107.659
R2322 VSS.t138 VSS.n957 107.659
R2323 VSS.n992 VSS.t115 107.659
R2324 VSS.n161 VSS.n160 97.5005
R2325 VSS.n159 VSS.n20 97.5005
R2326 VSS.n921 VSS.n920 97.5005
R2327 VSS.n918 VSS.n917 97.5005
R2328 VSS.n893 VSS.n892 97.5005
R2329 VSS.n891 VSS.n21 97.5005
R2330 VSS.n902 VSS.n900 97.5005
R2331 VSS.n901 VSS.n899 97.5005
R2332 VSS.n309 VSS.n308 97.5005
R2333 VSS.n307 VSS.n22 97.5005
R2334 VSS.n847 VSS.n846 97.5005
R2335 VSS.n844 VSS.n843 97.5005
R2336 VSS.n324 VSS.n320 97.5005
R2337 VSS.n323 VSS.n23 97.5005
R2338 VSS.n817 VSS.n816 97.5005
R2339 VSS.n820 VSS.n819 97.5005
R2340 VSS.n795 VSS.n794 97.5005
R2341 VSS.n792 VSS.n24 97.5005
R2342 VSS.n798 VSS.n347 97.5005
R2343 VSS.n797 VSS.n346 97.5005
R2344 VSS.n367 VSS.n366 97.5005
R2345 VSS.n365 VSS.n25 97.5005
R2346 VSS.n779 VSS.n778 97.5005
R2347 VSS.n776 VSS.n775 97.5005
R2348 VSS.n382 VSS.n378 97.5005
R2349 VSS.n381 VSS.n26 97.5005
R2350 VSS.n749 VSS.n748 97.5005
R2351 VSS.n752 VSS.n751 97.5005
R2352 VSS.n727 VSS.n726 97.5005
R2353 VSS.n724 VSS.n27 97.5005
R2354 VSS.n730 VSS.n405 97.5005
R2355 VSS.n729 VSS.n404 97.5005
R2356 VSS.n425 VSS.n424 97.5005
R2357 VSS.n423 VSS.n28 97.5005
R2358 VSS.n711 VSS.n710 97.5005
R2359 VSS.n708 VSS.n707 97.5005
R2360 VSS.n440 VSS.n436 97.5005
R2361 VSS.n439 VSS.n29 97.5005
R2362 VSS.n681 VSS.n680 97.5005
R2363 VSS.n684 VSS.n683 97.5005
R2364 VSS.n659 VSS.n658 97.5005
R2365 VSS.n656 VSS.n30 97.5005
R2366 VSS.n662 VSS.n463 97.5005
R2367 VSS.n661 VSS.n462 97.5005
R2368 VSS.n483 VSS.n482 97.5005
R2369 VSS.n481 VSS.n31 97.5005
R2370 VSS.n643 VSS.n642 97.5005
R2371 VSS.n640 VSS.n639 97.5005
R2372 VSS.n498 VSS.n494 97.5005
R2373 VSS.n497 VSS.n32 97.5005
R2374 VSS.n613 VSS.n612 97.5005
R2375 VSS.n616 VSS.n615 97.5005
R2376 VSS.n591 VSS.n590 97.5005
R2377 VSS.n588 VSS.n33 97.5005
R2378 VSS.n594 VSS.n521 97.5005
R2379 VSS.n593 VSS.n520 97.5005
R2380 VSS.n541 VSS.n540 97.5005
R2381 VSS.n539 VSS.n34 97.5005
R2382 VSS.n575 VSS.n574 97.5005
R2383 VSS.n572 VSS.n571 97.5005
R2384 VSS.n948 VSS.n947 97.5005
R2385 VSS.n945 VSS.n944 97.5005
R2386 VSS.n228 VSS.n226 97.5005
R2387 VSS.n227 VSS.n225 97.5005
R2388 VSS.n557 VSS.n556 97.5005
R2389 VSS.n554 VSS.n35 97.5005
R2390 VSS.n560 VSS.n549 97.5005
R2391 VSS.n559 VSS.n548 97.5005
R2392 VSS.n527 VSS.n523 97.5005
R2393 VSS.n526 VSS.n36 97.5005
R2394 VSS.n579 VSS.n578 97.5005
R2395 VSS.n582 VSS.n581 97.5005
R2396 VSS.n512 VSS.n511 97.5005
R2397 VSS.n510 VSS.n37 97.5005
R2398 VSS.n609 VSS.n608 97.5005
R2399 VSS.n606 VSS.n605 97.5005
R2400 VSS.n625 VSS.n624 97.5005
R2401 VSS.n622 VSS.n38 97.5005
R2402 VSS.n628 VSS.n492 97.5005
R2403 VSS.n627 VSS.n491 97.5005
R2404 VSS.n469 VSS.n465 97.5005
R2405 VSS.n468 VSS.n39 97.5005
R2406 VSS.n647 VSS.n646 97.5005
R2407 VSS.n650 VSS.n649 97.5005
R2408 VSS.n454 VSS.n453 97.5005
R2409 VSS.n452 VSS.n40 97.5005
R2410 VSS.n677 VSS.n676 97.5005
R2411 VSS.n674 VSS.n673 97.5005
R2412 VSS.n693 VSS.n692 97.5005
R2413 VSS.n690 VSS.n41 97.5005
R2414 VSS.n696 VSS.n434 97.5005
R2415 VSS.n695 VSS.n433 97.5005
R2416 VSS.n411 VSS.n407 97.5005
R2417 VSS.n410 VSS.n42 97.5005
R2418 VSS.n715 VSS.n714 97.5005
R2419 VSS.n718 VSS.n717 97.5005
R2420 VSS.n396 VSS.n395 97.5005
R2421 VSS.n394 VSS.n43 97.5005
R2422 VSS.n745 VSS.n744 97.5005
R2423 VSS.n742 VSS.n741 97.5005
R2424 VSS.n761 VSS.n760 97.5005
R2425 VSS.n758 VSS.n44 97.5005
R2426 VSS.n764 VSS.n376 97.5005
R2427 VSS.n763 VSS.n375 97.5005
R2428 VSS.n353 VSS.n349 97.5005
R2429 VSS.n352 VSS.n45 97.5005
R2430 VSS.n783 VSS.n782 97.5005
R2431 VSS.n786 VSS.n785 97.5005
R2432 VSS.n338 VSS.n337 97.5005
R2433 VSS.n336 VSS.n46 97.5005
R2434 VSS.n813 VSS.n812 97.5005
R2435 VSS.n810 VSS.n809 97.5005
R2436 VSS.n829 VSS.n828 97.5005
R2437 VSS.n826 VSS.n47 97.5005
R2438 VSS.n832 VSS.n318 97.5005
R2439 VSS.n831 VSS.n317 97.5005
R2440 VSS.n856 VSS.n298 97.5005
R2441 VSS.n297 VSS.n48 97.5005
R2442 VSS.n851 VSS.n850 97.5005
R2443 VSS.n854 VSS.n853 97.5005
R2444 VSS.n930 VSS.n147 97.5005
R2445 VSS.n146 VSS.n49 97.5005
R2446 VSS.n925 VSS.n924 97.5005
R2447 VSS.n928 VSS.n927 97.5005
R2448 VSS.n882 VSS.n871 97.5005
R2449 VSS.n870 VSS.n50 97.5005
R2450 VSS.n877 VSS.n876 97.5005
R2451 VSS.n880 VSS.n879 97.5005
R2452 VSS.n949 VSS.n948 95.581
R2453 VSS.n11 VSS.t117 92.8751
R2454 VSS.n873 VSS.t84 87.7129
R2455 VSS.n908 VSS.t74 87.7129
R2456 VSS.n301 VSS.t42 87.7129
R2457 VSS.n316 VSS.t10 87.7129
R2458 VSS.n806 VSS.t102 87.7129
R2459 VSS.n359 VSS.t60 87.7129
R2460 VSS.n374 VSS.t119 87.7129
R2461 VSS.n738 VSS.t100 87.7129
R2462 VSS.n417 VSS.t90 87.7129
R2463 VSS.n432 VSS.t20 87.7129
R2464 VSS.n670 VSS.t56 87.7129
R2465 VSS.n475 VSS.t3 87.7129
R2466 VSS.n490 VSS.t126 87.7129
R2467 VSS.n602 VSS.t48 87.7129
R2468 VSS.n533 VSS.t122 87.7129
R2469 VSS.n547 VSS.t78 87.7129
R2470 VSS.n224 VSS.t44 87.7129
R2471 VSS.n568 VSS.t1 87.7129
R2472 VSS.n519 VSS.t46 87.7129
R2473 VSS.n504 VSS.t50 87.7129
R2474 VSS.n636 VSS.t128 87.7129
R2475 VSS.n461 VSS.t54 87.7129
R2476 VSS.n446 VSS.t18 87.7129
R2477 VSS.n704 VSS.t8 87.7129
R2478 VSS.n403 VSS.t94 87.7129
R2479 VSS.n388 VSS.t132 87.7129
R2480 VSS.n772 VSS.t108 87.7129
R2481 VSS.n345 VSS.t30 87.7129
R2482 VSS.n330 VSS.t72 87.7129
R2483 VSS.n840 VSS.t58 87.7129
R2484 VSS.n898 VSS.t104 87.7129
R2485 VSS.n914 VSS.t80 87.7129
R2486 VSS.n869 VSS.t82 87.574
R2487 VSS.n145 VSS.t36 87.574
R2488 VSS.n296 VSS.t32 87.574
R2489 VSS.n315 VSS.t86 87.574
R2490 VSS.n342 VSS.t52 87.574
R2491 VSS.n357 VSS.t98 87.574
R2492 VSS.n373 VSS.t112 87.574
R2493 VSS.n400 VSS.t88 87.574
R2494 VSS.n415 VSS.t64 87.574
R2495 VSS.n431 VSS.t12 87.574
R2496 VSS.n458 VSS.t28 87.574
R2497 VSS.n473 VSS.t70 87.574
R2498 VSS.n489 VSS.t26 87.574
R2499 VSS.n516 VSS.t22 87.574
R2500 VSS.n531 VSS.t16 87.574
R2501 VSS.n546 VSS.t24 87.574
R2502 VSS.n233 VSS.t5 87.574
R2503 VSS.n545 VSS.t66 87.574
R2504 VSS.n518 VSS.t124 87.574
R2505 VSS.n502 VSS.t92 87.574
R2506 VSS.n487 VSS.t68 87.574
R2507 VSS.n460 VSS.t96 87.574
R2508 VSS.n444 VSS.t14 87.574
R2509 VSS.n429 VSS.t40 87.574
R2510 VSS.n402 VSS.t106 87.574
R2511 VSS.n386 VSS.t110 87.574
R2512 VSS.n371 VSS.t135 87.574
R2513 VSS.n344 VSS.t62 87.574
R2514 VSS.n328 VSS.t38 87.574
R2515 VSS.n313 VSS.t130 87.574
R2516 VSS.n897 VSS.t34 87.574
R2517 VSS.n153 VSS.t76 87.574
R2518 VSS.n984 VSS.n10 73.8004
R2519 VSS.n973 VSS.n14 62.4424
R2520 VSS.n969 VSS.n957 62.4424
R2521 VSS.n993 VSS.n992 62.4424
R2522 VSS.n970 VSS.n956 34.4123
R2523 VSS.n973 VSS.n972 34.4123
R2524 VSS.n966 VSS.n9 34.4123
R2525 VSS.n969 VSS.n968 34.4123
R2526 VSS.n997 VSS.n996 34.4123
R2527 VSS.n994 VSS.n993 34.4123
R2528 VSS.n975 VSS.n974 34.4123
R2529 VSS.n978 VSS.n977 34.4123
R2530 VSS.n963 VSS.t139 26.4492
R2531 VSS.n958 VSS.t141 26.4492
R2532 VSS.t120 VSS.n6 24.1763
R2533 VSS.n938 VSS.n83 14.5421
R2534 VSS.t114 VSS.n158 8.09052
R2535 VSS.t114 VSS.n83 8.09052
R2536 VSS.n942 VSS.t113 8.09052
R2537 VSS.n1008 VSS.n2 7.32795
R2538 VSS.n943 VSS.n942 6.70805
R2539 VSS.t113 VSS.n15 5.12077
R2540 VSS.n1008 VSS.n1007 3.4105
R2541 VSS.n1010 VSS.n1009 3.4105
R2542 VSS.n232 VSS.n1 3.4105
R2543 VSS.n565 VSS.n564 3.4105
R2544 VSS.n567 VSS.n566 3.4105
R2545 VSS.n532 VSS.n517 3.4105
R2546 VSS.n599 VSS.n598 3.4105
R2547 VSS.n601 VSS.n600 3.4105
R2548 VSS.n503 VSS.n488 3.4105
R2549 VSS.n633 VSS.n632 3.4105
R2550 VSS.n635 VSS.n634 3.4105
R2551 VSS.n474 VSS.n459 3.4105
R2552 VSS.n667 VSS.n666 3.4105
R2553 VSS.n669 VSS.n668 3.4105
R2554 VSS.n445 VSS.n430 3.4105
R2555 VSS.n701 VSS.n700 3.4105
R2556 VSS.n703 VSS.n702 3.4105
R2557 VSS.n416 VSS.n401 3.4105
R2558 VSS.n735 VSS.n734 3.4105
R2559 VSS.n737 VSS.n736 3.4105
R2560 VSS.n387 VSS.n372 3.4105
R2561 VSS.n769 VSS.n768 3.4105
R2562 VSS.n771 VSS.n770 3.4105
R2563 VSS.n358 VSS.n343 3.4105
R2564 VSS.n803 VSS.n802 3.4105
R2565 VSS.n805 VSS.n804 3.4105
R2566 VSS.n329 VSS.n314 3.4105
R2567 VSS.n837 VSS.n836 3.4105
R2568 VSS.n839 VSS.n838 3.4105
R2569 VSS.n300 VSS.n155 3.4105
R2570 VSS.n907 VSS.n906 3.4105
R2571 VSS.n911 VSS.n910 3.4105
R2572 VSS.n913 VSS.n912 3.4105
R2573 VSS.n872 VSS.n154 3.4105
R2574 VSS.n938 VSS.n15 2.97026
R2575 VSS.n1009 VSS.n1008 2.64895
R2576 VSS.n1009 VSS.n1 1.63258
R2577 VSS.n565 VSS.n1 1.54915
R2578 VSS.n566 VSS.n565 1.54915
R2579 VSS.n566 VSS.n517 1.54915
R2580 VSS.n599 VSS.n517 1.54915
R2581 VSS.n600 VSS.n599 1.54915
R2582 VSS.n600 VSS.n488 1.54915
R2583 VSS.n633 VSS.n488 1.54915
R2584 VSS.n634 VSS.n633 1.54915
R2585 VSS.n634 VSS.n459 1.54915
R2586 VSS.n667 VSS.n459 1.54915
R2587 VSS.n668 VSS.n667 1.54915
R2588 VSS.n668 VSS.n430 1.54915
R2589 VSS.n701 VSS.n430 1.54915
R2590 VSS.n702 VSS.n701 1.54915
R2591 VSS.n702 VSS.n401 1.54915
R2592 VSS.n735 VSS.n401 1.54915
R2593 VSS.n736 VSS.n735 1.54915
R2594 VSS.n736 VSS.n372 1.54915
R2595 VSS.n769 VSS.n372 1.54915
R2596 VSS.n770 VSS.n769 1.54915
R2597 VSS.n770 VSS.n343 1.54915
R2598 VSS.n803 VSS.n343 1.54915
R2599 VSS.n804 VSS.n803 1.54915
R2600 VSS.n804 VSS.n314 1.54915
R2601 VSS.n837 VSS.n314 1.54915
R2602 VSS.n838 VSS.n837 1.54915
R2603 VSS.n838 VSS.n155 1.54915
R2604 VSS.n907 VSS.n155 1.54915
R2605 VSS.n911 VSS.n907 1.54915
R2606 VSS.n912 VSS.n911 1.54915
R2607 VSS.n912 VSS.n154 1.54915
R2608 VSS.n154 VSS 1.27068
R2609 VSS.n886 VSS.n885 0.537643
R2610 VSS.n934 VSS.n933 0.537643
R2611 VSS.n861 VSS.n859 0.537643
R2612 VSS.n824 VSS.n823 0.537643
R2613 VSS.n341 VSS.n335 0.537643
R2614 VSS.n356 VSS.n351 0.537643
R2615 VSS.n756 VSS.n755 0.537643
R2616 VSS.n399 VSS.n393 0.537643
R2617 VSS.n414 VSS.n409 0.537643
R2618 VSS.n688 VSS.n687 0.537643
R2619 VSS.n457 VSS.n451 0.537643
R2620 VSS.n472 VSS.n467 0.537643
R2621 VSS.n620 VSS.n619 0.537643
R2622 VSS.n515 VSS.n509 0.537643
R2623 VSS.n530 VSS.n525 0.537643
R2624 VSS.n552 VSS.n551 0.537643
R2625 VSS.n236 VSS.n234 0.537643
R2626 VSS.n544 VSS.n538 0.537643
R2627 VSS.n586 VSS.n585 0.537643
R2628 VSS.n501 VSS.n496 0.537643
R2629 VSS.n486 VSS.n480 0.537643
R2630 VSS.n654 VSS.n653 0.537643
R2631 VSS.n443 VSS.n438 0.537643
R2632 VSS.n428 VSS.n422 0.537643
R2633 VSS.n722 VSS.n721 0.537643
R2634 VSS.n385 VSS.n380 0.537643
R2635 VSS.n370 VSS.n364 0.537643
R2636 VSS.n790 VSS.n789 0.537643
R2637 VSS.n327 VSS.n322 0.537643
R2638 VSS.n312 VSS.n306 0.537643
R2639 VSS.n896 VSS.n890 0.537643
R2640 VSS.n166 VSS.n164 0.537643
R2641 VSS.n1006 VSS.n3 0.504071
R2642 VSS.n964 VSS.n959 0.425738
R2643 VSS.n962 VSS.n961 0.420143
R2644 VSS.n11 VSS.n3 0.395524
R2645 VSS.n959 VSS.n958 0.3765
R2646 VSS.n2 VSS 0.346845
R2647 VSS.n1007 VSS 0.346845
R2648 VSS VSS.n1010 0.346845
R2649 VSS.n963 VSS.n962 0.298167
R2650 VSS.n1007 VSS.n1006 0.265714
R2651 VSS.n960 VSS.n2 0.19969
R2652 VSS.n961 VSS.n960 0.178429
R2653 VSS.n872 VSS.n869 0.148214
R2654 VSS.n910 VSS.n145 0.148214
R2655 VSS.n300 VSS.n296 0.148214
R2656 VSS.n836 VSS.n315 0.148214
R2657 VSS.n805 VSS.n342 0.148214
R2658 VSS.n358 VSS.n357 0.148214
R2659 VSS.n768 VSS.n373 0.148214
R2660 VSS.n737 VSS.n400 0.148214
R2661 VSS.n416 VSS.n415 0.148214
R2662 VSS.n700 VSS.n431 0.148214
R2663 VSS.n669 VSS.n458 0.148214
R2664 VSS.n474 VSS.n473 0.148214
R2665 VSS.n632 VSS.n489 0.148214
R2666 VSS.n601 VSS.n516 0.148214
R2667 VSS.n532 VSS.n531 0.148214
R2668 VSS.n564 VSS.n546 0.148214
R2669 VSS.n233 VSS.n232 0.148214
R2670 VSS.n567 VSS.n545 0.148214
R2671 VSS.n598 VSS.n518 0.148214
R2672 VSS.n503 VSS.n502 0.148214
R2673 VSS.n635 VSS.n487 0.148214
R2674 VSS.n666 VSS.n460 0.148214
R2675 VSS.n445 VSS.n444 0.148214
R2676 VSS.n703 VSS.n429 0.148214
R2677 VSS.n734 VSS.n402 0.148214
R2678 VSS.n387 VSS.n386 0.148214
R2679 VSS.n771 VSS.n371 0.148214
R2680 VSS.n802 VSS.n344 0.148214
R2681 VSS.n329 VSS.n328 0.148214
R2682 VSS.n839 VSS.n313 0.148214
R2683 VSS.n906 VSS.n897 0.148214
R2684 VSS.n913 VSS.n153 0.148214
R2685 VSS.n873 VSS 0.143179
R2686 VSS.n908 VSS 0.143179
R2687 VSS.n301 VSS 0.143179
R2688 VSS.n316 VSS 0.143179
R2689 VSS.n806 VSS 0.143179
R2690 VSS.n359 VSS 0.143179
R2691 VSS.n374 VSS 0.143179
R2692 VSS.n738 VSS 0.143179
R2693 VSS.n417 VSS 0.143179
R2694 VSS.n432 VSS 0.143179
R2695 VSS.n670 VSS 0.143179
R2696 VSS.n475 VSS 0.143179
R2697 VSS.n490 VSS 0.143179
R2698 VSS.n602 VSS 0.143179
R2699 VSS.n533 VSS 0.143179
R2700 VSS.n547 VSS 0.143179
R2701 VSS.n224 VSS 0.143179
R2702 VSS.n568 VSS 0.143179
R2703 VSS.n519 VSS 0.143179
R2704 VSS.n504 VSS 0.143179
R2705 VSS.n636 VSS 0.143179
R2706 VSS.n461 VSS 0.143179
R2707 VSS.n446 VSS 0.143179
R2708 VSS.n704 VSS 0.143179
R2709 VSS.n403 VSS 0.143179
R2710 VSS.n388 VSS 0.143179
R2711 VSS.n772 VSS 0.143179
R2712 VSS.n345 VSS 0.143179
R2713 VSS.n330 VSS 0.143179
R2714 VSS.n840 VSS 0.143179
R2715 VSS.n898 VSS 0.143179
R2716 VSS.n914 VSS 0.143179
R2717 VSS.n874 VSS.n872 0.114643
R2718 VSS.n910 VSS.n909 0.114643
R2719 VSS.n302 VSS.n300 0.114643
R2720 VSS.n836 VSS.n835 0.114643
R2721 VSS.n807 VSS.n805 0.114643
R2722 VSS.n360 VSS.n358 0.114643
R2723 VSS.n768 VSS.n767 0.114643
R2724 VSS.n739 VSS.n737 0.114643
R2725 VSS.n418 VSS.n416 0.114643
R2726 VSS.n700 VSS.n699 0.114643
R2727 VSS.n671 VSS.n669 0.114643
R2728 VSS.n476 VSS.n474 0.114643
R2729 VSS.n632 VSS.n631 0.114643
R2730 VSS.n603 VSS.n601 0.114643
R2731 VSS.n534 VSS.n532 0.114643
R2732 VSS.n564 VSS.n563 0.114643
R2733 VSS.n232 VSS.n231 0.114643
R2734 VSS.n569 VSS.n567 0.114643
R2735 VSS.n598 VSS.n597 0.114643
R2736 VSS.n505 VSS.n503 0.114643
R2737 VSS.n637 VSS.n635 0.114643
R2738 VSS.n666 VSS.n665 0.114643
R2739 VSS.n447 VSS.n445 0.114643
R2740 VSS.n705 VSS.n703 0.114643
R2741 VSS.n734 VSS.n733 0.114643
R2742 VSS.n389 VSS.n387 0.114643
R2743 VSS.n773 VSS.n771 0.114643
R2744 VSS.n802 VSS.n801 0.114643
R2745 VSS.n331 VSS.n329 0.114643
R2746 VSS.n841 VSS.n839 0.114643
R2747 VSS.n906 VSS.n905 0.114643
R2748 VSS.n915 VSS.n913 0.114643
R2749 VSS.n964 VSS.n963 0.0945
R2750 VSS.n874 VSS.n873 0.0900238
R2751 VSS.n885 VSS.n869 0.0900238
R2752 VSS.n909 VSS.n908 0.0900238
R2753 VSS.n933 VSS.n145 0.0900238
R2754 VSS.n302 VSS.n301 0.0900238
R2755 VSS.n859 VSS.n296 0.0900238
R2756 VSS.n835 VSS.n316 0.0900238
R2757 VSS.n824 VSS.n315 0.0900238
R2758 VSS.n807 VSS.n806 0.0900238
R2759 VSS.n342 VSS.n341 0.0900238
R2760 VSS.n360 VSS.n359 0.0900238
R2761 VSS.n357 VSS.n356 0.0900238
R2762 VSS.n767 VSS.n374 0.0900238
R2763 VSS.n756 VSS.n373 0.0900238
R2764 VSS.n739 VSS.n738 0.0900238
R2765 VSS.n400 VSS.n399 0.0900238
R2766 VSS.n418 VSS.n417 0.0900238
R2767 VSS.n415 VSS.n414 0.0900238
R2768 VSS.n699 VSS.n432 0.0900238
R2769 VSS.n688 VSS.n431 0.0900238
R2770 VSS.n671 VSS.n670 0.0900238
R2771 VSS.n458 VSS.n457 0.0900238
R2772 VSS.n476 VSS.n475 0.0900238
R2773 VSS.n473 VSS.n472 0.0900238
R2774 VSS.n631 VSS.n490 0.0900238
R2775 VSS.n620 VSS.n489 0.0900238
R2776 VSS.n603 VSS.n602 0.0900238
R2777 VSS.n516 VSS.n515 0.0900238
R2778 VSS.n534 VSS.n533 0.0900238
R2779 VSS.n531 VSS.n530 0.0900238
R2780 VSS.n563 VSS.n547 0.0900238
R2781 VSS.n552 VSS.n546 0.0900238
R2782 VSS.n231 VSS.n224 0.0900238
R2783 VSS.n234 VSS.n233 0.0900238
R2784 VSS.n569 VSS.n568 0.0900238
R2785 VSS.n545 VSS.n544 0.0900238
R2786 VSS.n597 VSS.n519 0.0900238
R2787 VSS.n586 VSS.n518 0.0900238
R2788 VSS.n505 VSS.n504 0.0900238
R2789 VSS.n502 VSS.n501 0.0900238
R2790 VSS.n637 VSS.n636 0.0900238
R2791 VSS.n487 VSS.n486 0.0900238
R2792 VSS.n665 VSS.n461 0.0900238
R2793 VSS.n654 VSS.n460 0.0900238
R2794 VSS.n447 VSS.n446 0.0900238
R2795 VSS.n444 VSS.n443 0.0900238
R2796 VSS.n705 VSS.n704 0.0900238
R2797 VSS.n429 VSS.n428 0.0900238
R2798 VSS.n733 VSS.n403 0.0900238
R2799 VSS.n722 VSS.n402 0.0900238
R2800 VSS.n389 VSS.n388 0.0900238
R2801 VSS.n386 VSS.n385 0.0900238
R2802 VSS.n773 VSS.n772 0.0900238
R2803 VSS.n371 VSS.n370 0.0900238
R2804 VSS.n801 VSS.n345 0.0900238
R2805 VSS.n790 VSS.n344 0.0900238
R2806 VSS.n331 VSS.n330 0.0900238
R2807 VSS.n328 VSS.n327 0.0900238
R2808 VSS.n841 VSS.n840 0.0900238
R2809 VSS.n313 VSS.n312 0.0900238
R2810 VSS.n905 VSS.n898 0.0900238
R2811 VSS.n897 VSS.n896 0.0900238
R2812 VSS.n915 VSS.n914 0.0900238
R2813 VSS.n164 VSS.n153 0.0900238
R2814 a_3465_n13274.t0 a_3465_n13274.t1 56.918
R2815 a_1865_n13274.t0 a_1865_n13274.t1 57.8108
R2816 a_3077_n9274.t0 a_3077_n9274.t1 118.638
R2817 a_1477_n9274.t0 a_1477_n9274.t1 117.746
R2818 a_677_n8854.t0 a_677_n8854.n1 130.643
R2819 a_677_n8854.n1 a_677_n8854.n0 0.354119
R2820 a_677_n8854.n0 a_677_n8854.t2 1055.88
R2821 a_677_n8854.n1 a_677_n8854.t1 340.68
R2822 a_677_n8854.n0 a_677_n8854.t3 1054.99
R2823 a_1065_n6268.t0 a_1065_n6268.n0 92.7554
R2824 a_1065_n6268.n0 a_1065_n6268.t1 93.1112
R2825 a_1065_n6268.n0 a_1065_n6268.t2 93.2589
R2826 sense_amp_scale1p5_flat_0.SA_OUT.n3 sense_amp_scale1p5_flat_0.SA_OUT.t2 93.6408
R2827 sense_amp_scale1p5_flat_0.SA_OUT sense_amp_scale1p5_flat_0.SA_OUT.n1 0.013369
R2828 sense_amp_scale1p5_flat_0.SA_OUT.n1 sense_amp_scale1p5_flat_0.SA_OUT.n3 0.168357
R2829 sense_amp_scale1p5_flat_0.SA_OUT.n3 sense_amp_scale1p5_flat_0.SA_OUT.n0 0.354119
R2830 sense_amp_scale1p5_flat_0.SA_OUT.n0 sense_amp_scale1p5_flat_0.SA_OUT.n2 0.0844286
R2831 sense_amp_scale1p5_flat_0.SA_OUT.n2 sense_amp_scale1p5_flat_0.SA_OUT.t3 388.132
R2832 sense_amp_scale1p5_flat_0.SA_OUT.n2 sense_amp_scale1p5_flat_0.SA_OUT.t1 123.656
R2833 sense_amp_scale1p5_flat_0.SA_OUT.n1 sense_amp_scale1p5_flat_0.SA_OUT.t0 143.55
R2834 sense_amp_scale1p5_flat_0.SA_OUT.n0 sense_amp_scale1p5_flat_0.SA_OUT.t4 548.649
R2835 sense_amp_scale1p5_flat_0.SA_OUTB.n3 sense_amp_scale1p5_flat_0.SA_OUTB.t0 92.3089
R2836 sense_amp_scale1p5_flat_0.SA_OUTB sense_amp_scale1p5_flat_0.SA_OUTB.n0 0.0172857
R2837 sense_amp_scale1p5_flat_0.SA_OUTB.n0 sense_amp_scale1p5_flat_0.SA_OUTB.n2 0.168357
R2838 sense_amp_scale1p5_flat_0.SA_OUTB.n2 sense_amp_scale1p5_flat_0.SA_OUTB.n1 0.206405
R2839 sense_amp_scale1p5_flat_0.SA_OUTB.n1 sense_amp_scale1p5_flat_0.SA_OUTB.n3 0.22431
R2840 sense_amp_scale1p5_flat_0.SA_OUTB.n3 sense_amp_scale1p5_flat_0.SA_OUTB.t2 125.222
R2841 sense_amp_scale1p5_flat_0.SA_OUTB.n2 sense_amp_scale1p5_flat_0.SA_OUTB.t3 386.979
R2842 sense_amp_scale1p5_flat_0.SA_OUTB.n1 sense_amp_scale1p5_flat_0.SA_OUTB.t1 144.882
R2843 sense_amp_scale1p5_flat_0.SA_OUTB.n0 sense_amp_scale1p5_flat_0.SA_OUTB.t4 549.981
R2844 a_665_996.t0 a_665_996.n2 667.521
R2845 a_665_996.n2 a_665_996.n0 4.34871
R2846 a_665_996.n0 a_665_996.n1 0.179548
R2847 a_665_996.n1 a_665_996.t2 233.82
R2848 a_665_996.n1 a_665_996.t4 312.329
R2849 a_665_996.n0 a_665_996.t3 433.293
R2850 a_665_996.n2 a_665_996.t1 85.1015
R2851 a_617_908.t1 a_617_908.n2 667.313
R2852 a_617_908.n2 a_617_908.n1 3.85693
R2853 a_617_908.n1 a_617_908.t2 234.183
R2854 a_617_908.n1 a_617_908.n0 4.41538
R2855 a_617_908.n0 a_617_908.t3 430.065
R2856 a_617_908.n0 a_617_908.t4 308.337
R2857 a_617_908.n2 a_617_908.t0 85.2404
R2858 a_665_3648.t0 a_665_3648.n2 667.521
R2859 a_665_3648.n2 a_665_3648.n0 4.34871
R2860 a_665_3648.n0 a_665_3648.n1 0.179548
R2861 a_665_3648.n1 a_665_3648.t2 233.82
R2862 a_665_3648.n1 a_665_3648.t4 312.329
R2863 a_665_3648.n0 a_665_3648.t3 433.293
R2864 a_665_3648.n2 a_665_3648.t1 85.1015
R2865 a_617_3560.t2 a_617_3560.n2 667.313
R2866 a_617_3560.n2 a_617_3560.n1 3.85693
R2867 a_617_3560.n1 a_617_3560.t0 234.183
R2868 a_617_3560.n1 a_617_3560.n0 4.41538
R2869 a_617_3560.n0 a_617_3560.t3 430.065
R2870 a_617_3560.n0 a_617_3560.t4 308.337
R2871 a_617_3560.n2 a_617_3560.t1 85.2404
R2872 a_665_6300.t1 a_665_6300.n2 667.521
R2873 a_665_6300.n2 a_665_6300.n0 4.34871
R2874 a_665_6300.n0 a_665_6300.n1 0.179548
R2875 a_665_6300.n1 a_665_6300.t2 233.82
R2876 a_665_6300.n1 a_665_6300.t4 312.329
R2877 a_665_6300.n0 a_665_6300.t3 433.293
R2878 a_665_6300.n2 a_665_6300.t0 85.1015
R2879 a_617_6212.t1 a_617_6212.n2 667.313
R2880 a_617_6212.n2 a_617_6212.n1 3.85693
R2881 a_617_6212.n1 a_617_6212.t2 234.183
R2882 a_617_6212.n1 a_617_6212.n0 4.41538
R2883 a_617_6212.n0 a_617_6212.t3 430.065
R2884 a_617_6212.n0 a_617_6212.t4 308.337
R2885 a_617_6212.n2 a_617_6212.t0 85.2404
R2886 a_665_8952.t0 a_665_8952.n2 667.521
R2887 a_665_8952.n2 a_665_8952.n0 4.34871
R2888 a_665_8952.n0 a_665_8952.n1 0.179548
R2889 a_665_8952.n1 a_665_8952.t1 233.82
R2890 a_665_8952.n1 a_665_8952.t4 312.329
R2891 a_665_8952.n0 a_665_8952.t3 433.293
R2892 a_665_8952.n2 a_665_8952.t2 85.1015
R2893 a_617_8864.t1 a_617_8864.n2 667.313
R2894 a_617_8864.n2 a_617_8864.n1 3.85693
R2895 a_617_8864.n1 a_617_8864.t2 234.183
R2896 a_617_8864.n1 a_617_8864.n0 4.41538
R2897 a_617_8864.n0 a_617_8864.t3 430.065
R2898 a_617_8864.n0 a_617_8864.t4 308.337
R2899 a_617_8864.n2 a_617_8864.t0 85.2404
R2900 a_665_11604.t1 a_665_11604.n2 667.521
R2901 a_665_11604.n2 a_665_11604.n0 4.34871
R2902 a_665_11604.n0 a_665_11604.n1 0.179548
R2903 a_665_11604.n1 a_665_11604.t2 233.82
R2904 a_665_11604.n1 a_665_11604.t4 312.329
R2905 a_665_11604.n0 a_665_11604.t3 433.293
R2906 a_665_11604.n2 a_665_11604.t0 85.1015
R2907 a_617_11516.t1 a_617_11516.n2 667.313
R2908 a_617_11516.n2 a_617_11516.n1 3.85693
R2909 a_617_11516.n1 a_617_11516.t2 234.183
R2910 a_617_11516.n1 a_617_11516.n0 4.41538
R2911 a_617_11516.n0 a_617_11516.t3 430.065
R2912 a_617_11516.n0 a_617_11516.t4 308.337
R2913 a_617_11516.n2 a_617_11516.t0 85.2404
R2914 a_665_14256.t1 a_665_14256.n2 667.521
R2915 a_665_14256.n2 a_665_14256.n0 4.34871
R2916 a_665_14256.n0 a_665_14256.n1 0.179548
R2917 a_665_14256.n1 a_665_14256.t2 233.82
R2918 a_665_14256.n1 a_665_14256.t4 312.329
R2919 a_665_14256.n0 a_665_14256.t3 433.293
R2920 a_665_14256.n2 a_665_14256.t0 85.1015
R2921 a_617_14168.t1 a_617_14168.n2 667.313
R2922 a_617_14168.n2 a_617_14168.n1 3.85693
R2923 a_617_14168.n1 a_617_14168.t2 234.183
R2924 a_617_14168.n1 a_617_14168.n0 4.41538
R2925 a_617_14168.n0 a_617_14168.t3 430.065
R2926 a_617_14168.n0 a_617_14168.t4 308.337
R2927 a_617_14168.n2 a_617_14168.t0 85.2404
R2928 a_665_16908.t2 a_665_16908.n2 667.521
R2929 a_665_16908.n2 a_665_16908.n0 4.34871
R2930 a_665_16908.n0 a_665_16908.n1 0.179548
R2931 a_665_16908.n1 a_665_16908.t1 233.82
R2932 a_665_16908.n1 a_665_16908.t4 312.329
R2933 a_665_16908.n0 a_665_16908.t3 433.293
R2934 a_665_16908.n2 a_665_16908.t0 85.1015
R2935 a_617_16820.t1 a_617_16820.n2 667.313
R2936 a_617_16820.n2 a_617_16820.n1 3.85693
R2937 a_617_16820.n1 a_617_16820.t2 234.183
R2938 a_617_16820.n1 a_617_16820.n0 4.41538
R2939 a_617_16820.n0 a_617_16820.t3 430.065
R2940 a_617_16820.n0 a_617_16820.t4 308.337
R2941 a_617_16820.n2 a_617_16820.t0 85.2404
R2942 a_665_19560.t0 a_665_19560.n2 667.521
R2943 a_665_19560.n2 a_665_19560.n0 4.34871
R2944 a_665_19560.n0 a_665_19560.n1 0.179548
R2945 a_665_19560.n1 a_665_19560.t1 233.82
R2946 a_665_19560.n1 a_665_19560.t4 312.329
R2947 a_665_19560.n0 a_665_19560.t3 433.293
R2948 a_665_19560.n2 a_665_19560.t2 85.1015
R2949 a_617_19472.t1 a_617_19472.n2 667.313
R2950 a_617_19472.n2 a_617_19472.n1 3.85693
R2951 a_617_19472.n1 a_617_19472.t2 234.183
R2952 a_617_19472.n1 a_617_19472.n0 4.41538
R2953 a_617_19472.n0 a_617_19472.t3 430.065
R2954 a_617_19472.n0 a_617_19472.t4 308.337
R2955 a_617_19472.n2 a_617_19472.t0 85.2404
R2956 a_665_22212.t0 a_665_22212.n2 667.521
R2957 a_665_22212.n2 a_665_22212.n0 4.34871
R2958 a_665_22212.n0 a_665_22212.n1 0.179548
R2959 a_665_22212.n1 a_665_22212.t1 233.82
R2960 a_665_22212.n1 a_665_22212.t4 312.329
R2961 a_665_22212.n0 a_665_22212.t3 433.293
R2962 a_665_22212.n2 a_665_22212.t2 85.1015
R2963 a_617_22124.t1 a_617_22124.n2 667.313
R2964 a_617_22124.n2 a_617_22124.n1 3.85693
R2965 a_617_22124.n1 a_617_22124.t2 234.183
R2966 a_617_22124.n1 a_617_22124.n0 4.41538
R2967 a_617_22124.n0 a_617_22124.t3 430.065
R2968 a_617_22124.n0 a_617_22124.t4 308.337
R2969 a_617_22124.n2 a_617_22124.t0 85.2404
R2970 a_665_24864.t1 a_665_24864.n2 667.521
R2971 a_665_24864.n2 a_665_24864.n0 4.34871
R2972 a_665_24864.n0 a_665_24864.n1 0.179548
R2973 a_665_24864.n1 a_665_24864.t2 233.82
R2974 a_665_24864.n1 a_665_24864.t4 312.329
R2975 a_665_24864.n0 a_665_24864.t3 433.293
R2976 a_665_24864.n2 a_665_24864.t0 85.1015
R2977 a_617_24776.t1 a_617_24776.n2 667.313
R2978 a_617_24776.n2 a_617_24776.n1 3.85693
R2979 a_617_24776.n1 a_617_24776.t2 234.183
R2980 a_617_24776.n1 a_617_24776.n0 4.41538
R2981 a_617_24776.n0 a_617_24776.t3 430.065
R2982 a_617_24776.n0 a_617_24776.t4 308.337
R2983 a_617_24776.n2 a_617_24776.t0 85.2404
R2984 a_665_27516.t1 a_665_27516.n2 667.521
R2985 a_665_27516.n2 a_665_27516.n0 4.34871
R2986 a_665_27516.n0 a_665_27516.n1 0.179548
R2987 a_665_27516.n1 a_665_27516.t2 233.82
R2988 a_665_27516.n1 a_665_27516.t4 312.329
R2989 a_665_27516.n0 a_665_27516.t3 433.293
R2990 a_665_27516.n2 a_665_27516.t0 85.1015
R2991 a_617_27428.t1 a_617_27428.n2 667.313
R2992 a_617_27428.n2 a_617_27428.n1 3.85693
R2993 a_617_27428.n1 a_617_27428.t2 234.183
R2994 a_617_27428.n1 a_617_27428.n0 4.41538
R2995 a_617_27428.n0 a_617_27428.t3 430.065
R2996 a_617_27428.n0 a_617_27428.t4 308.337
R2997 a_617_27428.n2 a_617_27428.t0 85.2404
R2998 a_665_30168.t0 a_665_30168.n2 667.521
R2999 a_665_30168.n2 a_665_30168.n0 4.34871
R3000 a_665_30168.n0 a_665_30168.n1 0.179548
R3001 a_665_30168.n1 a_665_30168.t2 233.82
R3002 a_665_30168.n1 a_665_30168.t4 312.329
R3003 a_665_30168.n0 a_665_30168.t3 433.293
R3004 a_665_30168.n2 a_665_30168.t1 85.1015
R3005 a_617_30080.t1 a_617_30080.n2 667.313
R3006 a_617_30080.n2 a_617_30080.n1 3.85693
R3007 a_617_30080.n1 a_617_30080.t2 234.183
R3008 a_617_30080.n1 a_617_30080.n0 4.41538
R3009 a_617_30080.n0 a_617_30080.t3 430.065
R3010 a_617_30080.n0 a_617_30080.t4 308.337
R3011 a_617_30080.n2 a_617_30080.t0 85.2404
R3012 a_665_32820.t1 a_665_32820.n2 667.521
R3013 a_665_32820.n2 a_665_32820.n0 4.34871
R3014 a_665_32820.n0 a_665_32820.n1 0.179548
R3015 a_665_32820.n1 a_665_32820.t2 233.82
R3016 a_665_32820.n1 a_665_32820.t4 312.329
R3017 a_665_32820.n0 a_665_32820.t3 433.293
R3018 a_665_32820.n2 a_665_32820.t0 85.1015
R3019 a_617_32732.t1 a_617_32732.n2 667.313
R3020 a_617_32732.n2 a_617_32732.n1 3.85693
R3021 a_617_32732.n1 a_617_32732.t2 234.183
R3022 a_617_32732.n1 a_617_32732.n0 4.41538
R3023 a_617_32732.n0 a_617_32732.t3 430.065
R3024 a_617_32732.n0 a_617_32732.t4 308.337
R3025 a_617_32732.n2 a_617_32732.t0 85.2404
R3026 a_665_35472.t1 a_665_35472.n2 667.521
R3027 a_665_35472.n2 a_665_35472.n0 4.34871
R3028 a_665_35472.n0 a_665_35472.n1 0.179548
R3029 a_665_35472.n1 a_665_35472.t2 233.82
R3030 a_665_35472.n1 a_665_35472.t4 312.329
R3031 a_665_35472.n0 a_665_35472.t3 433.293
R3032 a_665_35472.n2 a_665_35472.t0 85.1015
R3033 a_617_35384.t1 a_617_35384.n2 667.313
R3034 a_617_35384.n2 a_617_35384.n1 3.85693
R3035 a_617_35384.n1 a_617_35384.t2 234.183
R3036 a_617_35384.n1 a_617_35384.n0 4.41538
R3037 a_617_35384.n0 a_617_35384.t3 430.065
R3038 a_617_35384.n0 a_617_35384.t4 308.337
R3039 a_617_35384.n2 a_617_35384.t0 85.2404
R3040 a_665_38124.t0 a_665_38124.n2 667.521
R3041 a_665_38124.n2 a_665_38124.n0 4.34871
R3042 a_665_38124.n0 a_665_38124.n1 0.179548
R3043 a_665_38124.n1 a_665_38124.t2 233.82
R3044 a_665_38124.n1 a_665_38124.t4 312.329
R3045 a_665_38124.n0 a_665_38124.t3 433.293
R3046 a_665_38124.n2 a_665_38124.t1 85.1015
R3047 a_617_38036.t1 a_617_38036.n2 667.313
R3048 a_617_38036.n2 a_617_38036.n1 3.85693
R3049 a_617_38036.n1 a_617_38036.t2 234.183
R3050 a_617_38036.n1 a_617_38036.n0 4.41538
R3051 a_617_38036.n0 a_617_38036.t3 430.065
R3052 a_617_38036.n0 a_617_38036.t4 308.337
R3053 a_617_38036.n2 a_617_38036.t0 85.2404
R3054 a_665_40776.t0 a_665_40776.n2 667.521
R3055 a_665_40776.n2 a_665_40776.n0 4.34871
R3056 a_665_40776.n0 a_665_40776.n1 0.179548
R3057 a_665_40776.n1 a_665_40776.t2 233.82
R3058 a_665_40776.n1 a_665_40776.t4 312.329
R3059 a_665_40776.n0 a_665_40776.t3 433.293
R3060 a_665_40776.n2 a_665_40776.t1 85.1015
R3061 a_617_40688.t1 a_617_40688.n2 667.313
R3062 a_617_40688.n2 a_617_40688.n1 3.85693
R3063 a_617_40688.n1 a_617_40688.t2 234.183
R3064 a_617_40688.n1 a_617_40688.n0 4.41538
R3065 a_617_40688.n0 a_617_40688.t3 430.065
R3066 a_617_40688.n0 a_617_40688.t4 308.337
R3067 a_617_40688.n2 a_617_40688.t0 85.2404
R3068 a_665_43428.t0 a_665_43428.n2 667.521
R3069 a_665_43428.n2 a_665_43428.n0 4.34871
R3070 a_665_43428.n0 a_665_43428.n1 0.179548
R3071 a_665_43428.n1 a_665_43428.t2 233.82
R3072 a_665_43428.n1 a_665_43428.t4 312.329
R3073 a_665_43428.n0 a_665_43428.t3 433.293
R3074 a_665_43428.n2 a_665_43428.t1 85.1015
R3075 a_617_43340.t1 a_617_43340.n2 667.313
R3076 a_617_43340.n2 a_617_43340.n1 3.85693
R3077 a_617_43340.n1 a_617_43340.t2 234.183
R3078 a_617_43340.n1 a_617_43340.n0 4.41538
R3079 a_617_43340.n0 a_617_43340.t3 430.065
R3080 a_617_43340.n0 a_617_43340.t4 308.337
R3081 a_617_43340.n2 a_617_43340.t0 85.2404
R3082 a_665_46080.t0 a_665_46080.n2 667.521
R3083 a_665_46080.n2 a_665_46080.n0 4.34871
R3084 a_665_46080.n0 a_665_46080.n1 0.179548
R3085 a_665_46080.n1 a_665_46080.t2 233.82
R3086 a_665_46080.n1 a_665_46080.t4 312.329
R3087 a_665_46080.n0 a_665_46080.t3 433.293
R3088 a_665_46080.n2 a_665_46080.t1 85.1015
R3089 a_617_45992.t1 a_617_45992.n2 667.313
R3090 a_617_45992.n2 a_617_45992.n1 3.85693
R3091 a_617_45992.n1 a_617_45992.t2 234.183
R3092 a_617_45992.n1 a_617_45992.n0 4.41538
R3093 a_617_45992.n0 a_617_45992.t3 430.065
R3094 a_617_45992.n0 a_617_45992.t4 308.337
R3095 a_617_45992.n2 a_617_45992.t0 85.2404
R3096 a_665_48732.t1 a_665_48732.n2 667.521
R3097 a_665_48732.n2 a_665_48732.n0 4.34871
R3098 a_665_48732.n0 a_665_48732.n1 0.179548
R3099 a_665_48732.n1 a_665_48732.t0 233.82
R3100 a_665_48732.n1 a_665_48732.t4 312.329
R3101 a_665_48732.n0 a_665_48732.t3 433.293
R3102 a_665_48732.n2 a_665_48732.t2 85.1015
R3103 a_617_48644.t1 a_617_48644.n2 667.313
R3104 a_617_48644.n2 a_617_48644.n1 3.85693
R3105 a_617_48644.n1 a_617_48644.t2 234.183
R3106 a_617_48644.n1 a_617_48644.n0 4.41538
R3107 a_617_48644.n0 a_617_48644.t3 430.065
R3108 a_617_48644.n0 a_617_48644.t4 308.337
R3109 a_617_48644.n2 a_617_48644.t0 85.2404
R3110 a_665_51384.t1 a_665_51384.n2 667.521
R3111 a_665_51384.n2 a_665_51384.n0 4.34871
R3112 a_665_51384.n0 a_665_51384.n1 0.179548
R3113 a_665_51384.n1 a_665_51384.t0 233.82
R3114 a_665_51384.n1 a_665_51384.t4 312.329
R3115 a_665_51384.n0 a_665_51384.t3 433.293
R3116 a_665_51384.n2 a_665_51384.t2 85.1015
R3117 a_617_51296.t1 a_617_51296.n2 667.313
R3118 a_617_51296.n2 a_617_51296.n1 3.85693
R3119 a_617_51296.n1 a_617_51296.t2 234.183
R3120 a_617_51296.n1 a_617_51296.n0 4.41538
R3121 a_617_51296.n0 a_617_51296.t3 430.065
R3122 a_617_51296.n0 a_617_51296.t4 308.337
R3123 a_617_51296.n2 a_617_51296.t0 85.2404
R3124 a_665_54036.t0 a_665_54036.n2 667.521
R3125 a_665_54036.n2 a_665_54036.n0 4.34871
R3126 a_665_54036.n0 a_665_54036.n1 0.179548
R3127 a_665_54036.n1 a_665_54036.t2 233.82
R3128 a_665_54036.n1 a_665_54036.t4 312.329
R3129 a_665_54036.n0 a_665_54036.t3 433.293
R3130 a_665_54036.n2 a_665_54036.t1 85.1015
R3131 a_617_53948.t1 a_617_53948.n2 667.313
R3132 a_617_53948.n2 a_617_53948.n1 3.85693
R3133 a_617_53948.n1 a_617_53948.t2 234.183
R3134 a_617_53948.n1 a_617_53948.n0 4.41538
R3135 a_617_53948.n0 a_617_53948.t3 430.065
R3136 a_617_53948.n0 a_617_53948.t4 308.337
R3137 a_617_53948.n2 a_617_53948.t0 85.2404
R3138 a_665_56688.t0 a_665_56688.n2 667.521
R3139 a_665_56688.n2 a_665_56688.n0 4.34871
R3140 a_665_56688.n0 a_665_56688.n1 0.179548
R3141 a_665_56688.n1 a_665_56688.t2 233.82
R3142 a_665_56688.n1 a_665_56688.t4 312.329
R3143 a_665_56688.n0 a_665_56688.t3 433.293
R3144 a_665_56688.n2 a_665_56688.t1 85.1015
R3145 a_617_56600.t1 a_617_56600.n2 667.313
R3146 a_617_56600.n2 a_617_56600.n1 3.85693
R3147 a_617_56600.n1 a_617_56600.t2 234.183
R3148 a_617_56600.n1 a_617_56600.n0 4.41538
R3149 a_617_56600.n0 a_617_56600.t3 430.065
R3150 a_617_56600.n0 a_617_56600.t4 308.337
R3151 a_617_56600.n2 a_617_56600.t0 85.2404
R3152 a_665_59340.t1 a_665_59340.n2 667.521
R3153 a_665_59340.n2 a_665_59340.n0 4.34871
R3154 a_665_59340.n0 a_665_59340.n1 0.179548
R3155 a_665_59340.n1 a_665_59340.t2 233.82
R3156 a_665_59340.n1 a_665_59340.t4 312.329
R3157 a_665_59340.n0 a_665_59340.t3 433.293
R3158 a_665_59340.n2 a_665_59340.t0 85.1015
R3159 a_617_59252.t1 a_617_59252.n2 667.313
R3160 a_617_59252.n2 a_617_59252.n1 3.85693
R3161 a_617_59252.n1 a_617_59252.t2 234.183
R3162 a_617_59252.n1 a_617_59252.n0 4.41538
R3163 a_617_59252.n0 a_617_59252.t3 430.065
R3164 a_617_59252.n0 a_617_59252.t4 308.337
R3165 a_617_59252.n2 a_617_59252.t0 85.2404
R3166 a_665_61992.t0 a_665_61992.n2 667.521
R3167 a_665_61992.n2 a_665_61992.n0 4.34871
R3168 a_665_61992.n0 a_665_61992.n1 0.179548
R3169 a_665_61992.n1 a_665_61992.t2 233.82
R3170 a_665_61992.n1 a_665_61992.t4 312.329
R3171 a_665_61992.n0 a_665_61992.t3 433.293
R3172 a_665_61992.n2 a_665_61992.t1 85.1015
R3173 a_617_61904.t1 a_617_61904.n2 667.313
R3174 a_617_61904.n2 a_617_61904.n1 3.85693
R3175 a_617_61904.n1 a_617_61904.t2 234.183
R3176 a_617_61904.n1 a_617_61904.n0 4.41538
R3177 a_617_61904.n0 a_617_61904.t3 430.065
R3178 a_617_61904.n0 a_617_61904.t4 308.337
R3179 a_617_61904.n2 a_617_61904.t0 85.2404
R3180 a_665_64644.t0 a_665_64644.n2 667.521
R3181 a_665_64644.n2 a_665_64644.n0 4.34871
R3182 a_665_64644.n0 a_665_64644.n1 0.179548
R3183 a_665_64644.n1 a_665_64644.t2 233.82
R3184 a_665_64644.n1 a_665_64644.t4 312.329
R3185 a_665_64644.n0 a_665_64644.t3 433.293
R3186 a_665_64644.n2 a_665_64644.t1 85.1015
R3187 a_617_64556.t1 a_617_64556.n2 667.313
R3188 a_617_64556.n2 a_617_64556.n1 3.85693
R3189 a_617_64556.n1 a_617_64556.t2 234.183
R3190 a_617_64556.n1 a_617_64556.n0 4.41538
R3191 a_617_64556.n0 a_617_64556.t3 430.065
R3192 a_617_64556.n0 a_617_64556.t4 308.337
R3193 a_617_64556.n2 a_617_64556.t0 85.2404
R3194 a_665_67296.t1 a_665_67296.n2 667.521
R3195 a_665_67296.n2 a_665_67296.n0 4.34871
R3196 a_665_67296.n0 a_665_67296.n1 0.179548
R3197 a_665_67296.n1 a_665_67296.t2 233.82
R3198 a_665_67296.n1 a_665_67296.t4 312.329
R3199 a_665_67296.n0 a_665_67296.t3 433.293
R3200 a_665_67296.n2 a_665_67296.t0 85.1015
R3201 a_617_67208.t1 a_617_67208.n2 667.313
R3202 a_617_67208.n2 a_617_67208.n1 3.85693
R3203 a_617_67208.n1 a_617_67208.t2 234.183
R3204 a_617_67208.n1 a_617_67208.n0 4.41538
R3205 a_617_67208.n0 a_617_67208.t3 430.065
R3206 a_617_67208.n0 a_617_67208.t4 308.337
R3207 a_617_67208.n2 a_617_67208.t0 85.2404
R3208 a_665_69948.t0 a_665_69948.n2 667.521
R3209 a_665_69948.n2 a_665_69948.n0 4.34871
R3210 a_665_69948.n0 a_665_69948.n1 0.179548
R3211 a_665_69948.n1 a_665_69948.t2 233.82
R3212 a_665_69948.n1 a_665_69948.t4 312.329
R3213 a_665_69948.n0 a_665_69948.t3 433.293
R3214 a_665_69948.n2 a_665_69948.t1 85.1015
R3215 a_617_69860.t1 a_617_69860.n2 667.313
R3216 a_617_69860.n2 a_617_69860.n1 3.85693
R3217 a_617_69860.n1 a_617_69860.t2 234.183
R3218 a_617_69860.n1 a_617_69860.n0 4.41538
R3219 a_617_69860.n0 a_617_69860.t3 430.065
R3220 a_617_69860.n0 a_617_69860.t4 308.337
R3221 a_617_69860.n2 a_617_69860.t0 85.2404
R3222 a_665_72600.t1 a_665_72600.n2 667.521
R3223 a_665_72600.n2 a_665_72600.n0 4.34871
R3224 a_665_72600.n0 a_665_72600.n1 0.179548
R3225 a_665_72600.n1 a_665_72600.t2 233.82
R3226 a_665_72600.n1 a_665_72600.t4 312.329
R3227 a_665_72600.n0 a_665_72600.t3 433.293
R3228 a_665_72600.n2 a_665_72600.t0 85.1015
R3229 a_617_72512.t1 a_617_72512.n2 667.313
R3230 a_617_72512.n2 a_617_72512.n1 3.85693
R3231 a_617_72512.n1 a_617_72512.t2 234.183
R3232 a_617_72512.n1 a_617_72512.n0 4.41538
R3233 a_617_72512.n0 a_617_72512.t3 430.065
R3234 a_617_72512.n0 a_617_72512.t4 308.337
R3235 a_617_72512.n2 a_617_72512.t0 85.2404
R3236 a_665_75252.t1 a_665_75252.n2 667.521
R3237 a_665_75252.n2 a_665_75252.n0 4.34871
R3238 a_665_75252.n0 a_665_75252.n1 0.179548
R3239 a_665_75252.n1 a_665_75252.t2 233.82
R3240 a_665_75252.n1 a_665_75252.t4 312.329
R3241 a_665_75252.n0 a_665_75252.t3 433.293
R3242 a_665_75252.n2 a_665_75252.t0 85.1015
R3243 a_617_75164.t1 a_617_75164.n2 667.313
R3244 a_617_75164.n2 a_617_75164.n1 3.85693
R3245 a_617_75164.n1 a_617_75164.t2 234.183
R3246 a_617_75164.n1 a_617_75164.n0 4.41538
R3247 a_617_75164.n0 a_617_75164.t3 430.065
R3248 a_617_75164.n0 a_617_75164.t4 308.337
R3249 a_617_75164.n2 a_617_75164.t0 85.2404
R3250 a_665_77904.t0 a_665_77904.n2 667.521
R3251 a_665_77904.n2 a_665_77904.n0 4.34871
R3252 a_665_77904.n0 a_665_77904.n1 0.179548
R3253 a_665_77904.n1 a_665_77904.t2 233.82
R3254 a_665_77904.n1 a_665_77904.t4 312.329
R3255 a_665_77904.n0 a_665_77904.t3 433.293
R3256 a_665_77904.n2 a_665_77904.t1 85.1015
R3257 a_617_77816.t1 a_617_77816.n2 667.313
R3258 a_617_77816.n2 a_617_77816.n1 3.85693
R3259 a_617_77816.n1 a_617_77816.t2 234.183
R3260 a_617_77816.n1 a_617_77816.n0 4.41538
R3261 a_617_77816.n0 a_617_77816.t3 430.065
R3262 a_617_77816.n0 a_617_77816.t4 308.337
R3263 a_617_77816.n2 a_617_77816.t0 85.2404
R3264 a_665_80556.t1 a_665_80556.n2 667.521
R3265 a_665_80556.n2 a_665_80556.n0 4.34871
R3266 a_665_80556.n0 a_665_80556.n1 0.179548
R3267 a_665_80556.n1 a_665_80556.t2 233.82
R3268 a_665_80556.n1 a_665_80556.t4 312.329
R3269 a_665_80556.n0 a_665_80556.t3 433.293
R3270 a_665_80556.n2 a_665_80556.t0 85.1015
R3271 a_617_80468.t1 a_617_80468.n2 667.313
R3272 a_617_80468.n2 a_617_80468.n1 3.85693
R3273 a_617_80468.n1 a_617_80468.t2 234.183
R3274 a_617_80468.n1 a_617_80468.n0 4.41538
R3275 a_617_80468.n0 a_617_80468.t3 430.065
R3276 a_617_80468.n0 a_617_80468.t4 308.337
R3277 a_617_80468.n2 a_617_80468.t0 85.2404
R3278 a_665_83208.t0 a_665_83208.n2 667.521
R3279 a_665_83208.n2 a_665_83208.n0 4.34871
R3280 a_665_83208.n0 a_665_83208.n1 0.179548
R3281 a_665_83208.n1 a_665_83208.t2 233.82
R3282 a_665_83208.n1 a_665_83208.t4 312.329
R3283 a_665_83208.n0 a_665_83208.t3 433.293
R3284 a_665_83208.n2 a_665_83208.t1 85.1015
R3285 a_617_83120.t1 a_617_83120.n2 667.313
R3286 a_617_83120.n2 a_617_83120.n1 3.85693
R3287 a_617_83120.n1 a_617_83120.t2 234.183
R3288 a_617_83120.n1 a_617_83120.n0 4.41538
R3289 a_617_83120.n0 a_617_83120.t3 430.065
R3290 a_617_83120.n0 a_617_83120.t4 308.337
R3291 a_617_83120.n2 a_617_83120.t0 85.2404
C34 DATA VSS 3.10112f
C35 DATA_B VSS 2.31858f
C36 WE VSS 5.32997f
C37 SCLK VSS 2.94289f
C38 PRECH VSS 1.3915f
C39 BLB VSS 81.83859f
C40 BL VSS 50.70175f
C41 WLOFF VSS 0.1592p
C42 VDD VSS 0.15865p
C43 sense_amp_scale1p5_flat_0.SA_OUT VSS 2.32402f $ **FLOATING
C44 sense_amp_scale1p5_flat_0.SA_OUTB VSS 2.924f $ **FLOATING
C45 a_617_83120.t1 VSS 0.03239f $ **FLOATING
C46 a_617_83120.t0 VSS 0.11379f $ **FLOATING
C47 a_617_83120.t4 VSS 0.0614f $ **FLOATING
C48 a_617_83120.n0 VSS 1.06718f $ **FLOATING
C49 a_617_83120.t3 VSS 0.08266f $ **FLOATING
C50 a_617_83120.t2 VSS 0.06931f $ **FLOATING
C51 a_617_83120.n1 VSS 2.81269f $ **FLOATING
C52 a_617_83120.n2 VSS 1.07601f $ **FLOATING
C53 a_665_83208.t0 VSS 0.04034f $ **FLOATING
C54 a_665_83208.t1 VSS 0.1399f $ **FLOATING
C55 a_665_83208.t3 VSS 0.1109f $ **FLOATING
C56 a_665_83208.n0 VSS 2.1681f $ **FLOATING
C57 a_665_83208.t4 VSS 0.08257f $ **FLOATING
C58 a_665_83208.n1 VSS 3.051f $ **FLOATING
C59 a_665_83208.t2 VSS 0.08432f $ **FLOATING
C60 a_665_83208.n2 VSS 1.48906f $ **FLOATING
C61 a_617_80468.t1 VSS 0.03251f $ **FLOATING
C62 a_617_80468.t0 VSS 0.11421f $ **FLOATING
C63 a_617_80468.t4 VSS 0.06163f $ **FLOATING
C64 a_617_80468.n0 VSS 1.07118f $ **FLOATING
C65 a_617_80468.t3 VSS 0.08297f $ **FLOATING
C66 a_617_80468.t2 VSS 0.06956f $ **FLOATING
C67 a_617_80468.n1 VSS 2.82323f $ **FLOATING
C68 a_617_80468.n2 VSS 1.08005f $ **FLOATING
C69 a_665_80556.t1 VSS 0.04057f $ **FLOATING
C70 a_665_80556.t0 VSS 0.14071f $ **FLOATING
C71 a_665_80556.t3 VSS 0.11155f $ **FLOATING
C72 a_665_80556.n0 VSS 2.18072f $ **FLOATING
C73 a_665_80556.t4 VSS 0.08305f $ **FLOATING
C74 a_665_80556.n1 VSS 3.06877f $ **FLOATING
C75 a_665_80556.t2 VSS 0.08481f $ **FLOATING
C76 a_665_80556.n2 VSS 1.49773f $ **FLOATING
C77 a_617_77816.t1 VSS 0.03251f $ **FLOATING
C78 a_617_77816.t0 VSS 0.11421f $ **FLOATING
C79 a_617_77816.t4 VSS 0.06163f $ **FLOATING
C80 a_617_77816.n0 VSS 1.07118f $ **FLOATING
C81 a_617_77816.t3 VSS 0.08297f $ **FLOATING
C82 a_617_77816.t2 VSS 0.06956f $ **FLOATING
C83 a_617_77816.n1 VSS 2.82324f $ **FLOATING
C84 a_617_77816.n2 VSS 1.08005f $ **FLOATING
C85 a_665_77904.t0 VSS 0.04057f $ **FLOATING
C86 a_665_77904.t1 VSS 0.14071f $ **FLOATING
C87 a_665_77904.t3 VSS 0.11155f $ **FLOATING
C88 a_665_77904.n0 VSS 2.18072f $ **FLOATING
C89 a_665_77904.t4 VSS 0.08305f $ **FLOATING
C90 a_665_77904.n1 VSS 3.06877f $ **FLOATING
C91 a_665_77904.t2 VSS 0.08481f $ **FLOATING
C92 a_665_77904.n2 VSS 1.49773f $ **FLOATING
C93 a_617_75164.t1 VSS 0.03251f $ **FLOATING
C94 a_617_75164.t0 VSS 0.11421f $ **FLOATING
C95 a_617_75164.t4 VSS 0.06163f $ **FLOATING
C96 a_617_75164.n0 VSS 1.07118f $ **FLOATING
C97 a_617_75164.t3 VSS 0.08297f $ **FLOATING
C98 a_617_75164.t2 VSS 0.06956f $ **FLOATING
C99 a_617_75164.n1 VSS 2.82324f $ **FLOATING
C100 a_617_75164.n2 VSS 1.08005f $ **FLOATING
C101 a_665_75252.t1 VSS 0.04057f $ **FLOATING
C102 a_665_75252.t0 VSS 0.14071f $ **FLOATING
C103 a_665_75252.t3 VSS 0.11155f $ **FLOATING
C104 a_665_75252.n0 VSS 2.18072f $ **FLOATING
C105 a_665_75252.t4 VSS 0.08305f $ **FLOATING
C106 a_665_75252.n1 VSS 3.06877f $ **FLOATING
C107 a_665_75252.t2 VSS 0.08481f $ **FLOATING
C108 a_665_75252.n2 VSS 1.49773f $ **FLOATING
C109 a_617_72512.t1 VSS 0.03251f $ **FLOATING
C110 a_617_72512.t0 VSS 0.11421f $ **FLOATING
C111 a_617_72512.t4 VSS 0.06163f $ **FLOATING
C112 a_617_72512.n0 VSS 1.07118f $ **FLOATING
C113 a_617_72512.t3 VSS 0.08297f $ **FLOATING
C114 a_617_72512.t2 VSS 0.06956f $ **FLOATING
C115 a_617_72512.n1 VSS 2.82323f $ **FLOATING
C116 a_617_72512.n2 VSS 1.08005f $ **FLOATING
C117 a_665_72600.t1 VSS 0.04057f $ **FLOATING
C118 a_665_72600.t0 VSS 0.14071f $ **FLOATING
C119 a_665_72600.t3 VSS 0.11155f $ **FLOATING
C120 a_665_72600.n0 VSS 2.18072f $ **FLOATING
C121 a_665_72600.t4 VSS 0.08305f $ **FLOATING
C122 a_665_72600.n1 VSS 3.06877f $ **FLOATING
C123 a_665_72600.t2 VSS 0.08481f $ **FLOATING
C124 a_665_72600.n2 VSS 1.49773f $ **FLOATING
C125 a_617_69860.t1 VSS 0.03251f $ **FLOATING
C126 a_617_69860.t0 VSS 0.11421f $ **FLOATING
C127 a_617_69860.t4 VSS 0.06163f $ **FLOATING
C128 a_617_69860.n0 VSS 1.07118f $ **FLOATING
C129 a_617_69860.t3 VSS 0.08297f $ **FLOATING
C130 a_617_69860.t2 VSS 0.06956f $ **FLOATING
C131 a_617_69860.n1 VSS 2.82324f $ **FLOATING
C132 a_617_69860.n2 VSS 1.08005f $ **FLOATING
C133 a_665_69948.t0 VSS 0.04057f $ **FLOATING
C134 a_665_69948.t1 VSS 0.14071f $ **FLOATING
C135 a_665_69948.t3 VSS 0.11155f $ **FLOATING
C136 a_665_69948.n0 VSS 2.18072f $ **FLOATING
C137 a_665_69948.t4 VSS 0.08305f $ **FLOATING
C138 a_665_69948.n1 VSS 3.06877f $ **FLOATING
C139 a_665_69948.t2 VSS 0.08481f $ **FLOATING
C140 a_665_69948.n2 VSS 1.49773f $ **FLOATING
C141 a_617_67208.t1 VSS 0.03251f $ **FLOATING
C142 a_617_67208.t0 VSS 0.11421f $ **FLOATING
C143 a_617_67208.t4 VSS 0.06163f $ **FLOATING
C144 a_617_67208.n0 VSS 1.07118f $ **FLOATING
C145 a_617_67208.t3 VSS 0.08297f $ **FLOATING
C146 a_617_67208.t2 VSS 0.06956f $ **FLOATING
C147 a_617_67208.n1 VSS 2.82324f $ **FLOATING
C148 a_617_67208.n2 VSS 1.08005f $ **FLOATING
C149 a_665_67296.t1 VSS 0.04057f $ **FLOATING
C150 a_665_67296.t0 VSS 0.14071f $ **FLOATING
C151 a_665_67296.t3 VSS 0.11155f $ **FLOATING
C152 a_665_67296.n0 VSS 2.18072f $ **FLOATING
C153 a_665_67296.t4 VSS 0.08305f $ **FLOATING
C154 a_665_67296.n1 VSS 3.06877f $ **FLOATING
C155 a_665_67296.t2 VSS 0.08481f $ **FLOATING
C156 a_665_67296.n2 VSS 1.49773f $ **FLOATING
C157 a_617_64556.t1 VSS 0.03251f $ **FLOATING
C158 a_617_64556.t0 VSS 0.11421f $ **FLOATING
C159 a_617_64556.t4 VSS 0.06163f $ **FLOATING
C160 a_617_64556.n0 VSS 1.07118f $ **FLOATING
C161 a_617_64556.t3 VSS 0.08297f $ **FLOATING
C162 a_617_64556.t2 VSS 0.06956f $ **FLOATING
C163 a_617_64556.n1 VSS 2.82324f $ **FLOATING
C164 a_617_64556.n2 VSS 1.08005f $ **FLOATING
C165 a_665_64644.t0 VSS 0.04057f $ **FLOATING
C166 a_665_64644.t1 VSS 0.14071f $ **FLOATING
C167 a_665_64644.t3 VSS 0.11155f $ **FLOATING
C168 a_665_64644.n0 VSS 2.18072f $ **FLOATING
C169 a_665_64644.t4 VSS 0.08305f $ **FLOATING
C170 a_665_64644.n1 VSS 3.06877f $ **FLOATING
C171 a_665_64644.t2 VSS 0.08481f $ **FLOATING
C172 a_665_64644.n2 VSS 1.49773f $ **FLOATING
C173 a_617_61904.t1 VSS 0.03251f $ **FLOATING
C174 a_617_61904.t0 VSS 0.11421f $ **FLOATING
C175 a_617_61904.t4 VSS 0.06163f $ **FLOATING
C176 a_617_61904.n0 VSS 1.07118f $ **FLOATING
C177 a_617_61904.t3 VSS 0.08297f $ **FLOATING
C178 a_617_61904.t2 VSS 0.06956f $ **FLOATING
C179 a_617_61904.n1 VSS 2.82324f $ **FLOATING
C180 a_617_61904.n2 VSS 1.08005f $ **FLOATING
C181 a_665_61992.t0 VSS 0.04057f $ **FLOATING
C182 a_665_61992.t1 VSS 0.14071f $ **FLOATING
C183 a_665_61992.t3 VSS 0.11155f $ **FLOATING
C184 a_665_61992.n0 VSS 2.18072f $ **FLOATING
C185 a_665_61992.t4 VSS 0.08305f $ **FLOATING
C186 a_665_61992.n1 VSS 3.06877f $ **FLOATING
C187 a_665_61992.t2 VSS 0.08481f $ **FLOATING
C188 a_665_61992.n2 VSS 1.49773f $ **FLOATING
C189 a_617_59252.t1 VSS 0.03251f $ **FLOATING
C190 a_617_59252.t0 VSS 0.11421f $ **FLOATING
C191 a_617_59252.t4 VSS 0.06163f $ **FLOATING
C192 a_617_59252.n0 VSS 1.07118f $ **FLOATING
C193 a_617_59252.t3 VSS 0.08297f $ **FLOATING
C194 a_617_59252.t2 VSS 0.06956f $ **FLOATING
C195 a_617_59252.n1 VSS 2.82324f $ **FLOATING
C196 a_617_59252.n2 VSS 1.08005f $ **FLOATING
C197 a_665_59340.t1 VSS 0.04057f $ **FLOATING
C198 a_665_59340.t0 VSS 0.14071f $ **FLOATING
C199 a_665_59340.t3 VSS 0.11155f $ **FLOATING
C200 a_665_59340.n0 VSS 2.18072f $ **FLOATING
C201 a_665_59340.t4 VSS 0.08305f $ **FLOATING
C202 a_665_59340.n1 VSS 3.06877f $ **FLOATING
C203 a_665_59340.t2 VSS 0.08481f $ **FLOATING
C204 a_665_59340.n2 VSS 1.49773f $ **FLOATING
C205 a_617_56600.t1 VSS 0.03251f $ **FLOATING
C206 a_617_56600.t0 VSS 0.11421f $ **FLOATING
C207 a_617_56600.t4 VSS 0.06163f $ **FLOATING
C208 a_617_56600.n0 VSS 1.07118f $ **FLOATING
C209 a_617_56600.t3 VSS 0.08297f $ **FLOATING
C210 a_617_56600.t2 VSS 0.06956f $ **FLOATING
C211 a_617_56600.n1 VSS 2.82324f $ **FLOATING
C212 a_617_56600.n2 VSS 1.08005f $ **FLOATING
C213 a_665_56688.t0 VSS 0.04057f $ **FLOATING
C214 a_665_56688.t1 VSS 0.14071f $ **FLOATING
C215 a_665_56688.t3 VSS 0.11155f $ **FLOATING
C216 a_665_56688.n0 VSS 2.18072f $ **FLOATING
C217 a_665_56688.t4 VSS 0.08305f $ **FLOATING
C218 a_665_56688.n1 VSS 3.06877f $ **FLOATING
C219 a_665_56688.t2 VSS 0.08481f $ **FLOATING
C220 a_665_56688.n2 VSS 1.49773f $ **FLOATING
C221 a_617_53948.t1 VSS 0.03251f $ **FLOATING
C222 a_617_53948.t0 VSS 0.11421f $ **FLOATING
C223 a_617_53948.t4 VSS 0.06163f $ **FLOATING
C224 a_617_53948.n0 VSS 1.07118f $ **FLOATING
C225 a_617_53948.t3 VSS 0.08297f $ **FLOATING
C226 a_617_53948.t2 VSS 0.06956f $ **FLOATING
C227 a_617_53948.n1 VSS 2.82324f $ **FLOATING
C228 a_617_53948.n2 VSS 1.08005f $ **FLOATING
C229 a_665_54036.t0 VSS 0.04057f $ **FLOATING
C230 a_665_54036.t1 VSS 0.14071f $ **FLOATING
C231 a_665_54036.t3 VSS 0.11155f $ **FLOATING
C232 a_665_54036.n0 VSS 2.18072f $ **FLOATING
C233 a_665_54036.t4 VSS 0.08305f $ **FLOATING
C234 a_665_54036.n1 VSS 3.06877f $ **FLOATING
C235 a_665_54036.t2 VSS 0.08481f $ **FLOATING
C236 a_665_54036.n2 VSS 1.49773f $ **FLOATING
C237 a_617_51296.t1 VSS 0.03251f $ **FLOATING
C238 a_617_51296.t0 VSS 0.11421f $ **FLOATING
C239 a_617_51296.t4 VSS 0.06163f $ **FLOATING
C240 a_617_51296.n0 VSS 1.07118f $ **FLOATING
C241 a_617_51296.t3 VSS 0.08297f $ **FLOATING
C242 a_617_51296.t2 VSS 0.06956f $ **FLOATING
C243 a_617_51296.n1 VSS 2.82324f $ **FLOATING
C244 a_617_51296.n2 VSS 1.08005f $ **FLOATING
C245 a_665_51384.t1 VSS 0.04057f $ **FLOATING
C246 a_665_51384.t2 VSS 0.14071f $ **FLOATING
C247 a_665_51384.t3 VSS 0.11155f $ **FLOATING
C248 a_665_51384.n0 VSS 2.18072f $ **FLOATING
C249 a_665_51384.t4 VSS 0.08305f $ **FLOATING
C250 a_665_51384.n1 VSS 3.06877f $ **FLOATING
C251 a_665_51384.t0 VSS 0.08481f $ **FLOATING
C252 a_665_51384.n2 VSS 1.49773f $ **FLOATING
C253 a_617_48644.t1 VSS 0.03251f $ **FLOATING
C254 a_617_48644.t0 VSS 0.11421f $ **FLOATING
C255 a_617_48644.t4 VSS 0.06163f $ **FLOATING
C256 a_617_48644.n0 VSS 1.07118f $ **FLOATING
C257 a_617_48644.t3 VSS 0.08297f $ **FLOATING
C258 a_617_48644.t2 VSS 0.06956f $ **FLOATING
C259 a_617_48644.n1 VSS 2.82323f $ **FLOATING
C260 a_617_48644.n2 VSS 1.08005f $ **FLOATING
C261 a_665_48732.t1 VSS 0.04057f $ **FLOATING
C262 a_665_48732.t2 VSS 0.14071f $ **FLOATING
C263 a_665_48732.t3 VSS 0.11155f $ **FLOATING
C264 a_665_48732.n0 VSS 2.18072f $ **FLOATING
C265 a_665_48732.t4 VSS 0.08305f $ **FLOATING
C266 a_665_48732.n1 VSS 3.06877f $ **FLOATING
C267 a_665_48732.t0 VSS 0.08481f $ **FLOATING
C268 a_665_48732.n2 VSS 1.49773f $ **FLOATING
C269 a_617_45992.t1 VSS 0.03251f $ **FLOATING
C270 a_617_45992.t0 VSS 0.11421f $ **FLOATING
C271 a_617_45992.t4 VSS 0.06163f $ **FLOATING
C272 a_617_45992.n0 VSS 1.07118f $ **FLOATING
C273 a_617_45992.t3 VSS 0.08297f $ **FLOATING
C274 a_617_45992.t2 VSS 0.06956f $ **FLOATING
C275 a_617_45992.n1 VSS 2.82324f $ **FLOATING
C276 a_617_45992.n2 VSS 1.08005f $ **FLOATING
C277 a_665_46080.t0 VSS 0.04057f $ **FLOATING
C278 a_665_46080.t1 VSS 0.14071f $ **FLOATING
C279 a_665_46080.t3 VSS 0.11155f $ **FLOATING
C280 a_665_46080.n0 VSS 2.18072f $ **FLOATING
C281 a_665_46080.t4 VSS 0.08305f $ **FLOATING
C282 a_665_46080.n1 VSS 3.06877f $ **FLOATING
C283 a_665_46080.t2 VSS 0.08481f $ **FLOATING
C284 a_665_46080.n2 VSS 1.49773f $ **FLOATING
C285 a_617_43340.t1 VSS 0.03251f $ **FLOATING
C286 a_617_43340.t0 VSS 0.11421f $ **FLOATING
C287 a_617_43340.t4 VSS 0.06163f $ **FLOATING
C288 a_617_43340.n0 VSS 1.07118f $ **FLOATING
C289 a_617_43340.t3 VSS 0.08297f $ **FLOATING
C290 a_617_43340.t2 VSS 0.06956f $ **FLOATING
C291 a_617_43340.n1 VSS 2.82324f $ **FLOATING
C292 a_617_43340.n2 VSS 1.08005f $ **FLOATING
C293 a_665_43428.t0 VSS 0.04057f $ **FLOATING
C294 a_665_43428.t1 VSS 0.14071f $ **FLOATING
C295 a_665_43428.t3 VSS 0.11155f $ **FLOATING
C296 a_665_43428.n0 VSS 2.18072f $ **FLOATING
C297 a_665_43428.t4 VSS 0.08305f $ **FLOATING
C298 a_665_43428.n1 VSS 3.06877f $ **FLOATING
C299 a_665_43428.t2 VSS 0.08481f $ **FLOATING
C300 a_665_43428.n2 VSS 1.49773f $ **FLOATING
C301 a_617_40688.t1 VSS 0.03251f $ **FLOATING
C302 a_617_40688.t0 VSS 0.11421f $ **FLOATING
C303 a_617_40688.t4 VSS 0.06163f $ **FLOATING
C304 a_617_40688.n0 VSS 1.07118f $ **FLOATING
C305 a_617_40688.t3 VSS 0.08297f $ **FLOATING
C306 a_617_40688.t2 VSS 0.06956f $ **FLOATING
C307 a_617_40688.n1 VSS 2.82324f $ **FLOATING
C308 a_617_40688.n2 VSS 1.08005f $ **FLOATING
C309 a_665_40776.t0 VSS 0.04057f $ **FLOATING
C310 a_665_40776.t1 VSS 0.14071f $ **FLOATING
C311 a_665_40776.t3 VSS 0.11155f $ **FLOATING
C312 a_665_40776.n0 VSS 2.18072f $ **FLOATING
C313 a_665_40776.t4 VSS 0.08305f $ **FLOATING
C314 a_665_40776.n1 VSS 3.06877f $ **FLOATING
C315 a_665_40776.t2 VSS 0.08481f $ **FLOATING
C316 a_665_40776.n2 VSS 1.49773f $ **FLOATING
C317 a_617_38036.t1 VSS 0.03251f $ **FLOATING
C318 a_617_38036.t0 VSS 0.11421f $ **FLOATING
C319 a_617_38036.t4 VSS 0.06163f $ **FLOATING
C320 a_617_38036.n0 VSS 1.07118f $ **FLOATING
C321 a_617_38036.t3 VSS 0.08297f $ **FLOATING
C322 a_617_38036.t2 VSS 0.06956f $ **FLOATING
C323 a_617_38036.n1 VSS 2.82324f $ **FLOATING
C324 a_617_38036.n2 VSS 1.08005f $ **FLOATING
C325 a_665_38124.t0 VSS 0.04057f $ **FLOATING
C326 a_665_38124.t1 VSS 0.14071f $ **FLOATING
C327 a_665_38124.t3 VSS 0.11155f $ **FLOATING
C328 a_665_38124.n0 VSS 2.18072f $ **FLOATING
C329 a_665_38124.t4 VSS 0.08305f $ **FLOATING
C330 a_665_38124.n1 VSS 3.06877f $ **FLOATING
C331 a_665_38124.t2 VSS 0.08481f $ **FLOATING
C332 a_665_38124.n2 VSS 1.49773f $ **FLOATING
C333 a_617_35384.t1 VSS 0.03251f $ **FLOATING
C334 a_617_35384.t0 VSS 0.11421f $ **FLOATING
C335 a_617_35384.t4 VSS 0.06163f $ **FLOATING
C336 a_617_35384.n0 VSS 1.07118f $ **FLOATING
C337 a_617_35384.t3 VSS 0.08297f $ **FLOATING
C338 a_617_35384.t2 VSS 0.06956f $ **FLOATING
C339 a_617_35384.n1 VSS 2.82324f $ **FLOATING
C340 a_617_35384.n2 VSS 1.08005f $ **FLOATING
C341 a_665_35472.t1 VSS 0.04057f $ **FLOATING
C342 a_665_35472.t0 VSS 0.14071f $ **FLOATING
C343 a_665_35472.t3 VSS 0.11155f $ **FLOATING
C344 a_665_35472.n0 VSS 2.18072f $ **FLOATING
C345 a_665_35472.t4 VSS 0.08305f $ **FLOATING
C346 a_665_35472.n1 VSS 3.06877f $ **FLOATING
C347 a_665_35472.t2 VSS 0.08481f $ **FLOATING
C348 a_665_35472.n2 VSS 1.49773f $ **FLOATING
C349 a_617_32732.t1 VSS 0.03251f $ **FLOATING
C350 a_617_32732.t0 VSS 0.11421f $ **FLOATING
C351 a_617_32732.t4 VSS 0.06163f $ **FLOATING
C352 a_617_32732.n0 VSS 1.07118f $ **FLOATING
C353 a_617_32732.t3 VSS 0.08297f $ **FLOATING
C354 a_617_32732.t2 VSS 0.06956f $ **FLOATING
C355 a_617_32732.n1 VSS 2.82324f $ **FLOATING
C356 a_617_32732.n2 VSS 1.08005f $ **FLOATING
C357 a_665_32820.t1 VSS 0.04057f $ **FLOATING
C358 a_665_32820.t0 VSS 0.14071f $ **FLOATING
C359 a_665_32820.t3 VSS 0.11155f $ **FLOATING
C360 a_665_32820.n0 VSS 2.18072f $ **FLOATING
C361 a_665_32820.t4 VSS 0.08305f $ **FLOATING
C362 a_665_32820.n1 VSS 3.06877f $ **FLOATING
C363 a_665_32820.t2 VSS 0.08481f $ **FLOATING
C364 a_665_32820.n2 VSS 1.49773f $ **FLOATING
C365 a_617_30080.t1 VSS 0.03251f $ **FLOATING
C366 a_617_30080.t0 VSS 0.11421f $ **FLOATING
C367 a_617_30080.t4 VSS 0.06163f $ **FLOATING
C368 a_617_30080.n0 VSS 1.07118f $ **FLOATING
C369 a_617_30080.t3 VSS 0.08297f $ **FLOATING
C370 a_617_30080.t2 VSS 0.06956f $ **FLOATING
C371 a_617_30080.n1 VSS 2.82324f $ **FLOATING
C372 a_617_30080.n2 VSS 1.08005f $ **FLOATING
C373 a_665_30168.t0 VSS 0.04057f $ **FLOATING
C374 a_665_30168.t1 VSS 0.14071f $ **FLOATING
C375 a_665_30168.t3 VSS 0.11155f $ **FLOATING
C376 a_665_30168.n0 VSS 2.18072f $ **FLOATING
C377 a_665_30168.t4 VSS 0.08305f $ **FLOATING
C378 a_665_30168.n1 VSS 3.06877f $ **FLOATING
C379 a_665_30168.t2 VSS 0.08481f $ **FLOATING
C380 a_665_30168.n2 VSS 1.49773f $ **FLOATING
C381 a_617_27428.t1 VSS 0.03251f $ **FLOATING
C382 a_617_27428.t0 VSS 0.11421f $ **FLOATING
C383 a_617_27428.t4 VSS 0.06163f $ **FLOATING
C384 a_617_27428.n0 VSS 1.07118f $ **FLOATING
C385 a_617_27428.t3 VSS 0.08297f $ **FLOATING
C386 a_617_27428.t2 VSS 0.06956f $ **FLOATING
C387 a_617_27428.n1 VSS 2.82324f $ **FLOATING
C388 a_617_27428.n2 VSS 1.08005f $ **FLOATING
C389 a_665_27516.t1 VSS 0.04057f $ **FLOATING
C390 a_665_27516.t0 VSS 0.14071f $ **FLOATING
C391 a_665_27516.t3 VSS 0.11155f $ **FLOATING
C392 a_665_27516.n0 VSS 2.18072f $ **FLOATING
C393 a_665_27516.t4 VSS 0.08305f $ **FLOATING
C394 a_665_27516.n1 VSS 3.06877f $ **FLOATING
C395 a_665_27516.t2 VSS 0.08481f $ **FLOATING
C396 a_665_27516.n2 VSS 1.49773f $ **FLOATING
C397 a_617_24776.t1 VSS 0.03251f $ **FLOATING
C398 a_617_24776.t0 VSS 0.11421f $ **FLOATING
C399 a_617_24776.t4 VSS 0.06163f $ **FLOATING
C400 a_617_24776.n0 VSS 1.07118f $ **FLOATING
C401 a_617_24776.t3 VSS 0.08297f $ **FLOATING
C402 a_617_24776.t2 VSS 0.06956f $ **FLOATING
C403 a_617_24776.n1 VSS 2.82324f $ **FLOATING
C404 a_617_24776.n2 VSS 1.08005f $ **FLOATING
C405 a_665_24864.t1 VSS 0.04057f $ **FLOATING
C406 a_665_24864.t0 VSS 0.14071f $ **FLOATING
C407 a_665_24864.t3 VSS 0.11155f $ **FLOATING
C408 a_665_24864.n0 VSS 2.18072f $ **FLOATING
C409 a_665_24864.t4 VSS 0.08305f $ **FLOATING
C410 a_665_24864.n1 VSS 3.06877f $ **FLOATING
C411 a_665_24864.t2 VSS 0.08481f $ **FLOATING
C412 a_665_24864.n2 VSS 1.49773f $ **FLOATING
C413 a_617_22124.t1 VSS 0.03251f $ **FLOATING
C414 a_617_22124.t0 VSS 0.11421f $ **FLOATING
C415 a_617_22124.t4 VSS 0.06163f $ **FLOATING
C416 a_617_22124.n0 VSS 1.07118f $ **FLOATING
C417 a_617_22124.t3 VSS 0.08297f $ **FLOATING
C418 a_617_22124.t2 VSS 0.06956f $ **FLOATING
C419 a_617_22124.n1 VSS 2.82324f $ **FLOATING
C420 a_617_22124.n2 VSS 1.08005f $ **FLOATING
C421 a_665_22212.t0 VSS 0.04057f $ **FLOATING
C422 a_665_22212.t2 VSS 0.14071f $ **FLOATING
C423 a_665_22212.t3 VSS 0.11155f $ **FLOATING
C424 a_665_22212.n0 VSS 2.18072f $ **FLOATING
C425 a_665_22212.t4 VSS 0.08305f $ **FLOATING
C426 a_665_22212.n1 VSS 3.06877f $ **FLOATING
C427 a_665_22212.t1 VSS 0.08481f $ **FLOATING
C428 a_665_22212.n2 VSS 1.49773f $ **FLOATING
C429 a_617_19472.t1 VSS 0.03251f $ **FLOATING
C430 a_617_19472.t0 VSS 0.11421f $ **FLOATING
C431 a_617_19472.t4 VSS 0.06163f $ **FLOATING
C432 a_617_19472.n0 VSS 1.07118f $ **FLOATING
C433 a_617_19472.t3 VSS 0.08297f $ **FLOATING
C434 a_617_19472.t2 VSS 0.06956f $ **FLOATING
C435 a_617_19472.n1 VSS 2.82324f $ **FLOATING
C436 a_617_19472.n2 VSS 1.08005f $ **FLOATING
C437 a_665_19560.t0 VSS 0.04057f $ **FLOATING
C438 a_665_19560.t2 VSS 0.14071f $ **FLOATING
C439 a_665_19560.t3 VSS 0.11155f $ **FLOATING
C440 a_665_19560.n0 VSS 2.18072f $ **FLOATING
C441 a_665_19560.t4 VSS 0.08305f $ **FLOATING
C442 a_665_19560.n1 VSS 3.06877f $ **FLOATING
C443 a_665_19560.t1 VSS 0.08481f $ **FLOATING
C444 a_665_19560.n2 VSS 1.49773f $ **FLOATING
C445 a_617_16820.t1 VSS 0.03251f $ **FLOATING
C446 a_617_16820.t0 VSS 0.11421f $ **FLOATING
C447 a_617_16820.t4 VSS 0.06163f $ **FLOATING
C448 a_617_16820.n0 VSS 1.07118f $ **FLOATING
C449 a_617_16820.t3 VSS 0.08297f $ **FLOATING
C450 a_617_16820.t2 VSS 0.06956f $ **FLOATING
C451 a_617_16820.n1 VSS 2.82324f $ **FLOATING
C452 a_617_16820.n2 VSS 1.08005f $ **FLOATING
C453 a_665_16908.t2 VSS 0.04057f $ **FLOATING
C454 a_665_16908.t0 VSS 0.14071f $ **FLOATING
C455 a_665_16908.t3 VSS 0.11155f $ **FLOATING
C456 a_665_16908.n0 VSS 2.18072f $ **FLOATING
C457 a_665_16908.t4 VSS 0.08305f $ **FLOATING
C458 a_665_16908.n1 VSS 3.06877f $ **FLOATING
C459 a_665_16908.t1 VSS 0.08481f $ **FLOATING
C460 a_665_16908.n2 VSS 1.49773f $ **FLOATING
C461 a_617_14168.t1 VSS 0.03251f $ **FLOATING
C462 a_617_14168.t0 VSS 0.11421f $ **FLOATING
C463 a_617_14168.t4 VSS 0.06163f $ **FLOATING
C464 a_617_14168.n0 VSS 1.07118f $ **FLOATING
C465 a_617_14168.t3 VSS 0.08297f $ **FLOATING
C466 a_617_14168.t2 VSS 0.06956f $ **FLOATING
C467 a_617_14168.n1 VSS 2.82324f $ **FLOATING
C468 a_617_14168.n2 VSS 1.08005f $ **FLOATING
C469 a_665_14256.t1 VSS 0.04057f $ **FLOATING
C470 a_665_14256.t0 VSS 0.14071f $ **FLOATING
C471 a_665_14256.t3 VSS 0.11155f $ **FLOATING
C472 a_665_14256.n0 VSS 2.18072f $ **FLOATING
C473 a_665_14256.t4 VSS 0.08305f $ **FLOATING
C474 a_665_14256.n1 VSS 3.06877f $ **FLOATING
C475 a_665_14256.t2 VSS 0.08481f $ **FLOATING
C476 a_665_14256.n2 VSS 1.49773f $ **FLOATING
C477 a_617_11516.t1 VSS 0.03251f $ **FLOATING
C478 a_617_11516.t0 VSS 0.11421f $ **FLOATING
C479 a_617_11516.t4 VSS 0.06163f $ **FLOATING
C480 a_617_11516.n0 VSS 1.07118f $ **FLOATING
C481 a_617_11516.t3 VSS 0.08297f $ **FLOATING
C482 a_617_11516.t2 VSS 0.06956f $ **FLOATING
C483 a_617_11516.n1 VSS 2.82324f $ **FLOATING
C484 a_617_11516.n2 VSS 1.08005f $ **FLOATING
C485 a_665_11604.t1 VSS 0.04057f $ **FLOATING
C486 a_665_11604.t0 VSS 0.14071f $ **FLOATING
C487 a_665_11604.t3 VSS 0.11155f $ **FLOATING
C488 a_665_11604.n0 VSS 2.18072f $ **FLOATING
C489 a_665_11604.t4 VSS 0.08305f $ **FLOATING
C490 a_665_11604.n1 VSS 3.06877f $ **FLOATING
C491 a_665_11604.t2 VSS 0.08481f $ **FLOATING
C492 a_665_11604.n2 VSS 1.49773f $ **FLOATING
C493 a_617_8864.t1 VSS 0.03251f $ **FLOATING
C494 a_617_8864.t0 VSS 0.11421f $ **FLOATING
C495 a_617_8864.t4 VSS 0.06163f $ **FLOATING
C496 a_617_8864.n0 VSS 1.07118f $ **FLOATING
C497 a_617_8864.t3 VSS 0.08297f $ **FLOATING
C498 a_617_8864.t2 VSS 0.06956f $ **FLOATING
C499 a_617_8864.n1 VSS 2.82324f $ **FLOATING
C500 a_617_8864.n2 VSS 1.08005f $ **FLOATING
C501 a_665_8952.t0 VSS 0.04057f $ **FLOATING
C502 a_665_8952.t2 VSS 0.14071f $ **FLOATING
C503 a_665_8952.t3 VSS 0.11155f $ **FLOATING
C504 a_665_8952.n0 VSS 2.18072f $ **FLOATING
C505 a_665_8952.t4 VSS 0.08305f $ **FLOATING
C506 a_665_8952.n1 VSS 3.06877f $ **FLOATING
C507 a_665_8952.t1 VSS 0.08481f $ **FLOATING
C508 a_665_8952.n2 VSS 1.49773f $ **FLOATING
C509 a_617_6212.t1 VSS 0.03251f $ **FLOATING
C510 a_617_6212.t0 VSS 0.11421f $ **FLOATING
C511 a_617_6212.t4 VSS 0.06163f $ **FLOATING
C512 a_617_6212.n0 VSS 1.07118f $ **FLOATING
C513 a_617_6212.t3 VSS 0.08297f $ **FLOATING
C514 a_617_6212.t2 VSS 0.06956f $ **FLOATING
C515 a_617_6212.n1 VSS 2.82323f $ **FLOATING
C516 a_617_6212.n2 VSS 1.08005f $ **FLOATING
C517 a_665_6300.t1 VSS 0.04057f $ **FLOATING
C518 a_665_6300.t0 VSS 0.14071f $ **FLOATING
C519 a_665_6300.t3 VSS 0.11155f $ **FLOATING
C520 a_665_6300.n0 VSS 2.18072f $ **FLOATING
C521 a_665_6300.t4 VSS 0.08305f $ **FLOATING
C522 a_665_6300.n1 VSS 3.06877f $ **FLOATING
C523 a_665_6300.t2 VSS 0.08481f $ **FLOATING
C524 a_665_6300.n2 VSS 1.49773f $ **FLOATING
C525 a_617_3560.t2 VSS 0.03251f $ **FLOATING
C526 a_617_3560.t1 VSS 0.11421f $ **FLOATING
C527 a_617_3560.t4 VSS 0.06163f $ **FLOATING
C528 a_617_3560.n0 VSS 1.07118f $ **FLOATING
C529 a_617_3560.t3 VSS 0.08297f $ **FLOATING
C530 a_617_3560.t0 VSS 0.06956f $ **FLOATING
C531 a_617_3560.n1 VSS 2.82323f $ **FLOATING
C532 a_617_3560.n2 VSS 1.08005f $ **FLOATING
C533 a_665_3648.t0 VSS 0.04057f $ **FLOATING
C534 a_665_3648.t1 VSS 0.14071f $ **FLOATING
C535 a_665_3648.t3 VSS 0.11155f $ **FLOATING
C536 a_665_3648.n0 VSS 2.18072f $ **FLOATING
C537 a_665_3648.t4 VSS 0.08305f $ **FLOATING
C538 a_665_3648.n1 VSS 3.06877f $ **FLOATING
C539 a_665_3648.t2 VSS 0.08481f $ **FLOATING
C540 a_665_3648.n2 VSS 1.49773f $ **FLOATING
C541 a_617_908.t1 VSS 0.03237f $ **FLOATING
C542 a_617_908.t0 VSS 0.1137f $ **FLOATING
C543 a_617_908.t4 VSS 0.06135f $ **FLOATING
C544 a_617_908.n0 VSS 1.06633f $ **FLOATING
C545 a_617_908.t3 VSS 0.0826f $ **FLOATING
C546 a_617_908.t2 VSS 0.06925f $ **FLOATING
C547 a_617_908.n1 VSS 2.81047f $ **FLOATING
C548 a_617_908.n2 VSS 1.07516f $ **FLOATING
C549 a_665_996.t0 VSS 0.04047f $ **FLOATING
C550 a_665_996.t1 VSS 0.14035f $ **FLOATING
C551 a_665_996.t3 VSS 0.11126f $ **FLOATING
C552 a_665_996.n0 VSS 2.17504f $ **FLOATING
C553 a_665_996.t4 VSS 0.08284f $ **FLOATING
C554 a_665_996.n1 VSS 3.06077f $ **FLOATING
C555 a_665_996.t2 VSS 0.08459f $ **FLOATING
C556 a_665_996.n2 VSS 1.49383f $ **FLOATING
C557 sense_amp_scale1p5_flat_0.SA_OUTB.t0 VSS 0.094f $ **FLOATING
C558 sense_amp_scale1p5_flat_0.SA_OUTB.t4 VSS 0.12181f $ **FLOATING
C559 sense_amp_scale1p5_flat_0.SA_OUTB.n0 VSS 1.57111f $ **FLOATING
C560 sense_amp_scale1p5_flat_0.SA_OUTB.t1 VSS 0.2135f $ **FLOATING
C561 sense_amp_scale1p5_flat_0.SA_OUTB.n1 VSS 1.70354f $ **FLOATING
C562 sense_amp_scale1p5_flat_0.SA_OUTB.t3 VSS 0.08217f $ **FLOATING
C563 sense_amp_scale1p5_flat_0.SA_OUTB.n2 VSS 0.62737f $ **FLOATING
C564 sense_amp_scale1p5_flat_0.SA_OUTB.t2 VSS 0.24246f $ **FLOATING
C565 sense_amp_scale1p5_flat_0.SA_OUTB.n3 VSS 2.62933f $ **FLOATING
C566 sense_amp_scale1p5_flat_0.SA_OUT.t2 VSS 0.12883f $ **FLOATING
C567 sense_amp_scale1p5_flat_0.SA_OUT.t4 VSS 0.12215f $ **FLOATING
C568 sense_amp_scale1p5_flat_0.SA_OUT.n0 VSS 1.22575f $ **FLOATING
C569 sense_amp_scale1p5_flat_0.SA_OUT.t0 VSS 0.20035f $ **FLOATING
C570 sense_amp_scale1p5_flat_0.SA_OUT.n1 VSS 1.08803f $ **FLOATING
C571 sense_amp_scale1p5_flat_0.SA_OUT.t1 VSS 0.22066f $ **FLOATING
C572 sense_amp_scale1p5_flat_0.SA_OUT.t3 VSS 0.09129f $ **FLOATING
C573 sense_amp_scale1p5_flat_0.SA_OUT.n2 VSS 2.34786f $ **FLOATING
C574 sense_amp_scale1p5_flat_0.SA_OUT.n3 VSS 1.15658f $ **FLOATING
C575 a_1065_n6268.t0 VSS 0.04519f $ **FLOATING
C576 a_1065_n6268.t2 VSS 0.04869f $ **FLOATING
C577 a_1065_n6268.t1 VSS 0.04705f $ **FLOATING
C578 a_1065_n6268.n0 VSS 1.53999f $ **FLOATING
C579 a_677_n8854.t0 VSS 0.23173f $ **FLOATING
C580 a_677_n8854.t3 VSS 0.29501f $ **FLOATING
C581 a_677_n8854.n0 VSS 6.07822f $ **FLOATING
C582 a_677_n8854.t1 VSS 0.10872f $ **FLOATING
C583 a_677_n8854.t2 VSS 0.29813f $ **FLOATING
C584 a_677_n8854.n1 VSS 4.8966f $ **FLOATING
C585 a_1477_n9274.t0 VSS 5.89249f $ **FLOATING
C586 a_1477_n9274.t1 VSS 5.88718f $ **FLOATING
C587 a_3077_n9274.t0 VSS 5.87005f $ **FLOATING
C588 a_3077_n9274.t1 VSS 5.85983f $ **FLOATING
C589 a_1865_n13274.t0 VSS 4.60779f $ **FLOATING
C590 a_1865_n13274.t1 VSS 4.60944f $ **FLOATING
C591 a_3465_n13274.t0 VSS 2.60583f $ **FLOATING
C592 a_3465_n13274.t1 VSS 2.59979f $ **FLOATING
C593 VDD.t139 VSS 3.3175f $ **FLOATING
C594 VDD.t74 VSS 3.31564f $ **FLOATING
C595 VDD.n0 VSS 1.35521f $ **FLOATING
C596 VDD.t75 VSS 0.39174f $ **FLOATING
C597 VDD.n1 VSS 0.9249f $ **FLOATING
C598 VDD.t122 VSS 3.31564f $ **FLOATING
C599 VDD.n2 VSS 0.63747f $ **FLOATING
C600 VDD.t133 VSS 3.31564f $ **FLOATING
C601 VDD.n3 VSS 0.55984f $ **FLOATING
C602 VDD.t134 VSS 0.39174f $ **FLOATING
C603 VDD.n4 VSS 0.92151f $ **FLOATING
C604 VDD.t94 VSS 1.2387f $ **FLOATING
C605 VDD.t79 VSS 0.02734f $ **FLOATING
C606 VDD.n5 VSS 0.48607f $ **FLOATING
C607 VDD.t78 VSS 1.23665f $ **FLOATING
C608 VDD.n6 VSS 0.53156f $ **FLOATING
C609 VDD.t95 VSS 0.02751f $ **FLOATING
C610 VDD.n7 VSS 0.52154f $ **FLOATING
C611 VDD.n8 VSS 1.47761f $ **FLOATING
C612 VDD.n9 VSS 0.60435f $ **FLOATING
C613 VDD.t84 VSS 1.2387f $ **FLOATING
C614 VDD.t101 VSS 0.02734f $ **FLOATING
C615 VDD.n10 VSS 0.48607f $ **FLOATING
C616 VDD.t100 VSS 1.23665f $ **FLOATING
C617 VDD.n11 VSS 0.53156f $ **FLOATING
C618 VDD.t85 VSS 0.02751f $ **FLOATING
C619 VDD.n12 VSS 0.52154f $ **FLOATING
C620 VDD.n13 VSS 1.47761f $ **FLOATING
C621 VDD.n14 VSS 1.14813f $ **FLOATING
C622 VDD.t80 VSS 1.2387f $ **FLOATING
C623 VDD.t83 VSS 0.02734f $ **FLOATING
C624 VDD.n15 VSS 0.48607f $ **FLOATING
C625 VDD.t82 VSS 1.23665f $ **FLOATING
C626 VDD.n16 VSS 0.53156f $ **FLOATING
C627 VDD.t81 VSS 0.02751f $ **FLOATING
C628 VDD.n17 VSS 0.52154f $ **FLOATING
C629 VDD.n18 VSS 1.47761f $ **FLOATING
C630 VDD.n19 VSS 1.14813f $ **FLOATING
C631 VDD.t26 VSS 1.2387f $ **FLOATING
C632 VDD.t119 VSS 0.02734f $ **FLOATING
C633 VDD.n20 VSS 0.48607f $ **FLOATING
C634 VDD.t118 VSS 1.23665f $ **FLOATING
C635 VDD.n21 VSS 0.53156f $ **FLOATING
C636 VDD.t27 VSS 0.02751f $ **FLOATING
C637 VDD.n22 VSS 0.52154f $ **FLOATING
C638 VDD.n23 VSS 1.47761f $ **FLOATING
C639 VDD.n24 VSS 1.14813f $ **FLOATING
C640 VDD.t46 VSS 1.2387f $ **FLOATING
C641 VDD.t65 VSS 0.02734f $ **FLOATING
C642 VDD.n25 VSS 0.48607f $ **FLOATING
C643 VDD.t64 VSS 1.23665f $ **FLOATING
C644 VDD.n26 VSS 0.53156f $ **FLOATING
C645 VDD.t47 VSS 0.02751f $ **FLOATING
C646 VDD.n27 VSS 0.52154f $ **FLOATING
C647 VDD.n28 VSS 1.47761f $ **FLOATING
C648 VDD.n29 VSS 1.14813f $ **FLOATING
C649 VDD.t10 VSS 1.2387f $ **FLOATING
C650 VDD.t37 VSS 0.02734f $ **FLOATING
C651 VDD.n30 VSS 0.48607f $ **FLOATING
C652 VDD.t36 VSS 1.23665f $ **FLOATING
C653 VDD.n31 VSS 0.53156f $ **FLOATING
C654 VDD.t11 VSS 0.02751f $ **FLOATING
C655 VDD.n32 VSS 0.52154f $ **FLOATING
C656 VDD.n33 VSS 1.47761f $ **FLOATING
C657 VDD.n34 VSS 1.14813f $ **FLOATING
C658 VDD.t137 VSS 1.2387f $ **FLOATING
C659 VDD.t29 VSS 0.02734f $ **FLOATING
C660 VDD.n35 VSS 0.48607f $ **FLOATING
C661 VDD.t28 VSS 1.23665f $ **FLOATING
C662 VDD.n36 VSS 0.53156f $ **FLOATING
C663 VDD.t138 VSS 0.02751f $ **FLOATING
C664 VDD.n37 VSS 0.52154f $ **FLOATING
C665 VDD.n38 VSS 1.47761f $ **FLOATING
C666 VDD.n39 VSS 1.14813f $ **FLOATING
C667 VDD.t44 VSS 1.2387f $ **FLOATING
C668 VDD.t67 VSS 0.02734f $ **FLOATING
C669 VDD.n40 VSS 0.48607f $ **FLOATING
C670 VDD.t66 VSS 1.23665f $ **FLOATING
C671 VDD.n41 VSS 0.53156f $ **FLOATING
C672 VDD.t45 VSS 0.02751f $ **FLOATING
C673 VDD.n42 VSS 0.52154f $ **FLOATING
C674 VDD.n43 VSS 1.47761f $ **FLOATING
C675 VDD.n44 VSS 1.14813f $ **FLOATING
C676 VDD.t92 VSS 1.2387f $ **FLOATING
C677 VDD.t77 VSS 0.02734f $ **FLOATING
C678 VDD.n45 VSS 0.48607f $ **FLOATING
C679 VDD.t76 VSS 1.23665f $ **FLOATING
C680 VDD.n46 VSS 0.53156f $ **FLOATING
C681 VDD.t93 VSS 0.02751f $ **FLOATING
C682 VDD.n47 VSS 0.52154f $ **FLOATING
C683 VDD.n48 VSS 1.47761f $ **FLOATING
C684 VDD.n49 VSS 1.14813f $ **FLOATING
C685 VDD.t114 VSS 1.2387f $ **FLOATING
C686 VDD.t117 VSS 0.02734f $ **FLOATING
C687 VDD.n50 VSS 0.48607f $ **FLOATING
C688 VDD.t116 VSS 1.23665f $ **FLOATING
C689 VDD.n51 VSS 0.53156f $ **FLOATING
C690 VDD.t115 VSS 0.02751f $ **FLOATING
C691 VDD.n52 VSS 0.52154f $ **FLOATING
C692 VDD.n53 VSS 1.47761f $ **FLOATING
C693 VDD.n54 VSS 1.14813f $ **FLOATING
C694 VDD.t56 VSS 1.2387f $ **FLOATING
C695 VDD.t69 VSS 0.02734f $ **FLOATING
C696 VDD.n55 VSS 0.48607f $ **FLOATING
C697 VDD.t68 VSS 1.23665f $ **FLOATING
C698 VDD.n56 VSS 0.53156f $ **FLOATING
C699 VDD.t57 VSS 0.02751f $ **FLOATING
C700 VDD.n57 VSS 0.52154f $ **FLOATING
C701 VDD.n58 VSS 1.47761f $ **FLOATING
C702 VDD.n59 VSS 1.14813f $ **FLOATING
C703 VDD.t131 VSS 1.2387f $ **FLOATING
C704 VDD.t103 VSS 0.02734f $ **FLOATING
C705 VDD.n60 VSS 0.48607f $ **FLOATING
C706 VDD.t102 VSS 1.23665f $ **FLOATING
C707 VDD.n61 VSS 0.53156f $ **FLOATING
C708 VDD.t132 VSS 0.02751f $ **FLOATING
C709 VDD.n62 VSS 0.52154f $ **FLOATING
C710 VDD.n63 VSS 1.47761f $ **FLOATING
C711 VDD.n64 VSS 1.14813f $ **FLOATING
C712 VDD.t125 VSS 1.2387f $ **FLOATING
C713 VDD.t128 VSS 0.02734f $ **FLOATING
C714 VDD.n65 VSS 0.48607f $ **FLOATING
C715 VDD.t127 VSS 1.23665f $ **FLOATING
C716 VDD.n66 VSS 0.53156f $ **FLOATING
C717 VDD.t126 VSS 0.02751f $ **FLOATING
C718 VDD.n67 VSS 0.52154f $ **FLOATING
C719 VDD.n68 VSS 1.47761f $ **FLOATING
C720 VDD.n69 VSS 1.14813f $ **FLOATING
C721 VDD.t120 VSS 1.2387f $ **FLOATING
C722 VDD.t124 VSS 0.02734f $ **FLOATING
C723 VDD.n70 VSS 0.48607f $ **FLOATING
C724 VDD.t123 VSS 1.23665f $ **FLOATING
C725 VDD.n71 VSS 0.53156f $ **FLOATING
C726 VDD.t121 VSS 0.02751f $ **FLOATING
C727 VDD.n72 VSS 0.52154f $ **FLOATING
C728 VDD.n73 VSS 1.47761f $ **FLOATING
C729 VDD.n74 VSS 1.14813f $ **FLOATING
C730 VDD.t108 VSS 1.2387f $ **FLOATING
C731 VDD.t113 VSS 0.02734f $ **FLOATING
C732 VDD.n75 VSS 0.48607f $ **FLOATING
C733 VDD.t112 VSS 1.23665f $ **FLOATING
C734 VDD.n76 VSS 0.53156f $ **FLOATING
C735 VDD.t109 VSS 0.02751f $ **FLOATING
C736 VDD.n77 VSS 0.52154f $ **FLOATING
C737 VDD.n78 VSS 1.47761f $ **FLOATING
C738 VDD.n79 VSS 1.14813f $ **FLOATING
C739 VDD.t104 VSS 1.2387f $ **FLOATING
C740 VDD.t111 VSS 0.02734f $ **FLOATING
C741 VDD.n80 VSS 0.48607f $ **FLOATING
C742 VDD.t110 VSS 1.23665f $ **FLOATING
C743 VDD.n81 VSS 0.53156f $ **FLOATING
C744 VDD.t105 VSS 0.02751f $ **FLOATING
C745 VDD.n82 VSS 0.52154f $ **FLOATING
C746 VDD.n83 VSS 1.47761f $ **FLOATING
C747 VDD.n84 VSS 1.14813f $ **FLOATING
C748 VDD.t98 VSS 1.2387f $ **FLOATING
C749 VDD.t107 VSS 0.02734f $ **FLOATING
C750 VDD.n85 VSS 0.48607f $ **FLOATING
C751 VDD.t106 VSS 1.23665f $ **FLOATING
C752 VDD.n86 VSS 0.53156f $ **FLOATING
C753 VDD.t99 VSS 0.02751f $ **FLOATING
C754 VDD.n87 VSS 0.52154f $ **FLOATING
C755 VDD.n88 VSS 1.47761f $ **FLOATING
C756 VDD.n89 VSS 1.14813f $ **FLOATING
C757 VDD.t88 VSS 1.2387f $ **FLOATING
C758 VDD.t7 VSS 0.02734f $ **FLOATING
C759 VDD.n90 VSS 0.48607f $ **FLOATING
C760 VDD.t6 VSS 1.23665f $ **FLOATING
C761 VDD.n91 VSS 0.53156f $ **FLOATING
C762 VDD.t89 VSS 0.02751f $ **FLOATING
C763 VDD.n92 VSS 0.52154f $ **FLOATING
C764 VDD.n93 VSS 1.47761f $ **FLOATING
C765 VDD.n94 VSS 1.14813f $ **FLOATING
C766 VDD.t40 VSS 1.2387f $ **FLOATING
C767 VDD.t43 VSS 0.02734f $ **FLOATING
C768 VDD.n95 VSS 0.48607f $ **FLOATING
C769 VDD.t42 VSS 1.23665f $ **FLOATING
C770 VDD.n96 VSS 0.53156f $ **FLOATING
C771 VDD.t41 VSS 0.02751f $ **FLOATING
C772 VDD.n97 VSS 0.52154f $ **FLOATING
C773 VDD.n98 VSS 1.47761f $ **FLOATING
C774 VDD.n99 VSS 1.14813f $ **FLOATING
C775 VDD.t62 VSS 1.2387f $ **FLOATING
C776 VDD.t97 VSS 0.02734f $ **FLOATING
C777 VDD.n100 VSS 0.48607f $ **FLOATING
C778 VDD.t96 VSS 1.23665f $ **FLOATING
C779 VDD.n101 VSS 0.53156f $ **FLOATING
C780 VDD.t63 VSS 0.02751f $ **FLOATING
C781 VDD.n102 VSS 0.52154f $ **FLOATING
C782 VDD.n103 VSS 1.47761f $ **FLOATING
C783 VDD.n104 VSS 1.14813f $ **FLOATING
C784 VDD.t20 VSS 1.2387f $ **FLOATING
C785 VDD.t33 VSS 0.02734f $ **FLOATING
C786 VDD.n105 VSS 0.48607f $ **FLOATING
C787 VDD.t32 VSS 1.23665f $ **FLOATING
C788 VDD.n106 VSS 0.53156f $ **FLOATING
C789 VDD.t21 VSS 0.02751f $ **FLOATING
C790 VDD.n107 VSS 0.52154f $ **FLOATING
C791 VDD.n108 VSS 1.47761f $ **FLOATING
C792 VDD.n109 VSS 1.14813f $ **FLOATING
C793 VDD.t38 VSS 1.2387f $ **FLOATING
C794 VDD.t91 VSS 0.02734f $ **FLOATING
C795 VDD.n110 VSS 0.48607f $ **FLOATING
C796 VDD.t90 VSS 1.23665f $ **FLOATING
C797 VDD.n111 VSS 0.53156f $ **FLOATING
C798 VDD.t39 VSS 0.02751f $ **FLOATING
C799 VDD.n112 VSS 0.52154f $ **FLOATING
C800 VDD.n113 VSS 1.47761f $ **FLOATING
C801 VDD.n114 VSS 1.14813f $ **FLOATING
C802 VDD.t22 VSS 1.2387f $ **FLOATING
C803 VDD.t61 VSS 0.02734f $ **FLOATING
C804 VDD.n115 VSS 0.48607f $ **FLOATING
C805 VDD.t60 VSS 1.23665f $ **FLOATING
C806 VDD.n116 VSS 0.53156f $ **FLOATING
C807 VDD.t23 VSS 0.02751f $ **FLOATING
C808 VDD.n117 VSS 0.52154f $ **FLOATING
C809 VDD.n118 VSS 1.47761f $ **FLOATING
C810 VDD.n119 VSS 1.14813f $ **FLOATING
C811 VDD.t48 VSS 1.2387f $ **FLOATING
C812 VDD.t51 VSS 0.02734f $ **FLOATING
C813 VDD.n120 VSS 0.48607f $ **FLOATING
C814 VDD.t50 VSS 1.23665f $ **FLOATING
C815 VDD.n121 VSS 0.53156f $ **FLOATING
C816 VDD.t49 VSS 0.02751f $ **FLOATING
C817 VDD.n122 VSS 0.52154f $ **FLOATING
C818 VDD.n123 VSS 1.47761f $ **FLOATING
C819 VDD.n124 VSS 1.14813f $ **FLOATING
C820 VDD.t86 VSS 1.2387f $ **FLOATING
C821 VDD.t25 VSS 0.02734f $ **FLOATING
C822 VDD.n125 VSS 0.48607f $ **FLOATING
C823 VDD.t24 VSS 1.23665f $ **FLOATING
C824 VDD.n126 VSS 0.53156f $ **FLOATING
C825 VDD.t87 VSS 0.02751f $ **FLOATING
C826 VDD.n127 VSS 0.52154f $ **FLOATING
C827 VDD.n128 VSS 1.47761f $ **FLOATING
C828 VDD.n129 VSS 1.14813f $ **FLOATING
C829 VDD.t34 VSS 1.2387f $ **FLOATING
C830 VDD.t136 VSS 0.02734f $ **FLOATING
C831 VDD.n130 VSS 0.48607f $ **FLOATING
C832 VDD.t135 VSS 1.23665f $ **FLOATING
C833 VDD.n131 VSS 0.53156f $ **FLOATING
C834 VDD.t35 VSS 0.02751f $ **FLOATING
C835 VDD.n132 VSS 0.52154f $ **FLOATING
C836 VDD.n133 VSS 1.47761f $ **FLOATING
C837 VDD.n134 VSS 1.14813f $ **FLOATING
C838 VDD.t18 VSS 1.2387f $ **FLOATING
C839 VDD.t73 VSS 0.02734f $ **FLOATING
C840 VDD.n135 VSS 0.48607f $ **FLOATING
C841 VDD.t72 VSS 1.23665f $ **FLOATING
C842 VDD.n136 VSS 0.53156f $ **FLOATING
C843 VDD.t19 VSS 0.02751f $ **FLOATING
C844 VDD.n137 VSS 0.52154f $ **FLOATING
C845 VDD.n138 VSS 1.47761f $ **FLOATING
C846 VDD.n139 VSS 1.14813f $ **FLOATING
C847 VDD.t4 VSS 1.2387f $ **FLOATING
C848 VDD.t59 VSS 0.02734f $ **FLOATING
C849 VDD.n140 VSS 0.48607f $ **FLOATING
C850 VDD.t58 VSS 1.23665f $ **FLOATING
C851 VDD.n141 VSS 0.53156f $ **FLOATING
C852 VDD.t5 VSS 0.02751f $ **FLOATING
C853 VDD.n142 VSS 0.52154f $ **FLOATING
C854 VDD.n143 VSS 1.47761f $ **FLOATING
C855 VDD.n144 VSS 1.14813f $ **FLOATING
C856 VDD.t54 VSS 1.2387f $ **FLOATING
C857 VDD.t13 VSS 0.02734f $ **FLOATING
C858 VDD.n145 VSS 0.48607f $ **FLOATING
C859 VDD.t12 VSS 1.23665f $ **FLOATING
C860 VDD.n146 VSS 0.53156f $ **FLOATING
C861 VDD.t55 VSS 0.02751f $ **FLOATING
C862 VDD.n147 VSS 0.52154f $ **FLOATING
C863 VDD.n148 VSS 1.47761f $ **FLOATING
C864 VDD.n149 VSS 1.14813f $ **FLOATING
C865 VDD.t52 VSS 1.2387f $ **FLOATING
C866 VDD.t9 VSS 0.02734f $ **FLOATING
C867 VDD.n150 VSS 0.48607f $ **FLOATING
C868 VDD.t8 VSS 1.23665f $ **FLOATING
C869 VDD.n151 VSS 0.53156f $ **FLOATING
C870 VDD.t53 VSS 0.02751f $ **FLOATING
C871 VDD.n152 VSS 0.52154f $ **FLOATING
C872 VDD.n153 VSS 1.47761f $ **FLOATING
C873 VDD.n154 VSS 1.14813f $ **FLOATING
C874 VDD.t70 VSS 1.2387f $ **FLOATING
C875 VDD.t17 VSS 0.02734f $ **FLOATING
C876 VDD.n155 VSS 0.48607f $ **FLOATING
C877 VDD.t16 VSS 1.23665f $ **FLOATING
C878 VDD.n156 VSS 0.53156f $ **FLOATING
C879 VDD.t71 VSS 0.02751f $ **FLOATING
C880 VDD.n157 VSS 0.52154f $ **FLOATING
C881 VDD.n158 VSS 1.47761f $ **FLOATING
C882 VDD.n159 VSS 1.14813f $ **FLOATING
C883 VDD.t2 VSS 1.2387f $ **FLOATING
C884 VDD.t31 VSS 0.02734f $ **FLOATING
C885 VDD.n160 VSS 0.48607f $ **FLOATING
C886 VDD.t30 VSS 1.23665f $ **FLOATING
C887 VDD.n161 VSS 0.53156f $ **FLOATING
C888 VDD.t3 VSS 0.02751f $ **FLOATING
C889 VDD.n162 VSS 0.52154f $ **FLOATING
C890 VDD.n163 VSS 1.47761f $ **FLOATING
C891 VDD.n164 VSS 1.28614f $ **FLOATING
C892 VDD.t146 VSS 2.18898f $ **FLOATING
C893 VDD.t142 VSS 2.18715f $ **FLOATING
C894 VDD.n165 VSS 1.41589f $ **FLOATING
C895 VDD.t143 VSS 0.18049f $ **FLOATING
C896 VDD.n166 VSS 0.75005f $ **FLOATING
C897 VDD.t145 VSS 0.18049f $ **FLOATING
C898 VDD.n167 VSS 0.77939f $ **FLOATING
C899 VDD.t144 VSS 2.18715f $ **FLOATING
C900 VDD.n168 VSS 0.4765f $ **FLOATING
C901 VDD.n169 VSS 0.14401f $ **FLOATING
C902 VDD.n170 VSS 1.33154f $ **FLOATING
C903 VDD.t130 VSS 1.95403f $ **FLOATING
C904 VDD.t129 VSS 1.95328f $ **FLOATING
C905 VDD.n171 VSS 1.40834f $ **FLOATING
C906 VDD.t14 VSS 1.90379f $ **FLOATING
C907 VDD.n172 VSS 0.66161f $ **FLOATING
C908 VDD.t15 VSS 0.13165f $ **FLOATING
C909 VDD.n173 VSS 0.70096f $ **FLOATING
C910 VDD.t1 VSS 0.13165f $ **FLOATING
C911 VDD.n174 VSS 0.7303f $ **FLOATING
C912 VDD.t0 VSS 1.90379f $ **FLOATING
C913 VDD.n175 VSS 0.49743f $ **FLOATING
C914 VDD.n176 VSS 0.14939f $ **FLOATING
C915 VDD.n177 VSS 0.87136f $ **FLOATING
C916 VDD.t140 VSS 1.43073f $ **FLOATING
C917 VDD.n179 VSS 0.53327f $ **FLOATING
C918 VDD.t141 VSS 0.05581f $ **FLOATING
C919 VDD.n180 VSS 0.6414f $ **FLOATING
C920 WLOFF.t1 VSS 0.05298f $ **FLOATING
C921 WLOFF.t0 VSS 0.05229f $ **FLOATING
C922 WLOFF.n0 VSS 0.6004f $ **FLOATING
C923 WLOFF.t63 VSS 0.05298f $ **FLOATING
C924 WLOFF.t62 VSS 0.05229f $ **FLOATING
C925 WLOFF.n1 VSS 0.6004f $ **FLOATING
C926 WLOFF.n2 VSS 1.58327f $ **FLOATING
C927 WLOFF.n3 VSS 1.19648f $ **FLOATING
C928 WLOFF.t61 VSS 0.05298f $ **FLOATING
C929 WLOFF.t60 VSS 0.05229f $ **FLOATING
C930 WLOFF.n4 VSS 0.6004f $ **FLOATING
C931 WLOFF.n5 VSS 1.58327f $ **FLOATING
C932 WLOFF.n6 VSS 1.2738f $ **FLOATING
C933 WLOFF.t59 VSS 0.05298f $ **FLOATING
C934 WLOFF.t58 VSS 0.05229f $ **FLOATING
C935 WLOFF.n7 VSS 0.6004f $ **FLOATING
C936 WLOFF.n8 VSS 1.58327f $ **FLOATING
C937 WLOFF.n9 VSS 1.2738f $ **FLOATING
C938 WLOFF.t57 VSS 0.05298f $ **FLOATING
C939 WLOFF.t56 VSS 0.05229f $ **FLOATING
C940 WLOFF.n10 VSS 0.6004f $ **FLOATING
C941 WLOFF.n11 VSS 1.58327f $ **FLOATING
C942 WLOFF.n12 VSS 1.2738f $ **FLOATING
C943 WLOFF.t55 VSS 0.05298f $ **FLOATING
C944 WLOFF.t54 VSS 0.05229f $ **FLOATING
C945 WLOFF.n13 VSS 0.6004f $ **FLOATING
C946 WLOFF.n14 VSS 1.58327f $ **FLOATING
C947 WLOFF.n15 VSS 1.2738f $ **FLOATING
C948 WLOFF.t53 VSS 0.05298f $ **FLOATING
C949 WLOFF.t52 VSS 0.05229f $ **FLOATING
C950 WLOFF.n16 VSS 0.6004f $ **FLOATING
C951 WLOFF.n17 VSS 1.58327f $ **FLOATING
C952 WLOFF.n18 VSS 1.2738f $ **FLOATING
C953 WLOFF.t51 VSS 0.05298f $ **FLOATING
C954 WLOFF.t50 VSS 0.05229f $ **FLOATING
C955 WLOFF.n19 VSS 0.6004f $ **FLOATING
C956 WLOFF.n20 VSS 1.58327f $ **FLOATING
C957 WLOFF.n21 VSS 1.2738f $ **FLOATING
C958 WLOFF.t49 VSS 0.05298f $ **FLOATING
C959 WLOFF.t48 VSS 0.05229f $ **FLOATING
C960 WLOFF.n22 VSS 0.6004f $ **FLOATING
C961 WLOFF.n23 VSS 1.58327f $ **FLOATING
C962 WLOFF.n24 VSS 1.2738f $ **FLOATING
C963 WLOFF.t47 VSS 0.05298f $ **FLOATING
C964 WLOFF.t46 VSS 0.05229f $ **FLOATING
C965 WLOFF.n25 VSS 0.6004f $ **FLOATING
C966 WLOFF.n26 VSS 1.58327f $ **FLOATING
C967 WLOFF.n27 VSS 1.2738f $ **FLOATING
C968 WLOFF.t45 VSS 0.05298f $ **FLOATING
C969 WLOFF.t44 VSS 0.05229f $ **FLOATING
C970 WLOFF.n28 VSS 0.6004f $ **FLOATING
C971 WLOFF.n29 VSS 1.58327f $ **FLOATING
C972 WLOFF.n30 VSS 1.2738f $ **FLOATING
C973 WLOFF.t43 VSS 0.05298f $ **FLOATING
C974 WLOFF.t42 VSS 0.05229f $ **FLOATING
C975 WLOFF.n31 VSS 0.6004f $ **FLOATING
C976 WLOFF.n32 VSS 1.58327f $ **FLOATING
C977 WLOFF.n33 VSS 1.2738f $ **FLOATING
C978 WLOFF.t41 VSS 0.05298f $ **FLOATING
C979 WLOFF.t40 VSS 0.05229f $ **FLOATING
C980 WLOFF.n34 VSS 0.6004f $ **FLOATING
C981 WLOFF.n35 VSS 1.58327f $ **FLOATING
C982 WLOFF.n36 VSS 1.2738f $ **FLOATING
C983 WLOFF.t39 VSS 0.05298f $ **FLOATING
C984 WLOFF.t38 VSS 0.05229f $ **FLOATING
C985 WLOFF.n37 VSS 0.6004f $ **FLOATING
C986 WLOFF.n38 VSS 1.58327f $ **FLOATING
C987 WLOFF.n39 VSS 1.2738f $ **FLOATING
C988 WLOFF.t37 VSS 0.05298f $ **FLOATING
C989 WLOFF.t36 VSS 0.05229f $ **FLOATING
C990 WLOFF.n40 VSS 0.6004f $ **FLOATING
C991 WLOFF.n41 VSS 1.58327f $ **FLOATING
C992 WLOFF.n42 VSS 1.2738f $ **FLOATING
C993 WLOFF.t35 VSS 0.05298f $ **FLOATING
C994 WLOFF.t34 VSS 0.05229f $ **FLOATING
C995 WLOFF.n43 VSS 0.6004f $ **FLOATING
C996 WLOFF.n44 VSS 1.58327f $ **FLOATING
C997 WLOFF.n45 VSS 1.2738f $ **FLOATING
C998 WLOFF.t33 VSS 0.05298f $ **FLOATING
C999 WLOFF.t32 VSS 0.05229f $ **FLOATING
C1000 WLOFF.n46 VSS 0.6004f $ **FLOATING
C1001 WLOFF.n47 VSS 1.58327f $ **FLOATING
C1002 WLOFF.n48 VSS 1.2738f $ **FLOATING
C1003 WLOFF.t31 VSS 0.05298f $ **FLOATING
C1004 WLOFF.t30 VSS 0.05229f $ **FLOATING
C1005 WLOFF.n49 VSS 0.6004f $ **FLOATING
C1006 WLOFF.n50 VSS 1.58327f $ **FLOATING
C1007 WLOFF.n51 VSS 1.2738f $ **FLOATING
C1008 WLOFF.t29 VSS 0.05298f $ **FLOATING
C1009 WLOFF.t28 VSS 0.05229f $ **FLOATING
C1010 WLOFF.n52 VSS 0.6004f $ **FLOATING
C1011 WLOFF.n53 VSS 1.58327f $ **FLOATING
C1012 WLOFF.n54 VSS 1.2738f $ **FLOATING
C1013 WLOFF.t27 VSS 0.05298f $ **FLOATING
C1014 WLOFF.t26 VSS 0.05229f $ **FLOATING
C1015 WLOFF.n55 VSS 0.6004f $ **FLOATING
C1016 WLOFF.n56 VSS 1.58327f $ **FLOATING
C1017 WLOFF.n57 VSS 1.2738f $ **FLOATING
C1018 WLOFF.t25 VSS 0.05298f $ **FLOATING
C1019 WLOFF.t24 VSS 0.05229f $ **FLOATING
C1020 WLOFF.n58 VSS 0.6004f $ **FLOATING
C1021 WLOFF.n59 VSS 1.58327f $ **FLOATING
C1022 WLOFF.n60 VSS 1.2738f $ **FLOATING
C1023 WLOFF.t23 VSS 0.05298f $ **FLOATING
C1024 WLOFF.t22 VSS 0.05229f $ **FLOATING
C1025 WLOFF.n61 VSS 0.6004f $ **FLOATING
C1026 WLOFF.n62 VSS 1.58327f $ **FLOATING
C1027 WLOFF.n63 VSS 1.2738f $ **FLOATING
C1028 WLOFF.t21 VSS 0.05298f $ **FLOATING
C1029 WLOFF.t20 VSS 0.05229f $ **FLOATING
C1030 WLOFF.n64 VSS 0.6004f $ **FLOATING
C1031 WLOFF.n65 VSS 1.58327f $ **FLOATING
C1032 WLOFF.n66 VSS 1.2738f $ **FLOATING
C1033 WLOFF.t19 VSS 0.05298f $ **FLOATING
C1034 WLOFF.t18 VSS 0.05229f $ **FLOATING
C1035 WLOFF.n67 VSS 0.6004f $ **FLOATING
C1036 WLOFF.n68 VSS 1.58327f $ **FLOATING
C1037 WLOFF.n69 VSS 1.2738f $ **FLOATING
C1038 WLOFF.t17 VSS 0.05298f $ **FLOATING
C1039 WLOFF.t16 VSS 0.05229f $ **FLOATING
C1040 WLOFF.n70 VSS 0.6004f $ **FLOATING
C1041 WLOFF.n71 VSS 1.58327f $ **FLOATING
C1042 WLOFF.n72 VSS 1.2738f $ **FLOATING
C1043 WLOFF.t15 VSS 0.05298f $ **FLOATING
C1044 WLOFF.t14 VSS 0.05229f $ **FLOATING
C1045 WLOFF.n73 VSS 0.6004f $ **FLOATING
C1046 WLOFF.n74 VSS 1.58327f $ **FLOATING
C1047 WLOFF.n75 VSS 1.2738f $ **FLOATING
C1048 WLOFF.t13 VSS 0.05298f $ **FLOATING
C1049 WLOFF.t12 VSS 0.05229f $ **FLOATING
C1050 WLOFF.n76 VSS 0.6004f $ **FLOATING
C1051 WLOFF.n77 VSS 1.58327f $ **FLOATING
C1052 WLOFF.n78 VSS 1.2738f $ **FLOATING
C1053 WLOFF.t11 VSS 0.05298f $ **FLOATING
C1054 WLOFF.t10 VSS 0.05229f $ **FLOATING
C1055 WLOFF.n79 VSS 0.6004f $ **FLOATING
C1056 WLOFF.n80 VSS 1.58327f $ **FLOATING
C1057 WLOFF.n81 VSS 1.2738f $ **FLOATING
C1058 WLOFF.t9 VSS 0.05298f $ **FLOATING
C1059 WLOFF.t8 VSS 0.05229f $ **FLOATING
C1060 WLOFF.n82 VSS 0.6004f $ **FLOATING
C1061 WLOFF.n83 VSS 1.58327f $ **FLOATING
C1062 WLOFF.n84 VSS 1.2738f $ **FLOATING
C1063 WLOFF.t7 VSS 0.05298f $ **FLOATING
C1064 WLOFF.t6 VSS 0.05229f $ **FLOATING
C1065 WLOFF.n85 VSS 0.6004f $ **FLOATING
C1066 WLOFF.n86 VSS 1.58327f $ **FLOATING
C1067 WLOFF.n87 VSS 1.2738f $ **FLOATING
C1068 WLOFF.t5 VSS 0.05298f $ **FLOATING
C1069 WLOFF.t4 VSS 0.05229f $ **FLOATING
C1070 WLOFF.n88 VSS 0.6004f $ **FLOATING
C1071 WLOFF.n89 VSS 1.58327f $ **FLOATING
C1072 WLOFF.n90 VSS 1.2738f $ **FLOATING
C1073 WLOFF.t3 VSS 0.05298f $ **FLOATING
C1074 WLOFF.t2 VSS 0.05229f $ **FLOATING
C1075 WLOFF.n91 VSS 0.6004f $ **FLOATING
C1076 WLOFF.n92 VSS 1.58327f $ **FLOATING
C1077 WLOFF.n93 VSS 1.60803f $ **FLOATING
C1078 WLOFF.n94 VSS 1.73506f $ **FLOATING
C1079 BL.t26 VSS 0.75343f $ **FLOATING
C1080 BL.t25 VSS 1.24576f $ **FLOATING
C1081 BL.n0 VSS 7.14112f $ **FLOATING
C1082 BL.t18 VSS 0.08993f $ **FLOATING
C1083 BL.n1 VSS 3.42963f $ **FLOATING
C1084 BL.n2 VSS 1.93701f $ **FLOATING
C1085 BL.t33 VSS 0.08993f $ **FLOATING
C1086 BL.n3 VSS 3.42963f $ **FLOATING
C1087 BL.n4 VSS 2.00233f $ **FLOATING
C1088 BL.t9 VSS 0.08993f $ **FLOATING
C1089 BL.n5 VSS 3.42963f $ **FLOATING
C1090 BL.n6 VSS 2.00233f $ **FLOATING
C1091 BL.t34 VSS 0.08993f $ **FLOATING
C1092 BL.n7 VSS 3.42963f $ **FLOATING
C1093 BL.n8 VSS 2.00233f $ **FLOATING
C1094 BL.t31 VSS 0.08993f $ **FLOATING
C1095 BL.n9 VSS 3.42963f $ **FLOATING
C1096 BL.n10 VSS 2.00233f $ **FLOATING
C1097 BL.t15 VSS 0.08993f $ **FLOATING
C1098 BL.n11 VSS 3.42963f $ **FLOATING
C1099 BL.n12 VSS 2.00233f $ **FLOATING
C1100 BL.t24 VSS 0.08993f $ **FLOATING
C1101 BL.n13 VSS 3.42963f $ **FLOATING
C1102 BL.n14 VSS 2.00233f $ **FLOATING
C1103 BL.t3 VSS 0.08993f $ **FLOATING
C1104 BL.n15 VSS 3.42963f $ **FLOATING
C1105 BL.n16 VSS 2.00233f $ **FLOATING
C1106 BL.t12 VSS 0.08993f $ **FLOATING
C1107 BL.n17 VSS 3.42963f $ **FLOATING
C1108 BL.n18 VSS 2.00233f $ **FLOATING
C1109 BL.t22 VSS 0.08993f $ **FLOATING
C1110 BL.n19 VSS 3.42963f $ **FLOATING
C1111 BL.n20 VSS 2.00233f $ **FLOATING
C1112 BL.t0 VSS 0.08993f $ **FLOATING
C1113 BL.n21 VSS 3.42963f $ **FLOATING
C1114 BL.n22 VSS 2.00233f $ **FLOATING
C1115 BL.t21 VSS 0.08993f $ **FLOATING
C1116 BL.n23 VSS 3.42963f $ **FLOATING
C1117 BL.n24 VSS 2.00233f $ **FLOATING
C1118 BL.t20 VSS 0.08993f $ **FLOATING
C1119 BL.n25 VSS 3.42963f $ **FLOATING
C1120 BL.n26 VSS 2.00233f $ **FLOATING
C1121 BL.t1 VSS 0.08993f $ **FLOATING
C1122 BL.n27 VSS 3.42963f $ **FLOATING
C1123 BL.n28 VSS 2.00233f $ **FLOATING
C1124 BL.t13 VSS 0.08993f $ **FLOATING
C1125 BL.n29 VSS 3.42963f $ **FLOATING
C1126 BL.n30 VSS 2.00233f $ **FLOATING
C1127 BL.t28 VSS 0.08993f $ **FLOATING
C1128 BL.n31 VSS 3.42963f $ **FLOATING
C1129 BL.n32 VSS 2.00233f $ **FLOATING
C1130 BL.t19 VSS 0.08993f $ **FLOATING
C1131 BL.n33 VSS 3.42963f $ **FLOATING
C1132 BL.n34 VSS 2.00233f $ **FLOATING
C1133 BL.t32 VSS 0.08993f $ **FLOATING
C1134 BL.n35 VSS 3.42963f $ **FLOATING
C1135 BL.n36 VSS 2.00233f $ **FLOATING
C1136 BL.t14 VSS 0.08993f $ **FLOATING
C1137 BL.n37 VSS 3.42963f $ **FLOATING
C1138 BL.n38 VSS 2.00233f $ **FLOATING
C1139 BL.t29 VSS 0.08993f $ **FLOATING
C1140 BL.n39 VSS 3.42963f $ **FLOATING
C1141 BL.n40 VSS 2.00233f $ **FLOATING
C1142 BL.t6 VSS 0.08993f $ **FLOATING
C1143 BL.n41 VSS 3.42963f $ **FLOATING
C1144 BL.n42 VSS 2.00233f $ **FLOATING
C1145 BL.t5 VSS 0.08993f $ **FLOATING
C1146 BL.n43 VSS 3.42963f $ **FLOATING
C1147 BL.n44 VSS 2.00233f $ **FLOATING
C1148 BL.t10 VSS 0.08993f $ **FLOATING
C1149 BL.n45 VSS 3.42963f $ **FLOATING
C1150 BL.n46 VSS 2.00233f $ **FLOATING
C1151 BL.t16 VSS 0.08993f $ **FLOATING
C1152 BL.n47 VSS 3.42963f $ **FLOATING
C1153 BL.n48 VSS 2.00233f $ **FLOATING
C1154 BL.t7 VSS 0.08993f $ **FLOATING
C1155 BL.n49 VSS 3.42963f $ **FLOATING
C1156 BL.n50 VSS 2.00233f $ **FLOATING
C1157 BL.t17 VSS 0.08993f $ **FLOATING
C1158 BL.n51 VSS 3.42963f $ **FLOATING
C1159 BL.n52 VSS 2.00233f $ **FLOATING
C1160 BL.t11 VSS 0.08993f $ **FLOATING
C1161 BL.n53 VSS 3.42963f $ **FLOATING
C1162 BL.n54 VSS 2.00233f $ **FLOATING
C1163 BL.t30 VSS 0.08993f $ **FLOATING
C1164 BL.n55 VSS 3.42963f $ **FLOATING
C1165 BL.n56 VSS 2.00233f $ **FLOATING
C1166 BL.t8 VSS 0.08993f $ **FLOATING
C1167 BL.n57 VSS 3.42963f $ **FLOATING
C1168 BL.n58 VSS 2.00233f $ **FLOATING
C1169 BL.t4 VSS 0.08993f $ **FLOATING
C1170 BL.n59 VSS 3.42963f $ **FLOATING
C1171 BL.n60 VSS 2.00233f $ **FLOATING
C1172 BL.t23 VSS 0.08993f $ **FLOATING
C1173 BL.n61 VSS 3.42963f $ **FLOATING
C1174 BL.n62 VSS 2.00233f $ **FLOATING
C1175 BL.t2 VSS 0.08993f $ **FLOATING
C1176 BL.n63 VSS 3.42963f $ **FLOATING
C1177 BL.n64 VSS 1.81203f $ **FLOATING
C1178 BL.t36 VSS 0.32528f $ **FLOATING
C1179 BL.t35 VSS 0.30711f $ **FLOATING
C1180 BL.n65 VSS 3.78112f $ **FLOATING
C1181 BL.n66 VSS 0.17509f $ **FLOATING
C1182 BL.n67 VSS 1.51634f $ **FLOATING
C1183 BL.t27 VSS 0.26347f $ **FLOATING
C1184 BL.n68 VSS 3.33322f $ **FLOATING
C1185 BL.n69 VSS 3.04626f $ **FLOATING
C1186 BL.n70 VSS 0.54328f $ **FLOATING
C1187 BLB.t33 VSS 0.70937f $ **FLOATING
C1188 BLB.t34 VSS 1.13197f $ **FLOATING
C1189 BLB.n0 VSS 5.97747f $ **FLOATING
C1190 BLB.t13 VSS 0.08422f $ **FLOATING
C1191 BLB.n1 VSS 3.12891f $ **FLOATING
C1192 BLB.n2 VSS 1.85698f $ **FLOATING
C1193 BLB.t3 VSS 0.08422f $ **FLOATING
C1194 BLB.n3 VSS 3.12891f $ **FLOATING
C1195 BLB.n4 VSS 1.86545f $ **FLOATING
C1196 BLB.t6 VSS 0.08422f $ **FLOATING
C1197 BLB.n5 VSS 3.12891f $ **FLOATING
C1198 BLB.n6 VSS 1.86545f $ **FLOATING
C1199 BLB.t2 VSS 0.08422f $ **FLOATING
C1200 BLB.n7 VSS 3.12891f $ **FLOATING
C1201 BLB.n8 VSS 1.86545f $ **FLOATING
C1202 BLB.t23 VSS 0.08422f $ **FLOATING
C1203 BLB.n9 VSS 3.12891f $ **FLOATING
C1204 BLB.n10 VSS 1.86545f $ **FLOATING
C1205 BLB.t18 VSS 0.08422f $ **FLOATING
C1206 BLB.n11 VSS 3.12891f $ **FLOATING
C1207 BLB.n12 VSS 1.86545f $ **FLOATING
C1208 BLB.t7 VSS 0.08422f $ **FLOATING
C1209 BLB.n13 VSS 3.12891f $ **FLOATING
C1210 BLB.n14 VSS 1.86545f $ **FLOATING
C1211 BLB.t14 VSS 0.08422f $ **FLOATING
C1212 BLB.n15 VSS 3.12891f $ **FLOATING
C1213 BLB.n16 VSS 1.86545f $ **FLOATING
C1214 BLB.t20 VSS 0.08422f $ **FLOATING
C1215 BLB.n17 VSS 3.12891f $ **FLOATING
C1216 BLB.n18 VSS 1.86545f $ **FLOATING
C1217 BLB.t0 VSS 0.08422f $ **FLOATING
C1218 BLB.n19 VSS 3.12891f $ **FLOATING
C1219 BLB.n20 VSS 1.86545f $ **FLOATING
C1220 BLB.t19 VSS 0.08422f $ **FLOATING
C1221 BLB.n21 VSS 3.12891f $ **FLOATING
C1222 BLB.n22 VSS 1.86545f $ **FLOATING
C1223 BLB.t4 VSS 0.08422f $ **FLOATING
C1224 BLB.n23 VSS 3.12891f $ **FLOATING
C1225 BLB.n24 VSS 1.86545f $ **FLOATING
C1226 BLB.t15 VSS 0.08422f $ **FLOATING
C1227 BLB.n25 VSS 3.12891f $ **FLOATING
C1228 BLB.n26 VSS 1.86545f $ **FLOATING
C1229 BLB.t24 VSS 0.08422f $ **FLOATING
C1230 BLB.n27 VSS 3.12891f $ **FLOATING
C1231 BLB.n28 VSS 1.86545f $ **FLOATING
C1232 BLB.t9 VSS 0.08422f $ **FLOATING
C1233 BLB.n29 VSS 3.12891f $ **FLOATING
C1234 BLB.n30 VSS 1.86545f $ **FLOATING
C1235 BLB.t1 VSS 0.08422f $ **FLOATING
C1236 BLB.n31 VSS 3.12891f $ **FLOATING
C1237 BLB.n32 VSS 1.86545f $ **FLOATING
C1238 BLB.t29 VSS 0.08422f $ **FLOATING
C1239 BLB.n33 VSS 3.12891f $ **FLOATING
C1240 BLB.n34 VSS 1.86545f $ **FLOATING
C1241 BLB.t25 VSS 0.08422f $ **FLOATING
C1242 BLB.n35 VSS 3.12891f $ **FLOATING
C1243 BLB.n36 VSS 1.86545f $ **FLOATING
C1244 BLB.t10 VSS 0.08422f $ **FLOATING
C1245 BLB.n37 VSS 3.12891f $ **FLOATING
C1246 BLB.n38 VSS 1.86545f $ **FLOATING
C1247 BLB.t16 VSS 0.08422f $ **FLOATING
C1248 BLB.n39 VSS 3.12891f $ **FLOATING
C1249 BLB.n40 VSS 1.86545f $ **FLOATING
C1250 BLB.t5 VSS 0.08422f $ **FLOATING
C1251 BLB.n41 VSS 3.12891f $ **FLOATING
C1252 BLB.n42 VSS 1.86545f $ **FLOATING
C1253 BLB.t26 VSS 0.08422f $ **FLOATING
C1254 BLB.n43 VSS 3.12891f $ **FLOATING
C1255 BLB.n44 VSS 1.86545f $ **FLOATING
C1256 BLB.t8 VSS 0.08422f $ **FLOATING
C1257 BLB.n45 VSS 3.12891f $ **FLOATING
C1258 BLB.n46 VSS 1.86545f $ **FLOATING
C1259 BLB.t22 VSS 0.08422f $ **FLOATING
C1260 BLB.n47 VSS 3.12891f $ **FLOATING
C1261 BLB.n48 VSS 1.86545f $ **FLOATING
C1262 BLB.t30 VSS 0.08422f $ **FLOATING
C1263 BLB.n49 VSS 3.12891f $ **FLOATING
C1264 BLB.n50 VSS 1.86545f $ **FLOATING
C1265 BLB.t27 VSS 0.08422f $ **FLOATING
C1266 BLB.n51 VSS 3.12891f $ **FLOATING
C1267 BLB.n52 VSS 1.86545f $ **FLOATING
C1268 BLB.t11 VSS 0.08422f $ **FLOATING
C1269 BLB.n53 VSS 3.12891f $ **FLOATING
C1270 BLB.n54 VSS 1.86545f $ **FLOATING
C1271 BLB.t17 VSS 0.08422f $ **FLOATING
C1272 BLB.n55 VSS 3.12891f $ **FLOATING
C1273 BLB.n56 VSS 1.86545f $ **FLOATING
C1274 BLB.t31 VSS 0.08422f $ **FLOATING
C1275 BLB.n57 VSS 3.12891f $ **FLOATING
C1276 BLB.n58 VSS 1.86545f $ **FLOATING
C1277 BLB.t12 VSS 0.08422f $ **FLOATING
C1278 BLB.n59 VSS 3.12891f $ **FLOATING
C1279 BLB.n60 VSS 1.86545f $ **FLOATING
C1280 BLB.t32 VSS 0.08422f $ **FLOATING
C1281 BLB.n61 VSS 3.12891f $ **FLOATING
C1282 BLB.n62 VSS 1.86545f $ **FLOATING
C1283 BLB.t28 VSS 0.08422f $ **FLOATING
C1284 BLB.n63 VSS 3.12891f $ **FLOATING
C1285 BLB.n64 VSS 1.68816f $ **FLOATING
C1286 BLB.t35 VSS 0.3011f $ **FLOATING
C1287 BLB.t36 VSS 0.29144f $ **FLOATING
C1288 BLB.n65 VSS 3.33566f $ **FLOATING
C1289 BLB.n66 VSS 0.46201f $ **FLOATING
C1290 BLB.n67 VSS 1.41268f $ **FLOATING
C1291 BLB.t21 VSS 0.24182f $ **FLOATING
C1292 BLB.n68 VSS 2.89432f $ **FLOATING
C1293 BLB.n69 VSS 2.88797f $ **FLOATING
C1294 BLB.n70 VSS 1.15293f $ **FLOATING
C1295 PRECH.t0 VSS 0.16899f $ **FLOATING
C1296 PRECH.n0 VSS 1.50303f $ **FLOATING
C1297 PRECH.t1 VSS 0.16835f $ **FLOATING
C1298 PRECH.n1 VSS 0.71901f $ **FLOATING
C1299 PRECH.t2 VSS 0.16835f $ **FLOATING
C1300 PRECH.n2 VSS 0.88435f $ **FLOATING
C1301 SCLK.t1 VSS 0.11299f $ **FLOATING
C1302 SCLK.t0 VSS 0.07755f $ **FLOATING
C1303 SCLK.n0 VSS 2.09466f $ **FLOATING
C1304 SCLK.t2 VSS 0.11223f $ **FLOATING
C1305 SCLK.n1 VSS 1.31315f $ **FLOATING
C1306 SCLK.n2 VSS 0.63583f $ **FLOATING
C1307 WE.t0 VSS 0.22085f $ **FLOATING
C1308 WE.t1 VSS 0.21815f $ **FLOATING
C1309 WE.n0 VSS 5.86003f $ **FLOATING
C1310 WE.n1 VSS 0.27525f $ **FLOATING
C1311 WE.t2 VSS 0.10807f $ **FLOATING
C1312 WE.n2 VSS 2.4107f $ **FLOATING
C1313 WE.t3 VSS 0.08214f $ **FLOATING
C1314 WE.n3 VSS 0.9663f $ **FLOATING
C1315 DATA_B.t1 VSS 0.34007f $ **FLOATING
C1316 DATA_B.n0 VSS 4.96769f $ **FLOATING
C1317 DATA_B.t0 VSS 0.34206f $ **FLOATING
C1318 DATA_B.n1 VSS 3.67513f $ **FLOATING
C1319 DATA.t1 VSS 0.31905f $ **FLOATING
C1320 DATA.t0 VSS 0.31988f $ **FLOATING
C1321 DATA.n0 VSS 6.68743f $ **FLOATING
C1322 DATA.n1 VSS 1.21194f $ **FLOATING
.ends
