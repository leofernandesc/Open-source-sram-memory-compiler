* NGSPICE file created from column_32_full_g7_wpre2p52_flat.ext - technology: sky130A

.subckt column_32_full_g7_wpre2p52_flat BL BLB VSS VDD WLOFF PRECH SCLK WE DATA_B
+ DATA
X0 BLB WLOFF a_576_26220# VSS sky130_fd_pr__nfet_01v8 ad=0.171 pd=1.77 as=0.171 ps=1.77 w=0.6 l=0.15
X1 a_576_20820# a_623_20916# VDD VDD sky130_fd_pr__pfet_01v8 ad=0.1197 pd=1.41 as=0.1197 ps=1.41 w=0.42 l=0.15
X2 BLB WLOFF a_576_49620# VSS sky130_fd_pr__nfet_01v8 ad=0.171 pd=1.77 as=0.171 ps=1.77 w=0.6 l=0.15
X3 BL WLOFF a_623_2916# VSS sky130_fd_pr__nfet_01v8 ad=0.171 pd=1.77 as=0.171 ps=1.77 w=0.6 l=0.15
X4 a_623_17316# a_576_17220# VDD VDD sky130_fd_pr__pfet_01v8 ad=0.1197 pd=1.41 as=0.1197 ps=1.41 w=0.42 l=0.15
X5 a_623_28116# a_576_28020# VSS VSS sky130_fd_pr__nfet_01v8 ad=0.3591 pd=3.09 as=0.3591 ps=3.09 w=1.26 l=0.15
X6 a_576_44220# a_623_44316# VSS VSS sky130_fd_pr__nfet_01v8 ad=0.3591 pd=3.09 as=0.3591 ps=3.09 w=1.26 l=0.15
X7 a_3077_n9274# DATA BLB VDD sky130_fd_pr__pfet_01v8 ad=1.4616 pd=10.66 as=1.4616 ps=10.66 w=5.04 l=0.15
X8 BL WLOFF a_623_35316# VSS sky130_fd_pr__nfet_01v8 ad=0.171 pd=1.77 as=0.171 ps=1.77 w=0.6 l=0.15
X9 a_1065_n6268# sense_amp_scale1p5_flat_0.SA_OUT sense_amp_scale1p5_flat_0.SA_OUTB VSS sky130_fd_pr__nfet_01v8 ad=0.2842 pd=2.54 as=0.2842 ps=2.54 w=0.98 l=0.15
X10 VDD PRECH BLB VDD sky130_fd_pr__pfet_01v8 ad=0.7308 pd=5.62 as=0.7308 ps=5.62 w=2.52 l=0.15
X11 BLB WLOFF a_576_29820# VSS sky130_fd_pr__nfet_01v8 ad=0.171 pd=1.77 as=0.171 ps=1.77 w=0.6 l=0.15
X12 a_576_24420# a_623_24516# VSS VSS sky130_fd_pr__nfet_01v8 ad=0.3591 pd=3.09 as=0.3591 ps=3.09 w=1.26 l=0.15
X13 BL WLOFF a_623_15516# VSS sky130_fd_pr__nfet_01v8 ad=0.171 pd=1.77 as=0.171 ps=1.77 w=0.6 l=0.15
X14 a_576_47820# a_623_47916# VSS VSS sky130_fd_pr__nfet_01v8 ad=0.3591 pd=3.09 as=0.3591 ps=3.09 w=1.26 l=0.15
X15 a_576_44220# a_623_44316# VDD VDD sky130_fd_pr__pfet_01v8 ad=0.1197 pd=1.41 as=0.1197 ps=1.41 w=0.42 l=0.15
X16 BL WLOFF a_623_38916# VSS sky130_fd_pr__nfet_01v8 ad=0.171 pd=1.77 as=0.171 ps=1.77 w=0.6 l=0.15
X17 BLB WLOFF a_576_51420# VSS sky130_fd_pr__nfet_01v8 ad=0.171 pd=1.77 as=0.171 ps=1.77 w=0.6 l=0.15
X18 a_576_28020# a_623_28116# VSS VSS sky130_fd_pr__nfet_01v8 ad=0.3591 pd=3.09 as=0.3591 ps=3.09 w=1.26 l=0.15
X19 a_576_24420# a_623_24516# VDD VDD sky130_fd_pr__pfet_01v8 ad=0.1197 pd=1.41 as=0.1197 ps=1.41 w=0.42 l=0.15
X20 a_576_1020# a_623_1116# VDD VDD sky130_fd_pr__pfet_01v8 ad=0.1197 pd=1.41 as=0.1197 ps=1.41 w=0.42 l=0.15
X21 BL WLOFF a_623_19116# VSS sky130_fd_pr__nfet_01v8 ad=0.171 pd=1.77 as=0.171 ps=1.77 w=0.6 l=0.15
X22 a_623_42516# a_576_42420# VDD VDD sky130_fd_pr__pfet_01v8 ad=0.1197 pd=1.41 as=0.1197 ps=1.41 w=0.42 l=0.15
X23 VSS SCLK a_1065_n6268# VSS sky130_fd_pr__nfet_01v8 ad=0.2842 pd=2.54 as=0.2842 ps=2.54 w=0.98 l=0.15
X24 a_623_2916# a_576_2820# VSS VSS sky130_fd_pr__nfet_01v8 ad=0.3591 pd=3.09 as=0.3591 ps=3.09 w=1.26 l=0.15
X25 BL WLOFF a_623_6516# VSS sky130_fd_pr__nfet_01v8 ad=0.171 pd=1.77 as=0.171 ps=1.77 w=0.6 l=0.15
X26 a_576_47820# a_623_47916# VDD VDD sky130_fd_pr__pfet_01v8 ad=0.1197 pd=1.41 as=0.1197 ps=1.41 w=0.42 l=0.15
X27 a_623_53316# a_576_53220# VSS VSS sky130_fd_pr__nfet_01v8 ad=0.3591 pd=3.09 as=0.3591 ps=3.09 w=1.26 l=0.15
X28 BLB WLOFF a_576_31620# VSS sky130_fd_pr__nfet_01v8 ad=0.171 pd=1.77 as=0.171 ps=1.77 w=0.6 l=0.15
X29 a_623_10116# a_576_10020# VSS VSS sky130_fd_pr__nfet_01v8 ad=0.3591 pd=3.09 as=0.3591 ps=3.09 w=1.26 l=0.15
X30 BLB WLOFF a_576_55020# VSS sky130_fd_pr__nfet_01v8 ad=0.171 pd=1.77 as=0.171 ps=1.77 w=0.6 l=0.15
X31 a_623_22716# a_576_22620# VDD VDD sky130_fd_pr__pfet_01v8 ad=0.1197 pd=1.41 as=0.1197 ps=1.41 w=0.42 l=0.15
X32 a_576_4620# a_623_4716# VDD VDD sky130_fd_pr__pfet_01v8 ad=0.1197 pd=1.41 as=0.1197 ps=1.41 w=0.42 l=0.15
X33 a_623_33516# a_576_33420# VSS VSS sky130_fd_pr__nfet_01v8 ad=0.3591 pd=3.09 as=0.3591 ps=3.09 w=1.26 l=0.15
X34 BL WLOFF a_623_10116# VSS sky130_fd_pr__nfet_01v8 ad=0.171 pd=1.77 as=0.171 ps=1.77 w=0.6 l=0.15
X35 BLB WLOFF a_576_11820# VSS sky130_fd_pr__nfet_01v8 ad=0.171 pd=1.77 as=0.171 ps=1.77 w=0.6 l=0.15
X36 BL WLOFF a_623_40716# VSS sky130_fd_pr__nfet_01v8 ad=0.171 pd=1.77 as=0.171 ps=1.77 w=0.6 l=0.15
X37 VDD WE a_677_n8854# VDD sky130_fd_pr__pfet_01v8 ad=0.2436 pd=2.26 as=0.2436 ps=2.26 w=0.84 l=0.15
X38 a_623_56916# a_576_56820# VSS VSS sky130_fd_pr__nfet_01v8 ad=0.3591 pd=3.09 as=0.3591 ps=3.09 w=1.26 l=0.15
X39 a_623_1116# a_576_1020# VDD VDD sky130_fd_pr__pfet_01v8 ad=0.1197 pd=1.41 as=0.1197 ps=1.41 w=0.42 l=0.15
X40 a_623_13716# a_576_13620# VSS VSS sky130_fd_pr__nfet_01v8 ad=0.3591 pd=3.09 as=0.3591 ps=3.09 w=1.26 l=0.15
X41 VSS WE a_677_n8854# VSS sky130_fd_pr__nfet_01v8 ad=0.2436 pd=2.26 as=0.2436 ps=2.26 w=0.84 l=0.15
X42 BL WLOFF a_623_20916# VSS sky130_fd_pr__nfet_01v8 ad=0.171 pd=1.77 as=0.171 ps=1.77 w=0.6 l=0.15
X43 a_576_28020# a_623_28116# VDD VDD sky130_fd_pr__pfet_01v8 ad=0.1197 pd=1.41 as=0.1197 ps=1.41 w=0.42 l=0.15
X44 BLB PRECH BL VDD sky130_fd_pr__pfet_01v8 ad=0.7308 pd=5.62 as=0.7308 ps=5.62 w=2.52 l=0.15
X45 BLB WLOFF a_576_1020# VSS sky130_fd_pr__nfet_01v8 ad=0.171 pd=1.77 as=0.171 ps=1.77 w=0.6 l=0.15
X46 a_623_6516# a_576_6420# VSS VSS sky130_fd_pr__nfet_01v8 ad=0.3591 pd=3.09 as=0.3591 ps=3.09 w=1.26 l=0.15
X47 a_623_46116# a_576_46020# VDD VDD sky130_fd_pr__pfet_01v8 ad=0.1197 pd=1.41 as=0.1197 ps=1.41 w=0.42 l=0.15
X48 a_623_4716# a_576_4620# VDD VDD sky130_fd_pr__pfet_01v8 ad=0.1197 pd=1.41 as=0.1197 ps=1.41 w=0.42 l=0.15
X49 a_1865_n13274# DATA_B BL VSS sky130_fd_pr__nfet_01v8 ad=1.4616 pd=10.66 as=1.4616 ps=10.66 w=5.04 l=0.15
X50 BLB WLOFF a_576_35220# VSS sky130_fd_pr__nfet_01v8 ad=0.171 pd=1.77 as=0.171 ps=1.77 w=0.6 l=0.15
X51 a_623_26316# a_576_26220# VDD VDD sky130_fd_pr__pfet_01v8 ad=0.1197 pd=1.41 as=0.1197 ps=1.41 w=0.42 l=0.15
X52 a_576_8220# a_623_8316# VDD VDD sky130_fd_pr__pfet_01v8 ad=0.1197 pd=1.41 as=0.1197 ps=1.41 w=0.42 l=0.15
X53 a_576_53220# a_623_53316# VSS VSS sky130_fd_pr__nfet_01v8 ad=0.3591 pd=3.09 as=0.3591 ps=3.09 w=1.26 l=0.15
X54 a_623_49716# a_576_49620# VDD VDD sky130_fd_pr__pfet_01v8 ad=0.1197 pd=1.41 as=0.1197 ps=1.41 w=0.42 l=0.15
X55 a_623_37116# a_576_37020# VSS VSS sky130_fd_pr__nfet_01v8 ad=0.3591 pd=3.09 as=0.3591 ps=3.09 w=1.26 l=0.15
X56 BLB WLOFF a_576_15420# VSS sky130_fd_pr__nfet_01v8 ad=0.171 pd=1.77 as=0.171 ps=1.77 w=0.6 l=0.15
X57 BL WLOFF a_623_44316# VSS sky130_fd_pr__nfet_01v8 ad=0.171 pd=1.77 as=0.171 ps=1.77 w=0.6 l=0.15
X58 BLB WLOFF a_576_38820# VSS sky130_fd_pr__nfet_01v8 ad=0.171 pd=1.77 as=0.171 ps=1.77 w=0.6 l=0.15
X59 BLB WLOFF a_576_4620# VSS sky130_fd_pr__nfet_01v8 ad=0.171 pd=1.77 as=0.171 ps=1.77 w=0.6 l=0.15
X60 a_623_17316# a_576_17220# VSS VSS sky130_fd_pr__nfet_01v8 ad=0.3591 pd=3.09 as=0.3591 ps=3.09 w=1.26 l=0.15
X61 a_576_33420# a_623_33516# VSS VSS sky130_fd_pr__nfet_01v8 ad=0.3591 pd=3.09 as=0.3591 ps=3.09 w=1.26 l=0.15
X62 a_623_29916# a_576_29820# VDD VDD sky130_fd_pr__pfet_01v8 ad=0.1197 pd=1.41 as=0.1197 ps=1.41 w=0.42 l=0.15
X63 BL WLOFF a_623_24516# VSS sky130_fd_pr__nfet_01v8 ad=0.171 pd=1.77 as=0.171 ps=1.77 w=0.6 l=0.15
X64 BLB WLOFF a_576_19020# VSS sky130_fd_pr__nfet_01v8 ad=0.171 pd=1.77 as=0.171 ps=1.77 w=0.6 l=0.15
X65 a_576_56820# a_623_56916# VSS VSS sky130_fd_pr__nfet_01v8 ad=0.3591 pd=3.09 as=0.3591 ps=3.09 w=1.26 l=0.15
X66 a_576_53220# a_623_53316# VDD VDD sky130_fd_pr__pfet_01v8 ad=0.1197 pd=1.41 as=0.1197 ps=1.41 w=0.42 l=0.15
X67 BL WLOFF a_623_47916# VSS sky130_fd_pr__nfet_01v8 ad=0.171 pd=1.77 as=0.171 ps=1.77 w=0.6 l=0.15
X68 BL WLOFF a_623_1116# VSS sky130_fd_pr__nfet_01v8 ad=0.171 pd=1.77 as=0.171 ps=1.77 w=0.6 l=0.15
X69 a_576_4620# a_623_4716# VSS VSS sky130_fd_pr__nfet_01v8 ad=0.3591 pd=3.09 as=0.3591 ps=3.09 w=1.26 l=0.15
X70 a_623_8316# a_576_8220# VDD VDD sky130_fd_pr__pfet_01v8 ad=0.1197 pd=1.41 as=0.1197 ps=1.41 w=0.42 l=0.15
X71 a_576_13620# a_623_13716# VSS VSS sky130_fd_pr__nfet_01v8 ad=0.3591 pd=3.09 as=0.3591 ps=3.09 w=1.26 l=0.15
X72 a_576_10020# a_623_10116# VDD VDD sky130_fd_pr__pfet_01v8 ad=0.1197 pd=1.41 as=0.1197 ps=1.41 w=0.42 l=0.15
X73 a_576_37020# a_623_37116# VSS VSS sky130_fd_pr__nfet_01v8 ad=0.3591 pd=3.09 as=0.3591 ps=3.09 w=1.26 l=0.15
X74 a_576_33420# a_623_33516# VDD VDD sky130_fd_pr__pfet_01v8 ad=0.1197 pd=1.41 as=0.1197 ps=1.41 w=0.42 l=0.15
X75 BL WLOFF a_623_28116# VSS sky130_fd_pr__nfet_01v8 ad=0.171 pd=1.77 as=0.171 ps=1.77 w=0.6 l=0.15
X76 a_623_51516# a_576_51420# VDD VDD sky130_fd_pr__pfet_01v8 ad=0.1197 pd=1.41 as=0.1197 ps=1.41 w=0.42 l=0.15
X77 a_576_56820# a_623_56916# VDD VDD sky130_fd_pr__pfet_01v8 ad=0.1197 pd=1.41 as=0.1197 ps=1.41 w=0.42 l=0.15
X78 BLB WLOFF a_576_40620# VSS sky130_fd_pr__nfet_01v8 ad=0.171 pd=1.77 as=0.171 ps=1.77 w=0.6 l=0.15
X79 a_576_13620# a_623_13716# VDD VDD sky130_fd_pr__pfet_01v8 ad=0.1197 pd=1.41 as=0.1197 ps=1.41 w=0.42 l=0.15
X80 a_623_31716# a_576_31620# VDD VDD sky130_fd_pr__pfet_01v8 ad=0.1197 pd=1.41 as=0.1197 ps=1.41 w=0.42 l=0.15
X81 BLB WLOFF a_576_8220# VSS sky130_fd_pr__nfet_01v8 ad=0.171 pd=1.77 as=0.171 ps=1.77 w=0.6 l=0.15
X82 a_623_42516# a_576_42420# VSS VSS sky130_fd_pr__nfet_01v8 ad=0.3591 pd=3.09 as=0.3591 ps=3.09 w=1.26 l=0.15
X83 BLB WLOFF a_576_20820# VSS sky130_fd_pr__nfet_01v8 ad=0.171 pd=1.77 as=0.171 ps=1.77 w=0.6 l=0.15
X84 a_623_11916# a_576_11820# VDD VDD sky130_fd_pr__pfet_01v8 ad=0.1197 pd=1.41 as=0.1197 ps=1.41 w=0.42 l=0.15
X85 a_576_8220# a_623_8316# VSS VSS sky130_fd_pr__nfet_01v8 ad=0.3591 pd=3.09 as=0.3591 ps=3.09 w=1.26 l=0.15
X86 a_576_17220# a_623_17316# VSS VSS sky130_fd_pr__nfet_01v8 ad=0.3591 pd=3.09 as=0.3591 ps=3.09 w=1.26 l=0.15
X87 a_623_22716# a_576_22620# VSS VSS sky130_fd_pr__nfet_01v8 ad=0.3591 pd=3.09 as=0.3591 ps=3.09 w=1.26 l=0.15
X88 a_576_37020# a_623_37116# VDD VDD sky130_fd_pr__pfet_01v8 ad=0.1197 pd=1.41 as=0.1197 ps=1.41 w=0.42 l=0.15
X89 a_623_55116# a_576_55020# VDD VDD sky130_fd_pr__pfet_01v8 ad=0.1197 pd=1.41 as=0.1197 ps=1.41 w=0.42 l=0.15
X90 BLB WLOFF a_576_44220# VSS sky130_fd_pr__nfet_01v8 ad=0.171 pd=1.77 as=0.171 ps=1.77 w=0.6 l=0.15
X91 VDD a_677_n8854# a_1477_n9274# VDD sky130_fd_pr__pfet_01v8 ad=1.4616 pd=10.66 as=1.4616 ps=10.66 w=5.04 l=0.15
X92 a_576_17220# a_623_17316# VDD VDD sky130_fd_pr__pfet_01v8 ad=0.1197 pd=1.41 as=0.1197 ps=1.41 w=0.42 l=0.15
X93 a_623_35316# a_576_35220# VDD VDD sky130_fd_pr__pfet_01v8 ad=0.1197 pd=1.41 as=0.1197 ps=1.41 w=0.42 l=0.15
X94 a_623_46116# a_576_46020# VSS VSS sky130_fd_pr__nfet_01v8 ad=0.3591 pd=3.09 as=0.3591 ps=3.09 w=1.26 l=0.15
X95 BLB WLOFF a_576_24420# VSS sky130_fd_pr__nfet_01v8 ad=0.171 pd=1.77 as=0.171 ps=1.77 w=0.6 l=0.15
X96 BL WLOFF a_623_53316# VSS sky130_fd_pr__nfet_01v8 ad=0.171 pd=1.77 as=0.171 ps=1.77 w=0.6 l=0.15
X97 VSS WE a_1865_n13274# VSS sky130_fd_pr__nfet_01v8 ad=1.4616 pd=10.66 as=1.4616 ps=10.66 w=5.04 l=0.15
X98 BLB WLOFF a_576_47820# VSS sky130_fd_pr__nfet_01v8 ad=0.171 pd=1.77 as=0.171 ps=1.77 w=0.6 l=0.15
X99 a_623_15516# a_576_15420# VDD VDD sky130_fd_pr__pfet_01v8 ad=0.1197 pd=1.41 as=0.1197 ps=1.41 w=0.42 l=0.15
X100 a_623_26316# a_576_26220# VSS VSS sky130_fd_pr__nfet_01v8 ad=0.3591 pd=3.09 as=0.3591 ps=3.09 w=1.26 l=0.15
X101 a_576_42420# a_623_42516# VSS VSS sky130_fd_pr__nfet_01v8 ad=0.3591 pd=3.09 as=0.3591 ps=3.09 w=1.26 l=0.15
X102 a_623_38916# a_576_38820# VDD VDD sky130_fd_pr__pfet_01v8 ad=0.1197 pd=1.41 as=0.1197 ps=1.41 w=0.42 l=0.15
X103 a_623_49716# a_576_49620# VSS VSS sky130_fd_pr__nfet_01v8 ad=0.3591 pd=3.09 as=0.3591 ps=3.09 w=1.26 l=0.15
X104 BL WLOFF a_623_33516# VSS sky130_fd_pr__nfet_01v8 ad=0.171 pd=1.77 as=0.171 ps=1.77 w=0.6 l=0.15
X105 BLB WLOFF a_576_28020# VSS sky130_fd_pr__nfet_01v8 ad=0.171 pd=1.77 as=0.171 ps=1.77 w=0.6 l=0.15
X106 BL WLOFF a_623_56916# VSS sky130_fd_pr__nfet_01v8 ad=0.171 pd=1.77 as=0.171 ps=1.77 w=0.6 l=0.15
X107 a_576_22620# a_623_22716# VSS VSS sky130_fd_pr__nfet_01v8 ad=0.3591 pd=3.09 as=0.3591 ps=3.09 w=1.26 l=0.15
X108 BL WLOFF a_623_13716# VSS sky130_fd_pr__nfet_01v8 ad=0.171 pd=1.77 as=0.171 ps=1.77 w=0.6 l=0.15
X109 a_576_46020# a_623_46116# VSS VSS sky130_fd_pr__nfet_01v8 ad=0.3591 pd=3.09 as=0.3591 ps=3.09 w=1.26 l=0.15
X110 a_623_29916# a_576_29820# VSS VSS sky130_fd_pr__nfet_01v8 ad=0.3591 pd=3.09 as=0.3591 ps=3.09 w=1.26 l=0.15
X111 a_576_42420# a_623_42516# VDD VDD sky130_fd_pr__pfet_01v8 ad=0.1197 pd=1.41 as=0.1197 ps=1.41 w=0.42 l=0.15
X112 BL WLOFF a_623_37116# VSS sky130_fd_pr__nfet_01v8 ad=0.171 pd=1.77 as=0.171 ps=1.77 w=0.6 l=0.15
X113 VDD sense_amp_scale1p5_flat_0.SA_OUTB sense_amp_scale1p5_flat_0.SA_OUT VDD sky130_fd_pr__pfet_01v8 ad=0.5481 pd=4.36 as=0.5481 ps=4.36 w=1.89 l=0.15
X114 a_576_22620# a_623_22716# VDD VDD sky130_fd_pr__pfet_01v8 ad=0.1197 pd=1.41 as=0.1197 ps=1.41 w=0.42 l=0.15
X115 a_623_40716# a_576_40620# VDD VDD sky130_fd_pr__pfet_01v8 ad=0.1197 pd=1.41 as=0.1197 ps=1.41 w=0.42 l=0.15
X116 BL WLOFF a_623_4716# VSS sky130_fd_pr__nfet_01v8 ad=0.171 pd=1.77 as=0.171 ps=1.77 w=0.6 l=0.15
X117 a_623_19116# a_576_19020# VDD VDD sky130_fd_pr__pfet_01v8 ad=0.1197 pd=1.41 as=0.1197 ps=1.41 w=0.42 l=0.15
X118 a_623_51516# a_576_51420# VSS VSS sky130_fd_pr__nfet_01v8 ad=0.3591 pd=3.09 as=0.3591 ps=3.09 w=1.26 l=0.15
X119 a_576_2820# a_623_2916# VDD VDD sky130_fd_pr__pfet_01v8 ad=0.1197 pd=1.41 as=0.1197 ps=1.41 w=0.42 l=0.15
X120 a_623_20916# a_576_20820# VDD VDD sky130_fd_pr__pfet_01v8 ad=0.1197 pd=1.41 as=0.1197 ps=1.41 w=0.42 l=0.15
X121 a_623_31716# a_576_31620# VSS VSS sky130_fd_pr__nfet_01v8 ad=0.3591 pd=3.09 as=0.3591 ps=3.09 w=1.26 l=0.15
X122 a_576_26220# a_623_26316# VSS VSS sky130_fd_pr__nfet_01v8 ad=0.3591 pd=3.09 as=0.3591 ps=3.09 w=1.26 l=0.15
X123 a_1477_n9274# DATA_B BL VDD sky130_fd_pr__pfet_01v8 ad=1.4616 pd=10.66 as=1.4616 ps=10.66 w=5.04 l=0.15
X124 a_576_1020# a_623_1116# VSS VSS sky130_fd_pr__nfet_01v8 ad=0.3591 pd=3.09 as=0.3591 ps=3.09 w=1.26 l=0.15
X125 a_623_1116# a_576_1020# VSS VSS sky130_fd_pr__nfet_01v8 ad=0.3591 pd=3.09 as=0.3591 ps=3.09 w=1.26 l=0.15
X126 BL WLOFF a_623_17316# VSS sky130_fd_pr__nfet_01v8 ad=0.171 pd=1.77 as=0.171 ps=1.77 w=0.6 l=0.15
X127 a_576_49620# a_623_49716# VSS VSS sky130_fd_pr__nfet_01v8 ad=0.3591 pd=3.09 as=0.3591 ps=3.09 w=1.26 l=0.15
X128 VDD sense_amp_scale1p5_flat_0.SA_OUT sense_amp_scale1p5_flat_0.SA_OUTB VDD sky130_fd_pr__pfet_01v8 ad=0.5481 pd=4.36 as=0.5481 ps=4.36 w=1.89 l=0.15
X129 a_576_46020# a_623_46116# VDD VDD sky130_fd_pr__pfet_01v8 ad=0.1197 pd=1.41 as=0.1197 ps=1.41 w=0.42 l=0.15
X130 a_623_11916# a_576_11820# VSS VSS sky130_fd_pr__nfet_01v8 ad=0.3591 pd=3.09 as=0.3591 ps=3.09 w=1.26 l=0.15
X131 BLB WLOFF a_576_53220# VSS sky130_fd_pr__nfet_01v8 ad=0.171 pd=1.77 as=0.171 ps=1.77 w=0.6 l=0.15
X132 a_576_29820# a_623_29916# VSS VSS sky130_fd_pr__nfet_01v8 ad=0.3591 pd=3.09 as=0.3591 ps=3.09 w=1.26 l=0.15
X133 a_576_26220# a_623_26316# VDD VDD sky130_fd_pr__pfet_01v8 ad=0.1197 pd=1.41 as=0.1197 ps=1.41 w=0.42 l=0.15
X134 a_623_4716# a_576_4620# VSS VSS sky130_fd_pr__nfet_01v8 ad=0.3591 pd=3.09 as=0.3591 ps=3.09 w=1.26 l=0.15
X135 BL WLOFF a_623_8316# VSS sky130_fd_pr__nfet_01v8 ad=0.171 pd=1.77 as=0.171 ps=1.77 w=0.6 l=0.15
X136 a_623_44316# a_576_44220# VDD VDD sky130_fd_pr__pfet_01v8 ad=0.1197 pd=1.41 as=0.1197 ps=1.41 w=0.42 l=0.15
X137 a_623_2916# a_576_2820# VDD VDD sky130_fd_pr__pfet_01v8 ad=0.1197 pd=1.41 as=0.1197 ps=1.41 w=0.42 l=0.15
X138 a_576_49620# a_623_49716# VDD VDD sky130_fd_pr__pfet_01v8 ad=0.1197 pd=1.41 as=0.1197 ps=1.41 w=0.42 l=0.15
X139 a_623_55116# a_576_55020# VSS VSS sky130_fd_pr__nfet_01v8 ad=0.3591 pd=3.09 as=0.3591 ps=3.09 w=1.26 l=0.15
X140 BLB WLOFF a_576_33420# VSS sky130_fd_pr__nfet_01v8 ad=0.171 pd=1.77 as=0.171 ps=1.77 w=0.6 l=0.15
X141 a_623_24516# a_576_24420# VDD VDD sky130_fd_pr__pfet_01v8 ad=0.1197 pd=1.41 as=0.1197 ps=1.41 w=0.42 l=0.15
X142 BLB WLOFF a_576_56820# VSS sky130_fd_pr__nfet_01v8 ad=0.171 pd=1.77 as=0.171 ps=1.77 w=0.6 l=0.15
X143 a_576_29820# a_623_29916# VDD VDD sky130_fd_pr__pfet_01v8 ad=0.1197 pd=1.41 as=0.1197 ps=1.41 w=0.42 l=0.15
X144 a_576_6420# a_623_6516# VDD VDD sky130_fd_pr__pfet_01v8 ad=0.1197 pd=1.41 as=0.1197 ps=1.41 w=0.42 l=0.15
X145 a_576_51420# a_623_51516# VSS VSS sky130_fd_pr__nfet_01v8 ad=0.3591 pd=3.09 as=0.3591 ps=3.09 w=1.26 l=0.15
X146 a_623_47916# a_576_47820# VDD VDD sky130_fd_pr__pfet_01v8 ad=0.1197 pd=1.41 as=0.1197 ps=1.41 w=0.42 l=0.15
X147 a_623_35316# a_576_35220# VSS VSS sky130_fd_pr__nfet_01v8 ad=0.3591 pd=3.09 as=0.3591 ps=3.09 w=1.26 l=0.15
X148 BLB WLOFF a_576_13620# VSS sky130_fd_pr__nfet_01v8 ad=0.171 pd=1.77 as=0.171 ps=1.77 w=0.6 l=0.15
X149 BL WLOFF a_623_42516# VSS sky130_fd_pr__nfet_01v8 ad=0.171 pd=1.77 as=0.171 ps=1.77 w=0.6 l=0.15
X150 BLB WLOFF a_576_37020# VSS sky130_fd_pr__nfet_01v8 ad=0.171 pd=1.77 as=0.171 ps=1.77 w=0.6 l=0.15
X151 a_3465_n13274# DATA BLB VSS sky130_fd_pr__nfet_01v8 ad=1.4616 pd=10.66 as=1.4616 ps=10.66 w=5.04 l=0.15
X152 BLB WLOFF a_576_2820# VSS sky130_fd_pr__nfet_01v8 ad=0.171 pd=1.77 as=0.171 ps=1.77 w=0.6 l=0.15
X153 a_623_15516# a_576_15420# VSS VSS sky130_fd_pr__nfet_01v8 ad=0.3591 pd=3.09 as=0.3591 ps=3.09 w=1.26 l=0.15
X154 a_576_31620# a_623_31716# VSS VSS sky130_fd_pr__nfet_01v8 ad=0.3591 pd=3.09 as=0.3591 ps=3.09 w=1.26 l=0.15
X155 BL WLOFF a_623_22716# VSS sky130_fd_pr__nfet_01v8 ad=0.171 pd=1.77 as=0.171 ps=1.77 w=0.6 l=0.15
X156 a_623_38916# a_576_38820# VSS VSS sky130_fd_pr__nfet_01v8 ad=0.3591 pd=3.09 as=0.3591 ps=3.09 w=1.26 l=0.15
X157 a_576_55020# a_623_55116# VSS VSS sky130_fd_pr__nfet_01v8 ad=0.3591 pd=3.09 as=0.3591 ps=3.09 w=1.26 l=0.15
X158 a_576_51420# a_623_51516# VDD VDD sky130_fd_pr__pfet_01v8 ad=0.1197 pd=1.41 as=0.1197 ps=1.41 w=0.42 l=0.15
X159 BL WLOFF a_623_46116# VSS sky130_fd_pr__nfet_01v8 ad=0.171 pd=1.77 as=0.171 ps=1.77 w=0.6 l=0.15
X160 a_576_2820# a_623_2916# VSS VSS sky130_fd_pr__nfet_01v8 ad=0.3591 pd=3.09 as=0.3591 ps=3.09 w=1.26 l=0.15
X161 a_623_8316# a_576_8220# VSS VSS sky130_fd_pr__nfet_01v8 ad=0.3591 pd=3.09 as=0.3591 ps=3.09 w=1.26 l=0.15
X162 a_623_6516# a_576_6420# VDD VDD sky130_fd_pr__pfet_01v8 ad=0.1197 pd=1.41 as=0.1197 ps=1.41 w=0.42 l=0.15
X163 a_576_11820# a_623_11916# VSS VSS sky130_fd_pr__nfet_01v8 ad=0.3591 pd=3.09 as=0.3591 ps=3.09 w=1.26 l=0.15
X164 VDD a_677_n8854# a_3077_n9274# VDD sky130_fd_pr__pfet_01v8 ad=1.4616 pd=10.66 as=1.4616 ps=10.66 w=5.04 l=0.15
X165 a_576_31620# a_623_31716# VDD VDD sky130_fd_pr__pfet_01v8 ad=0.1197 pd=1.41 as=0.1197 ps=1.41 w=0.42 l=0.15
X166 a_623_28116# a_576_28020# VDD VDD sky130_fd_pr__pfet_01v8 ad=0.1197 pd=1.41 as=0.1197 ps=1.41 w=0.42 l=0.15
X167 BLB WLOFF a_576_17220# VSS sky130_fd_pr__nfet_01v8 ad=0.171 pd=1.77 as=0.171 ps=1.77 w=0.6 l=0.15
X168 a_576_11820# a_623_11916# VDD VDD sky130_fd_pr__pfet_01v8 ad=0.1197 pd=1.41 as=0.1197 ps=1.41 w=0.42 l=0.15
X169 BLB WLOFF a_576_6420# VSS sky130_fd_pr__nfet_01v8 ad=0.171 pd=1.77 as=0.171 ps=1.77 w=0.6 l=0.15
X170 a_623_40716# a_576_40620# VSS VSS sky130_fd_pr__nfet_01v8 ad=0.3591 pd=3.09 as=0.3591 ps=3.09 w=1.26 l=0.15
X171 sense_amp_scale1p5_flat_0.SA_OUT SCLK BL VDD sky130_fd_pr__pfet_01v8 ad=0.58 pd=4.58 as=0.58 ps=4.58 w=2 l=0.15
X172 a_623_19116# a_576_19020# VSS VSS sky130_fd_pr__nfet_01v8 ad=0.3591 pd=3.09 as=0.3591 ps=3.09 w=1.26 l=0.15
X173 a_576_35220# a_623_35316# VSS VSS sky130_fd_pr__nfet_01v8 ad=0.3591 pd=3.09 as=0.3591 ps=3.09 w=1.26 l=0.15
X174 BL WLOFF a_623_26316# VSS sky130_fd_pr__nfet_01v8 ad=0.171 pd=1.77 as=0.171 ps=1.77 w=0.6 l=0.15
X175 a_576_55020# a_623_55116# VDD VDD sky130_fd_pr__pfet_01v8 ad=0.1197 pd=1.41 as=0.1197 ps=1.41 w=0.42 l=0.15
X176 BL WLOFF a_623_49716# VSS sky130_fd_pr__nfet_01v8 ad=0.171 pd=1.77 as=0.171 ps=1.77 w=0.6 l=0.15
X177 a_576_6420# a_623_6516# VSS VSS sky130_fd_pr__nfet_01v8 ad=0.3591 pd=3.09 as=0.3591 ps=3.09 w=1.26 l=0.15
X178 BLB WLOFF a_576_10020# VSS sky130_fd_pr__nfet_01v8 ad=0.171 pd=1.77 as=0.171 ps=1.77 w=0.6 l=0.15
X179 a_576_15420# a_623_15516# VSS VSS sky130_fd_pr__nfet_01v8 ad=0.3591 pd=3.09 as=0.3591 ps=3.09 w=1.26 l=0.15
X180 a_623_20916# a_576_20820# VSS VSS sky130_fd_pr__nfet_01v8 ad=0.3591 pd=3.09 as=0.3591 ps=3.09 w=1.26 l=0.15
X181 a_576_38820# a_623_38916# VSS VSS sky130_fd_pr__nfet_01v8 ad=0.3591 pd=3.09 as=0.3591 ps=3.09 w=1.26 l=0.15
X182 a_576_35220# a_623_35316# VDD VDD sky130_fd_pr__pfet_01v8 ad=0.1197 pd=1.41 as=0.1197 ps=1.41 w=0.42 l=0.15
X183 a_1065_n6268# sense_amp_scale1p5_flat_0.SA_OUTB sense_amp_scale1p5_flat_0.SA_OUT VSS sky130_fd_pr__nfet_01v8 ad=0.2842 pd=2.54 as=0.2842 ps=2.54 w=0.98 l=0.15
X184 a_623_53316# a_576_53220# VDD VDD sky130_fd_pr__pfet_01v8 ad=0.1197 pd=1.41 as=0.1197 ps=1.41 w=0.42 l=0.15
X185 BL WLOFF a_623_29916# VSS sky130_fd_pr__nfet_01v8 ad=0.171 pd=1.77 as=0.171 ps=1.77 w=0.6 l=0.15
X186 BLB WLOFF a_576_42420# VSS sky130_fd_pr__nfet_01v8 ad=0.171 pd=1.77 as=0.171 ps=1.77 w=0.6 l=0.15
X187 a_576_10020# a_623_10116# VSS VSS sky130_fd_pr__nfet_01v8 ad=0.3591 pd=3.09 as=0.3591 ps=3.09 w=1.26 l=0.15
X188 a_623_10116# a_576_10020# VDD VDD sky130_fd_pr__pfet_01v8 ad=0.1197 pd=1.41 as=0.1197 ps=1.41 w=0.42 l=0.15
X189 a_576_19020# a_623_19116# VSS VSS sky130_fd_pr__nfet_01v8 ad=0.3591 pd=3.09 as=0.3591 ps=3.09 w=1.26 l=0.15
X190 a_576_15420# a_623_15516# VDD VDD sky130_fd_pr__pfet_01v8 ad=0.1197 pd=1.41 as=0.1197 ps=1.41 w=0.42 l=0.15
X191 a_623_33516# a_576_33420# VDD VDD sky130_fd_pr__pfet_01v8 ad=0.1197 pd=1.41 as=0.1197 ps=1.41 w=0.42 l=0.15
X192 a_623_44316# a_576_44220# VSS VSS sky130_fd_pr__nfet_01v8 ad=0.3591 pd=3.09 as=0.3591 ps=3.09 w=1.26 l=0.15
X193 a_576_38820# a_623_38916# VDD VDD sky130_fd_pr__pfet_01v8 ad=0.1197 pd=1.41 as=0.1197 ps=1.41 w=0.42 l=0.15
X194 BLB WLOFF a_576_22620# VSS sky130_fd_pr__nfet_01v8 ad=0.171 pd=1.77 as=0.171 ps=1.77 w=0.6 l=0.15
X195 a_623_56916# a_576_56820# VDD VDD sky130_fd_pr__pfet_01v8 ad=0.1197 pd=1.41 as=0.1197 ps=1.41 w=0.42 l=0.15
X196 BL WLOFF a_623_51516# VSS sky130_fd_pr__nfet_01v8 ad=0.171 pd=1.77 as=0.171 ps=1.77 w=0.6 l=0.15
X197 BLB WLOFF a_576_46020# VSS sky130_fd_pr__nfet_01v8 ad=0.171 pd=1.77 as=0.171 ps=1.77 w=0.6 l=0.15
X198 a_623_13716# a_576_13620# VDD VDD sky130_fd_pr__pfet_01v8 ad=0.1197 pd=1.41 as=0.1197 ps=1.41 w=0.42 l=0.15
X199 a_576_40620# a_623_40716# VSS VSS sky130_fd_pr__nfet_01v8 ad=0.3591 pd=3.09 as=0.3591 ps=3.09 w=1.26 l=0.15
X200 a_623_24516# a_576_24420# VSS VSS sky130_fd_pr__nfet_01v8 ad=0.3591 pd=3.09 as=0.3591 ps=3.09 w=1.26 l=0.15
X201 BL WLOFF a_623_31716# VSS sky130_fd_pr__nfet_01v8 ad=0.171 pd=1.77 as=0.171 ps=1.77 w=0.6 l=0.15
X202 a_623_47916# a_576_47820# VSS VSS sky130_fd_pr__nfet_01v8 ad=0.3591 pd=3.09 as=0.3591 ps=3.09 w=1.26 l=0.15
X203 VDD PRECH BL VDD sky130_fd_pr__pfet_01v8 ad=0.7308 pd=5.62 as=0.7308 ps=5.62 w=2.52 l=0.15
X204 BL WLOFF a_623_55116# VSS sky130_fd_pr__nfet_01v8 ad=0.171 pd=1.77 as=0.171 ps=1.77 w=0.6 l=0.15
X205 VSS WE a_3465_n13274# VSS sky130_fd_pr__nfet_01v8 ad=1.4616 pd=10.66 as=1.4616 ps=10.66 w=5.04 l=0.15
X206 a_576_20820# a_623_20916# VSS VSS sky130_fd_pr__nfet_01v8 ad=0.3591 pd=3.09 as=0.3591 ps=3.09 w=1.26 l=0.15
X207 BLB SCLK sense_amp_scale1p5_flat_0.SA_OUTB VDD sky130_fd_pr__pfet_01v8 ad=0.58 pd=4.58 as=0.58 ps=4.58 w=2 l=0.15
X208 BL WLOFF a_623_11916# VSS sky130_fd_pr__nfet_01v8 ad=0.171 pd=1.77 as=0.171 ps=1.77 w=0.6 l=0.15
X209 a_576_40620# a_623_40716# VDD VDD sky130_fd_pr__pfet_01v8 ad=0.1197 pd=1.41 as=0.1197 ps=1.41 w=0.42 l=0.15
X210 a_576_19020# a_623_19116# VDD VDD sky130_fd_pr__pfet_01v8 ad=0.1197 pd=1.41 as=0.1197 ps=1.41 w=0.42 l=0.15
X211 a_623_37116# a_576_37020# VDD VDD sky130_fd_pr__pfet_01v8 ad=0.1197 pd=1.41 as=0.1197 ps=1.41 w=0.42 l=0.15
.ends
