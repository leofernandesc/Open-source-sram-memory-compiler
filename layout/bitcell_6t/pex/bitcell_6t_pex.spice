* NGSPICE file created from bitcell_6t_flat.ext - technology: sky130A

.subckt bitcell_6t_flat VDD BL BLB VSS WL
X0 a_173_n1434.t1 a_126_n1530.t4 VDD.t3 VDD.t2 sky130_fd_pr__pfet_01v8 ad=0.1197 pd=1.41 as=0.1197 ps=1.41 w=0.42 l=0.15
X1 a_126_n1530.t0 a_173_n1434.t4 VDD.t1 VDD.t0 sky130_fd_pr__pfet_01v8 ad=0.1197 pd=1.41 as=0.1197 ps=1.41 w=0.42 l=0.15
X2 a_173_n1434.t0 a_126_n1530.t3 VSS.t3 VSS.t2 sky130_fd_pr__nfet_01v8 ad=0.3591 pd=3.09 as=0.3591 ps=3.09 w=1.26 l=0.15
X3 BLB.t0 WL.t0 a_126_n1530.t2 VSS.t5 sky130_fd_pr__nfet_01v8 ad=0.171 pd=1.77 as=0.171 ps=1.77 w=0.6 l=0.15
X4 a_126_n1530.t1 a_173_n1434.t3 VSS.t1 VSS.t0 sky130_fd_pr__nfet_01v8 ad=0.3591 pd=3.09 as=0.3591 ps=3.09 w=1.26 l=0.15
X5 BL.t0 WL.t1 a_173_n1434.t2 VSS.t4 sky130_fd_pr__nfet_01v8 ad=0.171 pd=1.77 as=0.171 ps=1.77 w=0.6 l=0.15
C0 BL WL 2.10522f
C1 BLB WL 0.32638f
C2 BL VDD 0.00122f
C3 BLB VDD 0.001f
C4 WL VDD 0.00242f
C5 BLB BL 1.67063f
R0 BLB BLB.t0 233.912
R1 BL BL.t0 233.48
R2 WL.n0 WL.t0 330.012
R3 WL.n0 WL.t1 329.848
R4 WL WL.n0 1.48492
R5 VDD.n12 VDD.n4 1224.71
R6 VDD.n8 VDD.n5 1224.71
R7 VDD.n12 VDD.n5 1224.71
R8 VDD.n19 VDD.n1 1224.71
R9 VDD.n19 VDD.n2 1224.71
R10 VDD.n15 VDD.n2 1224.71
R11 VDD.n15 VDD.n1 1224.71
R12 VDD.n0 VDD.t1 669.717
R13 VDD.n0 VDD.t3 669.297
R14 VDD VDD.n20 615.634
R15 VDD.n13 VDD.t0 319.38
R16 VDD.n14 VDD.t2 319.38
R17 VDD.n20 VDD.t2 319.38
R18 VDD.n8 VDD.n7 266.092
R19 VDD.n9 VDD.n6 130.636
R20 VDD.n11 VDD.n6 130.636
R21 VDD.n10 VDD.n9 130.636
R22 VDD.n11 VDD.n10 130.636
R23 VDD.n18 VDD.n3 130.636
R24 VDD.n18 VDD.n17 130.636
R25 VDD.n17 VDD.n16 130.636
R26 VDD.n16 VDD.n3 130.636
R27 VDD.n14 VDD.n13 111.885
R28 VDD.n3 VDD.n1 92.5005
R29 VDD.n1 VDD.t2 92.5005
R30 VDD.n10 VDD.n5 92.5005
R31 VDD.n5 VDD.t0 92.5005
R32 VDD.n6 VDD.n4 92.5005
R33 VDD.n17 VDD.n2 92.5005
R34 VDD.n2 VDD.t2 92.5005
R35 VDD.n7 VDD.n4 67.3191
R36 VDD.n12 VDD.n11 46.2505
R37 VDD.n13 VDD.n12 46.2505
R38 VDD.n9 VDD.n8 46.2505
R39 VDD.n19 VDD.n18 46.2505
R40 VDD.n20 VDD.n19 46.2505
R41 VDD.n16 VDD.n15 46.2505
R42 VDD.n15 VDD.n14 46.2505
R43 VDD.n7 VDD.t0 20.0984
R44 VDD VDD.n0 0.24725
R45 VSS.n20 VSS.n12 2450.91
R46 VSS.n16 VSS.n12 2450.91
R47 VSS.n20 VSS.n13 2450.91
R48 VSS.n27 VSS.n9 2450.91
R49 VSS.n23 VSS.n9 2450.91
R50 VSS.n27 VSS.n10 2450.91
R51 VSS.n23 VSS.n10 2450.91
R52 VSS.n34 VSS.n6 2068.5
R53 VSS.n30 VSS.n6 2068.5
R54 VSS.n34 VSS.n7 2068.5
R55 VSS.n30 VSS.n7 2068.5
R56 VSS.n37 VSS.n1 2068.5
R57 VSS.n37 VSS.n3 2068.5
R58 VSS.n41 VSS.n3 1778.79
R59 VSS.n44 VSS.n1 1060.74
R60 VSS.n41 VSS.n2 568.865
R61 VSS.n42 VSS.t5 397.012
R62 VSS.n36 VSS.t5 397.012
R63 VSS.n35 VSS.t4 397.012
R64 VSS.n29 VSS.t4 397.012
R65 VSS.n28 VSS.t0 397.012
R66 VSS.n22 VSS.t0 397.012
R67 VSS.n21 VSS.t2 397.012
R68 VSS.n16 VSS.n15 374.317
R69 VSS.n43 VSS.n42 303.334
R70 VSS.n32 VSS.n7 292.5
R71 VSS.n7 VSS.t4 292.5
R72 VSS.n8 VSS.n6 292.5
R73 VSS.n6 VSS.t4 292.5
R74 VSS.n25 VSS.n10 292.5
R75 VSS.n10 VSS.t0 292.5
R76 VSS.n11 VSS.n9 292.5
R77 VSS.n9 VSS.t0 292.5
R78 VSS.n18 VSS.n13 292.5
R79 VSS.n14 VSS.n12 292.5
R80 VSS.n12 VSS.t2 292.5
R81 VSS.n39 VSS.n3 292.5
R82 VSS.n3 VSS.t5 292.5
R83 VSS.n5 VSS.n1 292.5
R84 VSS.t5 VSS.n1 292.5
R85 VSS.n2 VSS.n0 292.5
R86 VSS.n45 VSS.n44 292.5
R87 VSS.n15 VSS.n13 221.405
R88 VSS.n41 VSS.n40 195
R89 VSS.n42 VSS.n41 195
R90 VSS.n19 VSS.n14 159.248
R91 VSS.n17 VSS.n14 159.248
R92 VSS.n19 VSS.n18 159.248
R93 VSS.n18 VSS.n17 159.248
R94 VSS.n26 VSS.n11 159.248
R95 VSS.n24 VSS.n11 159.248
R96 VSS.n26 VSS.n25 159.248
R97 VSS.n25 VSS.n24 159.248
R98 VSS.n31 VSS.n30 146.25
R99 VSS.n30 VSS.n29 146.25
R100 VSS.n34 VSS.n33 146.25
R101 VSS.n35 VSS.n34 146.25
R102 VSS.n38 VSS.n37 146.25
R103 VSS.n37 VSS.n36 146.25
R104 VSS.n36 VSS.n35 139.081
R105 VSS.n29 VSS.n28 139.081
R106 VSS.n22 VSS.n21 139.081
R107 VSS.n33 VSS.n8 134.4
R108 VSS.n31 VSS.n8 134.4
R109 VSS.n33 VSS.n32 134.4
R110 VSS.n32 VSS.n31 134.4
R111 VSS.n39 VSS.n38 134.4
R112 VSS.n38 VSS.n5 134.4
R113 VSS.n40 VSS.n39 115.576
R114 VSS.n24 VSS.n23 97.5005
R115 VSS.n23 VSS.n22 97.5005
R116 VSS.n27 VSS.n26 97.5005
R117 VSS.n28 VSS.n27 97.5005
R118 VSS.n17 VSS.n16 97.5005
R119 VSS.n20 VSS.n19 97.5005
R120 VSS.n21 VSS.n20 97.5005
R121 VSS.n47 VSS.t3 87.5157
R122 VSS.n46 VSS.t1 87.4021
R123 VSS.n5 VSS.n4 67.3887
R124 VSS.n46 VSS.n45 58.0587
R125 VSS.n15 VSS.t2 44.673
R126 VSS.n44 VSS.n43 38.5179
R127 VSS.n43 VSS.n2 34.3594
R128 VSS.n40 VSS.n4 33.1299
R129 VSS.n4 VSS.n0 6.03479
R130 VSS.n45 VSS.n0 1.2805
R131 VSS VSS.n47 0.81125
R132 VSS.n47 VSS.n46 0.290333
R133 a_173_n1434.t1 a_173_n1434.n0 669.27
R134 a_173_n1434.n0 a_173_n1434.n1 0.384333
R135 a_173_n1434.n1 a_173_n1434.n2 0.1885
R136 a_173_n1434.n2 a_173_n1434.t2 232.047
R137 a_173_n1434.n2 a_173_n1434.t3 435.25
R138 a_173_n1434.n1 a_173_n1434.t0 87.3032
R139 a_173_n1434.n0 a_173_n1434.t4 314.149
R140 a_126_n1530.t0 a_126_n1530.n2 668.986
R141 a_126_n1530.n2 a_126_n1530.n0 0.196333
R142 a_126_n1530.n0 a_126_n1530.n1 0.384333
R143 a_126_n1530.n1 a_126_n1530.t2 232.115
R144 a_126_n1530.n1 a_126_n1530.t1 87.1667
R145 a_126_n1530.n0 a_126_n1530.t3 434.887
R146 a_126_n1530.n2 a_126_n1530.t4 314.171
C6 BLB VSS 3.20213f
C7 BL VSS 4.22496f
C8 WL VSS 3.33501f
C9 VDD VSS 3.74788f
C10 a_126_n1530.t0 VSS 0.04371f $ **FLOATING
C11 a_126_n1530.t4 VSS 0.0961f $ **FLOATING
C12 a_126_n1530.t3 VSS 0.12218f $ **FLOATING
C13 a_126_n1530.n0 VSS 0.44909f $ **FLOATING
C14 a_126_n1530.t1 VSS 0.15521f $ **FLOATING
C15 a_126_n1530.n1 VSS 1.79892f $ **FLOATING
C16 a_126_n1530.t2 VSS 0.07198f $ **FLOATING
C17 a_126_n1530.n2 VSS 1.30594f $ **FLOATING
C18 a_173_n1434.t1 VSS 0.05848f $ **FLOATING
C19 a_173_n1434.t4 VSS 0.12792f $ **FLOATING
C20 a_173_n1434.n0 VSS 1.89162f $ **FLOATING
C21 a_173_n1434.t0 VSS 0.20851f $ **FLOATING
C22 a_173_n1434.n1 VSS 0.96678f $ **FLOATING
C23 a_173_n1434.t3 VSS 0.16313f $ **FLOATING
C24 a_173_n1434.n2 VSS 2.22352f $ **FLOATING
C25 a_173_n1434.t2 VSS 0.09541f $ **FLOATING
C26 VDD.t1 VSS 0.0186f $ **FLOATING
C27 VDD.t3 VSS 0.01818f $ **FLOATING
C28 VDD.n0 VSS 1.00442f $ **FLOATING
C29 VDD.t2 VSS 0.35624f $ **FLOATING
C30 VDD.n1 VSS 0.04633f $ **FLOATING
C31 VDD.n2 VSS 0.04633f $ **FLOATING
C32 VDD.n3 VSS 0.04633f $ **FLOATING
C33 VDD.t0 VSS 0.23018f $ **FLOATING
C34 VDD.n4 VSS 0.04633f $ **FLOATING
C35 VDD.n5 VSS 0.04633f $ **FLOATING
C36 VDD.n6 VSS 0.04633f $ **FLOATING
C37 VDD.n8 VSS 0.16832f $ **FLOATING
C38 VDD.n9 VSS 0.04592f $ **FLOATING
C39 VDD.n10 VSS 0.04633f $ **FLOATING
C40 VDD.n11 VSS 0.04592f $ **FLOATING
C41 VDD.n12 VSS 0.04592f $ **FLOATING
C42 VDD.n13 VSS 0.17243f $ **FLOATING
C43 VDD.n14 VSS 0.1845f $ **FLOATING
C44 VDD.n15 VSS 0.04592f $ **FLOATING
C45 VDD.n16 VSS 0.04592f $ **FLOATING
C46 VDD.n17 VSS 0.04633f $ **FLOATING
C47 VDD.n18 VSS 0.04592f $ **FLOATING
C48 VDD.n19 VSS 0.04592f $ **FLOATING
C49 VDD.n20 VSS 0.24133f $ **FLOATING
C50 WL.t0 VSS 0.09972f $ **FLOATING
C51 WL.t1 VSS 0.09938f $ **FLOATING
C52 WL.n0 VSS 1.93747f $ **FLOATING
C53 BL.t0 VSS 0.14124f $ **FLOATING
C54 BLB.t0 VSS 0.07609f $ **FLOATING
.ends
