* SKY130A StrongARM, 11 MOS. Ports SA/SAB map to the original bit polarity.
.subckt strongarm_tt_v0 BL BLB SCLK VDD VSS SA SAB
* Input branches: BL discharges DI_BL and then SAB.
XIN_BL   DI_BL   BL    NTAIL  VSS sky130_fd_pr__nfet_01v8 w=0.65 l=0.15
XIN_BLB  DI_BLB  BLB   NTAIL  VSS sky130_fd_pr__nfet_01v8 w=0.65 l=0.15
XTAIL    NTAIL   SCLK  VSS    VSS sky130_fd_pr__nfet_01v8 w=0.98 l=0.15
* Stacked NMOS and cross-coupled PMOS regeneration.
XLN_SAB  SAB     SA    DI_BL  VSS sky130_fd_pr__nfet_01v8 w=0.98 l=0.15
XLN_SA   SA      SAB   DI_BLB VSS sky130_fd_pr__nfet_01v8 w=0.98 l=0.15
XLP_SAB  SAB     SA    VDD    VDD sky130_fd_pr__pfet_01v8 w=1.89 l=0.15
XLP_SA   SA      SAB   VDD    VDD sky130_fd_pr__pfet_01v8 w=1.89 l=0.15
* Active-low internal reset of both differential stages.
XR_DI_BL  DI_BL   SCLK  VDD  VDD sky130_fd_pr__pfet_01v8 w=0.84 l=0.15
XR_DI_BLB DI_BLB  SCLK  VDD  VDD sky130_fd_pr__pfet_01v8 w=0.84 l=0.15
XR_SAB    SAB     SCLK  VDD  VDD sky130_fd_pr__pfet_01v8 w=0.84 l=0.15
XR_SA     SA      SCLK  VDD  VDD sky130_fd_pr__pfet_01v8 w=0.84 l=0.15
.ends strongarm_tt_v0

.subckt sky130_fd_sc_hd__buf_1 A VGND VNB VPB VPWR X
X0 VGND a_27_47# X VNB sky130_fd_pr__nfet_01v8 w=520000u l=150000u
X1 a_27_47# A VPWR VPB sky130_fd_pr__pfet_01v8_hvt w=790000u l=150000u
X2 a_27_47# A VGND VNB sky130_fd_pr__nfet_01v8 w=520000u l=150000u
X3 VPWR a_27_47# X VPB sky130_fd_pr__pfet_01v8_hvt w=790000u l=150000u
.ends sky130_fd_sc_hd__buf_1

.subckt sky130_fd_sc_hd__and2_1 A B VGND VNB VPB VPWR X
X0 VGND a_59_75# X VNB sky130_fd_pr__nfet_01v8 w=650000u l=150000u
X1 VPWR A a_59_75# VPB sky130_fd_pr__pfet_01v8_hvt w=420000u l=150000u
X2 a_59_75# A a_145_75# VNB sky130_fd_pr__nfet_01v8 w=420000u l=150000u
X3 a_59_75# B VPWR VPB sky130_fd_pr__pfet_01v8_hvt w=420000u l=150000u
X4 a_145_75# B VGND VNB sky130_fd_pr__nfet_01v8 w=420000u l=150000u
X5 VPWR a_59_75# X VPB sky130_fd_pr__pfet_01v8_hvt w=1e+06u l=150000u
.ends

.subckt sky130_fd_sc_hd__and2_4 A B VGND VNB VPB VPWR X
X0 a_27_47# B VPWR VPB sky130_fd_pr__pfet_01v8_hvt w=1e+06u l=150000u
X1 VPWR A a_27_47# VPB sky130_fd_pr__pfet_01v8_hvt w=1e+06u l=150000u
X2 a_110_47# B VGND VNB sky130_fd_pr__nfet_01v8 w=650000u l=150000u
X3 VGND a_27_47# X VNB sky130_fd_pr__nfet_01v8 w=650000u l=150000u
X4 a_27_47# A a_110_47# VNB sky130_fd_pr__nfet_01v8 w=650000u l=150000u
X5 X a_27_47# VGND VNB sky130_fd_pr__nfet_01v8 w=650000u l=150000u
X6 VPWR a_27_47# X VPB sky130_fd_pr__pfet_01v8_hvt w=1e+06u l=150000u
X7 VPWR a_27_47# X VPB sky130_fd_pr__pfet_01v8_hvt w=1e+06u l=150000u
X8 VGND a_27_47# X VNB sky130_fd_pr__nfet_01v8 w=650000u l=150000u
X9 X a_27_47# VPWR VPB sky130_fd_pr__pfet_01v8_hvt w=1e+06u l=150000u
X10 X a_27_47# VGND VNB sky130_fd_pr__nfet_01v8 w=650000u l=150000u
X11 X a_27_47# VPWR VPB sky130_fd_pr__pfet_01v8_hvt w=1e+06u l=150000u
.ends

.subckt sky130_fd_sc_hd__and3_2 A B C VGND VNB VPB VPWR X
X0 X a_29_311# VGND VNB sky130_fd_pr__nfet_01v8 w=650000u l=150000u
X1 X a_29_311# VPWR VPB sky130_fd_pr__pfet_01v8_hvt w=1e+06u l=150000u
X2 a_184_53# C VGND VNB sky130_fd_pr__nfet_01v8 w=420000u l=150000u
X3 a_29_311# A VPWR VPB sky130_fd_pr__pfet_01v8_hvt w=420000u l=150000u
X4 VGND a_29_311# X VNB sky130_fd_pr__nfet_01v8 w=650000u l=150000u
X5 a_112_53# B a_184_53# VNB sky130_fd_pr__nfet_01v8 w=420000u l=150000u
X6 a_29_311# A a_112_53# VNB sky130_fd_pr__nfet_01v8 w=420000u l=150000u
X7 VPWR a_29_311# X VPB sky130_fd_pr__pfet_01v8_hvt w=1e+06u l=150000u
X8 VPWR B a_29_311# VPB sky130_fd_pr__pfet_01v8_hvt w=420000u l=150000u
X9 a_29_311# C VPWR VPB sky130_fd_pr__pfet_01v8_hvt w=420000u l=150000u
.ends

.subckt sky130_fd_sc_hd__and3_4 A B C VGND VNB VPB VPWR X
X0 a_185_47# B a_294_47# VNB sky130_fd_pr__nfet_01v8 w=650000u l=150000u
X1 X a_94_47# VGND VNB sky130_fd_pr__nfet_01v8 w=650000u l=150000u
X2 VPWR B a_94_47# VPB sky130_fd_pr__pfet_01v8_hvt w=1e+06u l=150000u
X3 a_94_47# A VPWR VPB sky130_fd_pr__pfet_01v8_hvt w=1e+06u l=150000u
X4 a_94_47# A a_185_47# VNB sky130_fd_pr__nfet_01v8 w=650000u l=150000u
X5 a_94_47# C VPWR VPB sky130_fd_pr__pfet_01v8_hvt w=1e+06u l=150000u
X6 VGND a_94_47# X VNB sky130_fd_pr__nfet_01v8 w=650000u l=150000u
X7 X a_94_47# VPWR VPB sky130_fd_pr__pfet_01v8_hvt w=1e+06u l=150000u
X8 VPWR a_94_47# X VPB sky130_fd_pr__pfet_01v8_hvt w=1e+06u l=150000u
X9 a_294_47# C VGND VNB sky130_fd_pr__nfet_01v8 w=650000u l=150000u
X10 X a_94_47# VGND VNB sky130_fd_pr__nfet_01v8 w=650000u l=150000u
X11 VGND a_94_47# X VNB sky130_fd_pr__nfet_01v8 w=650000u l=150000u
X12 X a_94_47# VPWR VPB sky130_fd_pr__pfet_01v8_hvt w=1e+06u l=150000u
X13 VPWR a_94_47# X VPB sky130_fd_pr__pfet_01v8_hvt w=1e+06u l=150000u
.ends

.subckt sky130_fd_sc_hd__clkbuf_2 A VGND VNB VPB VPWR X
X0 a_27_47# A VPWR VPB sky130_fd_pr__pfet_01v8_hvt w=1e+06u l=150000u
X1 a_27_47# A VGND VNB sky130_fd_pr__nfet_01v8 w=420000u l=150000u
X2 X a_27_47# VPWR VPB sky130_fd_pr__pfet_01v8_hvt w=1e+06u l=150000u
X3 VPWR a_27_47# X VPB sky130_fd_pr__pfet_01v8_hvt w=1e+06u l=150000u
X4 X a_27_47# VGND VNB sky130_fd_pr__nfet_01v8 w=420000u l=150000u
X5 VGND a_27_47# X VNB sky130_fd_pr__nfet_01v8 w=420000u l=150000u
.ends

.subckt sky130_fd_sc_hd__clkinv_1 A VGND VNB VPB VPWR Y
X0 Y A VPWR VPB sky130_fd_pr__pfet_01v8_hvt w=840000u l=150000u
X1 Y A VGND VNB sky130_fd_pr__nfet_01v8 w=420000u l=150000u
X2 VPWR A Y VPB sky130_fd_pr__pfet_01v8_hvt w=840000u l=150000u
.ends

.subckt sky130_fd_sc_hd__dfxtp_1 CLK D VGND VNB VPB VPWR Q
X0 a_891_413# a_193_47# a_975_413# VPB sky130_fd_pr__pfet_01v8_hvt w=420000u l=150000u
X1 a_1059_315# a_891_413# VGND VNB sky130_fd_pr__nfet_01v8 w=650000u l=150000u
X2 a_466_413# a_27_47# a_561_413# VPB sky130_fd_pr__pfet_01v8_hvt w=420000u l=150000u
X3 a_634_159# a_27_47# a_891_413# VPB sky130_fd_pr__pfet_01v8_hvt w=420000u l=150000u
X4 a_381_47# a_193_47# a_466_413# VPB sky130_fd_pr__pfet_01v8_hvt w=420000u l=150000u
X5 VPWR D a_381_47# VPB sky130_fd_pr__pfet_01v8_hvt w=420000u l=150000u
X6 VPWR a_466_413# a_634_159# VPB sky130_fd_pr__pfet_01v8_hvt w=750000u l=150000u
X7 VGND a_466_413# a_634_159# VNB sky130_fd_pr__nfet_01v8 w=640000u l=150000u
X8 a_1017_47# a_1059_315# VGND VNB sky130_fd_pr__nfet_01v8 w=420000u l=150000u
X9 a_1059_315# a_891_413# VPWR VPB sky130_fd_pr__pfet_01v8_hvt w=1e+06u l=150000u
X10 a_561_413# a_634_159# VPWR VPB sky130_fd_pr__pfet_01v8_hvt w=420000u l=150000u
X11 VPWR a_1059_315# Q VPB sky130_fd_pr__pfet_01v8_hvt w=1e+06u l=150000u
X12 a_891_413# a_27_47# a_1017_47# VNB sky130_fd_pr__special_nfet_01v8 w=360000u l=150000u
X13 a_634_159# a_193_47# a_891_413# VNB sky130_fd_pr__special_nfet_01v8 w=360000u l=150000u
X14 a_592_47# a_634_159# VGND VNB sky130_fd_pr__nfet_01v8 w=420000u l=150000u
X15 a_466_413# a_193_47# a_592_47# VNB sky130_fd_pr__special_nfet_01v8 w=360000u l=150000u
X16 VGND a_27_47# a_193_47# VNB sky130_fd_pr__nfet_01v8 w=420000u l=150000u
X17 a_381_47# a_27_47# a_466_413# VNB sky130_fd_pr__special_nfet_01v8 w=360000u l=150000u
X18 a_27_47# CLK VGND VNB sky130_fd_pr__nfet_01v8 w=420000u l=150000u
X19 a_27_47# CLK VPWR VPB sky130_fd_pr__pfet_01v8_hvt w=640000u l=150000u
X20 VPWR a_27_47# a_193_47# VPB sky130_fd_pr__pfet_01v8_hvt w=640000u l=150000u
X21 VGND D a_381_47# VNB sky130_fd_pr__nfet_01v8 w=420000u l=150000u
X22 a_975_413# a_1059_315# VPWR VPB sky130_fd_pr__pfet_01v8_hvt w=420000u l=150000u
X23 VGND a_1059_315# Q VNB sky130_fd_pr__nfet_01v8 w=650000u l=150000u
.ends

.subckt sky130_fd_sc_hd__dfxtp_2 CLK D VGND VNB VPB VPWR Q
X0 a_891_413# a_193_47# a_975_413# VPB sky130_fd_pr__pfet_01v8_hvt w=420000u l=150000u
X1 a_1059_315# a_891_413# VGND VNB sky130_fd_pr__nfet_01v8 w=650000u l=150000u
X2 a_466_413# a_27_47# a_561_413# VPB sky130_fd_pr__pfet_01v8_hvt w=420000u l=150000u
X3 a_634_159# a_27_47# a_891_413# VPB sky130_fd_pr__pfet_01v8_hvt w=420000u l=150000u
X4 a_381_47# a_193_47# a_466_413# VPB sky130_fd_pr__pfet_01v8_hvt w=420000u l=150000u
X5 VPWR D a_381_47# VPB sky130_fd_pr__pfet_01v8_hvt w=420000u l=150000u
X6 VPWR a_466_413# a_634_159# VPB sky130_fd_pr__pfet_01v8_hvt w=750000u l=150000u
X7 VGND a_466_413# a_634_159# VNB sky130_fd_pr__nfet_01v8 w=640000u l=150000u
X8 a_1017_47# a_1059_315# VGND VNB sky130_fd_pr__nfet_01v8 w=420000u l=150000u
X9 a_1059_315# a_891_413# VPWR VPB sky130_fd_pr__pfet_01v8_hvt w=1e+06u l=150000u
X10 Q a_1059_315# VPWR VPB sky130_fd_pr__pfet_01v8_hvt w=1e+06u l=150000u
X11 a_561_413# a_634_159# VPWR VPB sky130_fd_pr__pfet_01v8_hvt w=420000u l=150000u
X12 VPWR a_1059_315# Q VPB sky130_fd_pr__pfet_01v8_hvt w=1e+06u l=150000u
X13 a_891_413# a_27_47# a_1017_47# VNB sky130_fd_pr__special_nfet_01v8 w=360000u l=150000u
X14 a_634_159# a_193_47# a_891_413# VNB sky130_fd_pr__special_nfet_01v8 w=360000u l=150000u
X15 a_592_47# a_634_159# VGND VNB sky130_fd_pr__nfet_01v8 w=420000u l=150000u
X16 a_466_413# a_193_47# a_592_47# VNB sky130_fd_pr__special_nfet_01v8 w=360000u l=150000u
X17 VGND a_27_47# a_193_47# VNB sky130_fd_pr__nfet_01v8 w=420000u l=150000u
X18 a_381_47# a_27_47# a_466_413# VNB sky130_fd_pr__special_nfet_01v8 w=360000u l=150000u
X19 a_27_47# CLK VGND VNB sky130_fd_pr__nfet_01v8 w=420000u l=150000u
X20 a_27_47# CLK VPWR VPB sky130_fd_pr__pfet_01v8_hvt w=640000u l=150000u
X21 Q a_1059_315# VGND VNB sky130_fd_pr__nfet_01v8 w=650000u l=150000u
X22 VPWR a_27_47# a_193_47# VPB sky130_fd_pr__pfet_01v8_hvt w=640000u l=150000u
X23 VGND D a_381_47# VNB sky130_fd_pr__nfet_01v8 w=420000u l=150000u
X24 a_975_413# a_1059_315# VPWR VPB sky130_fd_pr__pfet_01v8_hvt w=420000u l=150000u
X25 VGND a_1059_315# Q VNB sky130_fd_pr__nfet_01v8 w=650000u l=150000u
.ends

.subckt sky130_fd_sc_hd__ebufn_8 A TE_B VGND VNB VPB VPWR Z
X0 a_407_309# a_116_47# Z VPB sky130_fd_pr__pfet_01v8_hvt w=1e+06u l=150000u
X1 VPWR TE_B a_407_309# VPB sky130_fd_pr__pfet_01v8_hvt w=940000u l=150000u
X2 a_455_47# a_116_47# Z VNB sky130_fd_pr__nfet_01v8 w=650000u l=150000u
X3 a_455_47# a_116_47# Z VNB sky130_fd_pr__nfet_01v8 w=650000u l=150000u
X4 VPWR TE_B a_407_309# VPB sky130_fd_pr__pfet_01v8_hvt w=940000u l=150000u
X5 VPWR TE_B a_407_309# VPB sky130_fd_pr__pfet_01v8_hvt w=940000u l=150000u
X6 Z a_116_47# a_407_309# VPB sky130_fd_pr__pfet_01v8_hvt w=1e+06u l=150000u
X7 Z a_116_47# a_407_309# VPB sky130_fd_pr__pfet_01v8_hvt w=1e+06u l=150000u
X8 VGND a_301_47# a_455_47# VNB sky130_fd_pr__nfet_01v8 w=650000u l=150000u
X9 Z a_116_47# a_455_47# VNB sky130_fd_pr__nfet_01v8 w=650000u l=150000u
X10 VGND a_301_47# a_455_47# VNB sky130_fd_pr__nfet_01v8 w=650000u l=150000u
X11 a_455_47# a_301_47# VGND VNB sky130_fd_pr__nfet_01v8 w=650000u l=150000u
X12 VPWR TE_B a_407_309# VPB sky130_fd_pr__pfet_01v8_hvt w=940000u l=150000u
X13 a_455_47# a_301_47# VGND VNB sky130_fd_pr__nfet_01v8 w=650000u l=150000u
X14 a_116_47# A VGND VNB sky130_fd_pr__nfet_01v8 w=650000u l=150000u
X15 a_407_309# TE_B VPWR VPB sky130_fd_pr__pfet_01v8_hvt w=940000u l=150000u
X16 VGND a_301_47# a_455_47# VNB sky130_fd_pr__nfet_01v8 w=650000u l=150000u
X17 VPWR A a_116_47# VPB sky130_fd_pr__pfet_01v8_hvt w=1e+06u l=150000u
X18 a_407_309# TE_B VPWR VPB sky130_fd_pr__pfet_01v8_hvt w=940000u l=150000u
X19 VGND A a_116_47# VNB sky130_fd_pr__nfet_01v8 w=650000u l=150000u
X20 a_116_47# A VPWR VPB sky130_fd_pr__pfet_01v8_hvt w=1e+06u l=150000u
X21 a_455_47# a_116_47# Z VNB sky130_fd_pr__nfet_01v8 w=650000u l=150000u
X22 Z a_116_47# a_407_309# VPB sky130_fd_pr__pfet_01v8_hvt w=1e+06u l=150000u
X23 VGND a_301_47# a_455_47# VNB sky130_fd_pr__nfet_01v8 w=650000u l=150000u
X24 Z a_116_47# a_455_47# VNB sky130_fd_pr__nfet_01v8 w=650000u l=150000u
X25 a_407_309# a_116_47# Z VPB sky130_fd_pr__pfet_01v8_hvt w=1e+06u l=150000u
X26 Z a_116_47# a_455_47# VNB sky130_fd_pr__nfet_01v8 w=650000u l=150000u
X27 VPWR TE_B a_301_47# VPB sky130_fd_pr__pfet_01v8_hvt w=1e+06u l=150000u
X28 VGND TE_B a_301_47# VNB sky130_fd_pr__nfet_01v8 w=650000u l=150000u
X29 a_455_47# a_301_47# VGND VNB sky130_fd_pr__nfet_01v8 w=650000u l=150000u
X30 a_455_47# a_116_47# Z VNB sky130_fd_pr__nfet_01v8 w=650000u l=150000u
X31 a_407_309# TE_B VPWR VPB sky130_fd_pr__pfet_01v8_hvt w=940000u l=150000u
X32 Z a_116_47# a_407_309# VPB sky130_fd_pr__pfet_01v8_hvt w=1e+06u l=150000u
X33 a_455_47# a_301_47# VGND VNB sky130_fd_pr__nfet_01v8 w=650000u l=150000u
X34 a_407_309# TE_B VPWR VPB sky130_fd_pr__pfet_01v8_hvt w=940000u l=150000u
X35 a_407_309# a_116_47# Z VPB sky130_fd_pr__pfet_01v8_hvt w=1e+06u l=150000u
X36 Z a_116_47# a_455_47# VNB sky130_fd_pr__nfet_01v8 w=650000u l=150000u
X37 a_407_309# a_116_47# Z VPB sky130_fd_pr__pfet_01v8_hvt w=1e+06u l=150000u
.ends

.subckt sky130_fd_sc_hd__fill_1 VGND VNB VPB VPWR
.ends

.subckt sky130_fd_sc_hd__fill_2 VGND VNB VPB VPWR
.ends

.subckt sky130_fd_sc_hd__fill_4 VGND VNB VPB VPWR
.ends

.subckt sky130_fd_sc_hd__fill_8 VGND VNB VPB VPWR
.ends

.subckt sky130_fd_sc_hd__inv_1 A VGND VNB VPB VPWR Y
X0 VGND A Y VNB sky130_fd_pr__nfet_01v8 w=650000u l=150000u
X1 VPWR A Y VPB sky130_fd_pr__pfet_01v8_hvt w=1e+06u l=150000u
.ends

.subckt sky130_fd_sc_hd__mux2_1 A0 A1 S VGND VNB VPB VPWR X
X0 VPWR S a_218_374# VPB sky130_fd_pr__pfet_01v8_hvt w=420000u l=150000u
X1 a_76_199# A0 a_439_47# VNB sky130_fd_pr__nfet_01v8 w=420000u l=150000u
X2 a_535_374# a_505_21# VPWR VPB sky130_fd_pr__pfet_01v8_hvt w=420000u l=150000u
X3 VPWR S a_505_21# VPB sky130_fd_pr__pfet_01v8_hvt w=420000u l=150000u
X4 a_76_199# A1 a_535_374# VPB sky130_fd_pr__pfet_01v8_hvt w=420000u l=150000u
X5 a_218_47# A1 a_76_199# VNB sky130_fd_pr__nfet_01v8 w=420000u l=150000u
X6 a_218_374# A0 a_76_199# VPB sky130_fd_pr__pfet_01v8_hvt w=420000u l=150000u
X7 X a_76_199# VGND VNB sky130_fd_pr__nfet_01v8 w=650000u l=150000u
X8 X a_76_199# VPWR VPB sky130_fd_pr__pfet_01v8_hvt w=1e+06u l=150000u
X9 VGND S a_218_47# VNB sky130_fd_pr__nfet_01v8 w=420000u l=150000u
X10 VGND S a_505_21# VNB sky130_fd_pr__nfet_01v8 w=420000u l=150000u
X11 a_439_47# a_505_21# VGND VNB sky130_fd_pr__nfet_01v8 w=420000u l=150000u
.ends

.subckt sky130_fd_sc_hd__nand2_1 A B VGND VNB VPB VPWR Y
X0 Y A VPWR VPB sky130_fd_pr__pfet_01v8_hvt w=1e+06u l=150000u
X1 VPWR B Y VPB sky130_fd_pr__pfet_01v8_hvt w=1e+06u l=150000u
X2 VGND B a_113_47# VNB sky130_fd_pr__nfet_01v8 w=650000u l=150000u
X3 a_113_47# A Y VNB sky130_fd_pr__nfet_01v8 w=650000u l=150000u
.ends

.subckt sky130_fd_sc_hd__nor3b_1 A B C_N VGND VNB VPB VPWR Y
X0 Y A VGND VNB sky130_fd_pr__nfet_01v8 w=650000u l=150000u
X1 VPWR C_N a_91_199# VPB sky130_fd_pr__pfet_01v8_hvt w=420000u l=150000u
X2 a_161_297# B a_245_297# VPB sky130_fd_pr__pfet_01v8_hvt w=1e+06u l=150000u
X3 VGND C_N a_91_199# VNB sky130_fd_pr__nfet_01v8 w=420000u l=150000u
X4 Y a_91_199# a_161_297# VPB sky130_fd_pr__pfet_01v8_hvt w=1e+06u l=150000u
X5 a_245_297# A VPWR VPB sky130_fd_pr__pfet_01v8_hvt w=1e+06u l=150000u
X6 VGND B Y VNB sky130_fd_pr__nfet_01v8 w=650000u l=150000u
X7 Y a_91_199# VGND VNB sky130_fd_pr__nfet_01v8 w=650000u l=150000u
.ends

.subckt sky130_fd_sc_hd__or2_1 A B VGND VNB VPB VPWR X
X0 a_150_297# A VPWR VPB sky130_fd_pr__pfet_01v8_hvt w=420000u l=150000u
X1 VGND a_68_297# X VNB sky130_fd_pr__nfet_01v8 w=650000u l=150000u
X2 VGND B a_68_297# VNB sky130_fd_pr__nfet_01v8 w=420000u l=150000u
X3 a_68_297# A VGND VNB sky130_fd_pr__nfet_01v8 w=420000u l=150000u
X4 a_68_297# B a_150_297# VPB sky130_fd_pr__pfet_01v8_hvt w=420000u l=150000u
X5 VPWR a_68_297# X VPB sky130_fd_pr__pfet_01v8_hvt w=1e+06u l=150000u
.ends

.subckt sky130_fd_sc_hd__tapvpwrvgnd_1 VGND VPWR
.ends

.subckt sram_4x8_wrapper CLK CSb OEb WEb ADDR0 ADDR1 DATA0 DATA1 DATA2 DATA3 DATA4 DATA5 DATA6 DATA7 VDD VSS
Xmapped12674 CLK VSS VSS VDD VDD n16 sky130_fd_sc_hd__clkinv_1
Xmapped12675 OEb CSb WEb VSS VSS VDD VDD n17 sky130_fd_sc_hd__nor3b_1
Xmapped12676 n18 n17 VSS VSS VDD VDD n19 sky130_fd_sc_hd__nand2_1
Xmapped12677 n20 n21 n18 VSS VSS VDD VDD n22 sky130_fd_sc_hd__mux2_1
Xmapped12678 n23 n24 n18 VSS VSS VDD VDD n25 sky130_fd_sc_hd__mux2_1
Xmapped12679 n26 n27 n18 VSS VSS VDD VDD n28 sky130_fd_sc_hd__mux2_1
Xmapped12680 n29 n30 n18 VSS VSS VDD VDD n31 sky130_fd_sc_hd__mux2_1
Xmapped12681 n32 n33 n18 VSS VSS VDD VDD n34 sky130_fd_sc_hd__mux2_1
Xmapped12682 n35 n36 n18 VSS VSS VDD VDD n37 sky130_fd_sc_hd__mux2_1
Xmapped12683 n38 n39 n18 VSS VSS VDD VDD n40 sky130_fd_sc_hd__mux2_1
Xmapped12684 n41 n42 n18 VSS VSS VDD VDD n43 sky130_fd_sc_hd__mux2_1
Xmapped12685 WEb CSb OEb VSS VSS VDD VDD n44 sky130_fd_sc_hd__nor3b_1
Xmapped12686 n45 DATA0 n44 VSS VSS VDD VDD n46 sky130_fd_sc_hd__mux2_1
Xmapped12687 n47 DATA1 n44 VSS VSS VDD VDD n48 sky130_fd_sc_hd__mux2_1
Xmapped12688 n49 DATA2 n44 VSS VSS VDD VDD n50 sky130_fd_sc_hd__mux2_1
Xmapped12689 n51 DATA3 n44 VSS VSS VDD VDD n52 sky130_fd_sc_hd__mux2_1
Xmapped12690 n53 DATA4 n44 VSS VSS VDD VDD n54 sky130_fd_sc_hd__mux2_1
Xmapped12691 n55 DATA5 n44 VSS VSS VDD VDD n56 sky130_fd_sc_hd__mux2_1
Xmapped12692 n57 DATA6 n44 VSS VSS VDD VDD n58 sky130_fd_sc_hd__mux2_1
Xmapped12693 n59 DATA7 n44 VSS VSS VDD VDD n60 sky130_fd_sc_hd__mux2_1
Xmapped12694 n18 n17 VSS VSS VDD VDD n61 sky130_fd_sc_hd__nand2_1
Xmapped12695 n18 n17 VSS VSS VDD VDD n62 sky130_fd_sc_hd__nand2_1
Xmapped12696 n18 n17 VSS VSS VDD VDD n63 sky130_fd_sc_hd__nand2_1
Xmapped12697 n18 n17 VSS VSS VDD VDD n64 sky130_fd_sc_hd__nand2_1
Xmapped12698 n18 n17 VSS VSS VDD VDD n65 sky130_fd_sc_hd__nand2_1
Xmapped12699 n18 n17 VSS VSS VDD VDD n66 sky130_fd_sc_hd__nand2_1
Xmapped12700 n18 n17 VSS VSS VDD VDD n67 sky130_fd_sc_hd__nand2_1
Xmapped12701 CLK VSS VSS VDD VDD n68 sky130_fd_sc_hd__clkinv_1
Xmapped12702 CLK VSS VSS VDD VDD n69 sky130_fd_sc_hd__clkinv_1
Xmapped12703 CLK VSS VSS VDD VDD n70 sky130_fd_sc_hd__clkinv_1
Xmapped12704 CLK VSS VSS VDD VDD n71 sky130_fd_sc_hd__clkinv_1
Xmapped12705 CLK VSS VSS VDD VDD n72 sky130_fd_sc_hd__clkinv_1
Xmapped12706 CLK VSS VSS VDD VDD n73 sky130_fd_sc_hd__clkinv_1
Xmapped12707 CLK VSS VSS VDD VDD n74 sky130_fd_sc_hd__clkinv_1
Xmapped12708 n75 n46 VSS VSS VDD VDD n45 sky130_fd_sc_hd__dfxtp_1
Xmapped12709 n75 n48 VSS VSS VDD VDD n47 sky130_fd_sc_hd__dfxtp_1
Xmapped12710 n75 n50 VSS VSS VDD VDD n49 sky130_fd_sc_hd__dfxtp_1
Xmapped12711 n75 n52 VSS VSS VDD VDD n51 sky130_fd_sc_hd__dfxtp_1
Xmapped12712 n76 n54 VSS VSS VDD VDD n53 sky130_fd_sc_hd__dfxtp_1
Xmapped12713 n76 n56 VSS VSS VDD VDD n55 sky130_fd_sc_hd__dfxtp_1
Xmapped12714 n76 n58 VSS VSS VDD VDD n57 sky130_fd_sc_hd__dfxtp_1
Xmapped12715 n76 n60 VSS VSS VDD VDD n59 sky130_fd_sc_hd__dfxtp_1
Xmapped12716 n16 n43 VSS VSS VDD VDD n41 sky130_fd_sc_hd__dfxtp_2
Xmapped12717 n68 n40 VSS VSS VDD VDD n38 sky130_fd_sc_hd__dfxtp_2
Xmapped12718 n69 n37 VSS VSS VDD VDD n35 sky130_fd_sc_hd__dfxtp_2
Xmapped12719 n70 n34 VSS VSS VDD VDD n32 sky130_fd_sc_hd__dfxtp_2
Xmapped12720 n71 n31 VSS VSS VDD VDD n29 sky130_fd_sc_hd__dfxtp_2
Xmapped12721 n72 n28 VSS VSS VDD VDD n26 sky130_fd_sc_hd__dfxtp_2
Xmapped12722 n73 n25 VSS VSS VDD VDD n23 sky130_fd_sc_hd__dfxtp_2
Xmapped12723 n74 n22 VSS VSS VDD VDD n20 sky130_fd_sc_hd__dfxtp_2
Xmapped12724 n75 n44 VSS VSS VDD VDD n77 sky130_fd_sc_hd__dfxtp_1
Xmapped12725 n75 n17 VSS VSS VDD VDD n18 sky130_fd_sc_hd__dfxtp_1
Xmapped12726 n75 ADDR0 VSS VSS VDD VDD n78 sky130_fd_sc_hd__dfxtp_1
Xmapped12727 n75 ADDR1 VSS VSS VDD VDD n79 sky130_fd_sc_hd__dfxtp_1
Xmapped12728 n41 n67 VSS VSS VDD VDD DATA0 sky130_fd_sc_hd__ebufn_8
Xmapped12729 n38 n66 VSS VSS VDD VDD DATA1 sky130_fd_sc_hd__ebufn_8
Xmapped12730 n35 n65 VSS VSS VDD VDD DATA2 sky130_fd_sc_hd__ebufn_8
Xmapped12731 n32 n64 VSS VSS VDD VDD DATA3 sky130_fd_sc_hd__ebufn_8
Xmapped12732 n29 n63 VSS VSS VDD VDD DATA4 sky130_fd_sc_hd__ebufn_8
Xmapped12733 n26 n62 VSS VSS VDD VDD DATA5 sky130_fd_sc_hd__ebufn_8
Xmapped12734 n23 n61 VSS VSS VDD VDD DATA6 sky130_fd_sc_hd__ebufn_8
Xmapped12735 n20 n19 VSS VSS VDD VDD DATA7 sky130_fd_sc_hd__ebufn_8
Xmapped12736 CLK VSS VSS VDD VDD n80 sky130_fd_sc_hd__clkbuf_2
Xmapped12737 n80 VSS VSS VDD VDD n75 sky130_fd_sc_hd__clkbuf_2
Xmapped12738 n80 VSS VSS VDD VDD n76 sky130_fd_sc_hd__clkbuf_2
Xmapped12739 n18 n77 VSS VSS VDD VDD n81 sky130_fd_sc_hd__or2_1
Xmapped12740 VDD VSS n78 n79 n94 n95 n100 n101 n45 n47 n49 n51 n53 n55 n57 n59 n86 n87 n88 n89 n90 n91 n92 n93 n42 n39 n36 n33 n30 n27 n24 n21 n96 n97 n98 n99 n82 n83 n84 n85 leaf_fabric
Xmapped12741 n45 VSS VSS VDD VDD n86 sky130_fd_sc_hd__inv_1
Xmapped12742 n47 VSS VSS VDD VDD n87 sky130_fd_sc_hd__inv_1
Xmapped12743 n49 VSS VSS VDD VDD n88 sky130_fd_sc_hd__inv_1
Xmapped12744 n51 VSS VSS VDD VDD n89 sky130_fd_sc_hd__inv_1
Xmapped12745 n53 VSS VSS VDD VDD n90 sky130_fd_sc_hd__inv_1
Xmapped12746 n55 VSS VSS VDD VDD n91 sky130_fd_sc_hd__inv_1
Xmapped12747 n57 VSS VSS VDD VDD n92 sky130_fd_sc_hd__inv_1
Xmapped12748 n59 VSS VSS VDD VDD n93 sky130_fd_sc_hd__inv_1
Xmapped12749 n81 n75 n102 VSS VSS VDD VDD n94 sky130_fd_sc_hd__and3_2
Xmapped12750 n76 VSS VSS VDD VDD n103 sky130_fd_sc_hd__inv_1
Xmapped12751 n104 VSS VSS VDD VDD n105 sky130_fd_sc_hd__inv_1
Xmapped12752 n105 VSS VSS VDD VDD n106 sky130_fd_sc_hd__inv_1
Xmapped12753 n106 VSS VSS VDD VDD n107 sky130_fd_sc_hd__inv_1
Xmapped12754 n107 VSS VSS VDD VDD n108 sky130_fd_sc_hd__inv_1
Xmapped12755 n108 VSS VSS VDD VDD n109 sky130_fd_sc_hd__inv_1
Xmapped12756 n109 VSS VSS VDD VDD n110 sky130_fd_sc_hd__inv_1
Xmapped12757 n110 VSS VSS VDD VDD n111 sky130_fd_sc_hd__inv_1
Xmapped12758 n111 VSS VSS VDD VDD n112 sky130_fd_sc_hd__inv_1
Xmapped12759 n112 VSS VSS VDD VDD n113 sky130_fd_sc_hd__inv_1
Xmapped12760 n113 VSS VSS VDD VDD n114 sky130_fd_sc_hd__inv_1
Xmapped12761 n103 VSS VSS VDD VDD n115 sky130_fd_sc_hd__inv_1
Xmapped12762 n114 VSS VSS VDD VDD n116 sky130_fd_sc_hd__inv_1
Xmapped12763 n116 VSS VSS VDD VDD n117 sky130_fd_sc_hd__inv_1
Xmapped12764 n117 VSS VSS VDD VDD n118 sky130_fd_sc_hd__inv_1
Xmapped12765 n118 VSS VSS VDD VDD n119 sky130_fd_sc_hd__inv_1
Xmapped12766 n119 VSS VSS VDD VDD n120 sky130_fd_sc_hd__inv_1
Xmapped12767 n120 VSS VSS VDD VDD n121 sky130_fd_sc_hd__inv_1
Xmapped12768 n121 VSS VSS VDD VDD n122 sky130_fd_sc_hd__inv_1
Xmapped12769 n122 VSS VSS VDD VDD n123 sky130_fd_sc_hd__inv_1
Xmapped12770 n123 VSS VSS VDD VDD n124 sky130_fd_sc_hd__inv_1
Xmapped12771 n124 VSS VSS VDD VDD n125 sky130_fd_sc_hd__inv_1
Xmapped12772 n115 VSS VSS VDD VDD n126 sky130_fd_sc_hd__inv_1
Xmapped12773 n125 VSS VSS VDD VDD n127 sky130_fd_sc_hd__inv_1
Xmapped12774 n127 VSS VSS VDD VDD n128 sky130_fd_sc_hd__inv_1
Xmapped12775 n128 VSS VSS VDD VDD n129 sky130_fd_sc_hd__inv_1
Xmapped12776 n129 VSS VSS VDD VDD n130 sky130_fd_sc_hd__inv_1
Xmapped12777 n130 VSS VSS VDD VDD n131 sky130_fd_sc_hd__inv_1
Xmapped12778 n131 VSS VSS VDD VDD n132 sky130_fd_sc_hd__inv_1
Xmapped12779 n132 VSS VSS VDD VDD n133 sky130_fd_sc_hd__inv_1
Xmapped12780 n133 VSS VSS VDD VDD n134 sky130_fd_sc_hd__inv_1
Xmapped12781 n134 VSS VSS VDD VDD n135 sky130_fd_sc_hd__inv_1
Xmapped12782 n135 VSS VSS VDD VDD n136 sky130_fd_sc_hd__inv_1
Xmapped12783 n126 VSS VSS VDD VDD n137 sky130_fd_sc_hd__inv_1
Xmapped12784 n136 VSS VSS VDD VDD n138 sky130_fd_sc_hd__inv_1
Xmapped12785 n138 VSS VSS VDD VDD n139 sky130_fd_sc_hd__inv_1
Xmapped12786 n139 VSS VSS VDD VDD n140 sky130_fd_sc_hd__inv_1
Xmapped12787 n140 VSS VSS VDD VDD n141 sky130_fd_sc_hd__inv_1
Xmapped12788 n141 VSS VSS VDD VDD n142 sky130_fd_sc_hd__inv_1
Xmapped12789 n142 VSS VSS VDD VDD n143 sky130_fd_sc_hd__inv_1
Xmapped12790 n143 VSS VSS VDD VDD n144 sky130_fd_sc_hd__inv_1
Xmapped12791 n144 VSS VSS VDD VDD n102 sky130_fd_sc_hd__inv_1
Xmapped12792 n102 VSS VSS VDD VDD n145 sky130_fd_sc_hd__inv_1
Xmapped12793 n145 VSS VSS VDD VDD n146 sky130_fd_sc_hd__inv_1
Xmapped12794 n137 VSS VSS VDD VDD n147 sky130_fd_sc_hd__inv_1
Xmapped12795 n146 VSS VSS VDD VDD n148 sky130_fd_sc_hd__inv_1
Xmapped12796 n148 VSS VSS VDD VDD n149 sky130_fd_sc_hd__inv_1
Xmapped12797 n149 VSS VSS VDD VDD n150 sky130_fd_sc_hd__inv_1
Xmapped12798 n150 VSS VSS VDD VDD n151 sky130_fd_sc_hd__inv_1
Xmapped12799 n151 VSS VSS VDD VDD n152 sky130_fd_sc_hd__inv_1
Xmapped12800 n152 VSS VSS VDD VDD n153 sky130_fd_sc_hd__inv_1
Xmapped12801 n153 VSS VSS VDD VDD n154 sky130_fd_sc_hd__inv_1
Xmapped12802 n154 VSS VSS VDD VDD n155 sky130_fd_sc_hd__inv_1
Xmapped12803 n155 VSS VSS VDD VDD n156 sky130_fd_sc_hd__inv_1
Xmapped12804 n156 VSS VSS VDD VDD n157 sky130_fd_sc_hd__inv_1
Xmapped12805 n147 VSS VSS VDD VDD n158 sky130_fd_sc_hd__inv_1
Xmapped12806 n157 VSS VSS VDD VDD n159 sky130_fd_sc_hd__inv_1
Xmapped12807 n159 VSS VSS VDD VDD n160 sky130_fd_sc_hd__inv_1
Xmapped12808 n160 VSS VSS VDD VDD n161 sky130_fd_sc_hd__inv_1
Xmapped12809 n161 VSS VSS VDD VDD n162 sky130_fd_sc_hd__inv_1
Xmapped12810 n162 VSS VSS VDD VDD n163 sky130_fd_sc_hd__inv_1
Xmapped12811 n163 VSS VSS VDD VDD n164 sky130_fd_sc_hd__inv_1
Xmapped12812 n164 VSS VSS VDD VDD n165 sky130_fd_sc_hd__inv_1
Xmapped12813 n165 VSS VSS VDD VDD n166 sky130_fd_sc_hd__inv_1
Xmapped12814 n166 VSS VSS VDD VDD n167 sky130_fd_sc_hd__inv_1
Xmapped12815 n167 VSS VSS VDD VDD n168 sky130_fd_sc_hd__inv_1
Xmapped12816 n158 VSS VSS VDD VDD n169 sky130_fd_sc_hd__inv_1
Xmapped12817 n168 VSS VSS VDD VDD n170 sky130_fd_sc_hd__inv_1
Xmapped12818 n170 VSS VSS VDD VDD n171 sky130_fd_sc_hd__inv_1
Xmapped12819 n171 VSS VSS VDD VDD n172 sky130_fd_sc_hd__inv_1
Xmapped12820 n172 VSS VSS VDD VDD n173 sky130_fd_sc_hd__inv_1
Xmapped12821 n173 VSS VSS VDD VDD n174 sky130_fd_sc_hd__inv_1
Xmapped12822 n174 VSS VSS VDD VDD n175 sky130_fd_sc_hd__inv_1
Xmapped12823 n175 VSS VSS VDD VDD n176 sky130_fd_sc_hd__inv_1
Xmapped12824 n176 VSS VSS VDD VDD n177 sky130_fd_sc_hd__inv_1
Xmapped12825 n177 VSS VSS VDD VDD n178 sky130_fd_sc_hd__inv_1
Xmapped12826 n178 VSS VSS VDD VDD n179 sky130_fd_sc_hd__inv_1
Xmapped12827 n169 VSS VSS VDD VDD n180 sky130_fd_sc_hd__inv_1
Xmapped12828 n180 VSS VSS VDD VDD n181 sky130_fd_sc_hd__inv_1
Xmapped12829 n181 VSS VSS VDD VDD n104 sky130_fd_sc_hd__inv_1
Xmapped12830 n81 n182 VSS VSS VDD VDD n95 sky130_fd_sc_hd__and2_4
Xmapped12831 n183 n179 VSS VSS VDD VDD n182 sky130_fd_sc_hd__or2_1
Xmapped12832 n82 n94 VSS VSS VDD VDD n96 sky130_fd_sc_hd__and2_1
Xmapped12833 n83 n94 VSS VSS VDD VDD n97 sky130_fd_sc_hd__and2_1
Xmapped12834 n84 n94 VSS VSS VDD VDD n98 sky130_fd_sc_hd__and2_1
Xmapped12835 n85 n94 VSS VSS VDD VDD n99 sky130_fd_sc_hd__and2_1
Xmapped12836 n76 n119 VSS VSS VDD VDD n183 sky130_fd_sc_hd__and2_1
Xmapped12837 n18 n179 VSS VSS VDD VDD n100 sky130_fd_sc_hd__and2_4
Xmapped12838 n77 n75 n136 VSS VSS VDD VDD n101 sky130_fd_sc_hd__and3_4
.ends sram_4x8_wrapper
* Xschem-derived canonical electrical leaf; standalone stimuli omitted.
.subckt bitcell_6t VDD BL BLB VSS WL
XMPL Q QB VDD VDD sky130_fd_pr__pfet_01v8 L=0.15 W=0.42 nf=1 ad='W * 0.29' as='W * 0.29' pd='W + 2 * 0.29' ps='W + 2 * 0.29' nrd=0 nrs=0 sa=0 sb=0 sd=0 mult=1 m=1
XMNL Q QB VSS VSS sky130_fd_pr__nfet_01v8 L=0.15 W=1.26 nf=1 ad='W * 0.29' as='W * 0.29' pd='W + 2 * 0.29' ps='W + 2 * 0.29' nrd=0 nrs=0 sa=0 sb=0 sd=0 mult=1 m=1
XMPR QB Q VDD VDD sky130_fd_pr__pfet_01v8 L=0.15 W=0.42 nf=1 ad='W * 0.29' as='W * 0.29' pd='W + 2 * 0.29' ps='W + 2 * 0.29' nrd=0 nrs=0 sa=0 sb=0 sd=0 mult=1 m=1
XMNR QB Q VSS VSS sky130_fd_pr__nfet_01v8 L=0.15 W=1.26 nf=1 ad='W * 0.29' as='W * 0.29' pd='W + 2 * 0.29' ps='W + 2 * 0.29' nrd=0 nrs=0 sa=0 sb=0 sd=0 mult=1 m=1
XMAL Q WL BL VSS sky130_fd_pr__nfet_01v8 L=0.15 W=0.60 nf=1 ad='W * 0.29' as='W * 0.29' pd='W + 2 * 0.29' ps='W + 2 * 0.29' nrd=0 nrs=0 sa=0 sb=0 sd=0 mult=1 m=1
XMAR BLB WL QB VSS sky130_fd_pr__nfet_01v8 L=0.15 W=0.60 nf=1 ad='W * 0.29' as='W * 0.29' pd='W + 2 * 0.29' ps='W + 2 * 0.29' nrd=0 nrs=0 sa=0 sb=0 sd=0 mult=1 m=1
.ends bitcell_6t

* Xschem-derived canonical electrical leaf; standalone stimuli omitted.
.subckt sense_amp VDD VSS BL BLB SCLK SA_OUT SA_OUTB
XMP1 SA_OUT SA_OUTB VDD VDD sky130_fd_pr__pfet_01v8 L=0.15 W=1.89 nf=1 ad='int((nf+1)/2) * W/nf * 0.29' as='int((nf+2)/2) * W/nf * 0.29' pd='2*int((nf+1)/2) * (W/nf + 0.29)' ps='2*int((nf+2)/2) * (W/nf + 0.29)' nrd='0.29 / W' nrs='0.29 / W' sa=0 sb=0 sd=0 mult=1 m=1
XMN1 SA_OUT SA_OUTB NTAIL VSS sky130_fd_pr__nfet_01v8 L=0.15 W=0.975 nf=1 ad='int((nf+1)/2) * W/nf * 0.29' as='int((nf+2)/2) * W/nf * 0.29' pd='2*int((nf+1)/2) * (W/nf + 0.29)' ps='2*int((nf+2)/2) * (W/nf + 0.29)' nrd='0.29 / W' nrs='0.29 / W' sa=0 sb=0 sd=0 mult=1 m=1
XMP2 SA_OUTB SA_OUT VDD VDD sky130_fd_pr__pfet_01v8 L=0.15 W=1.89 nf=1 ad='int((nf+1)/2) * W/nf * 0.29' as='int((nf+2)/2) * W/nf * 0.29' pd='2*int((nf+1)/2) * (W/nf + 0.29)' ps='2*int((nf+2)/2) * (W/nf + 0.29)' nrd='0.29 / W' nrs='0.29 / W' sa=0 sb=0 sd=0 mult=1 m=1
XMN2 SA_OUTB SA_OUT NTAIL VSS sky130_fd_pr__nfet_01v8 L=0.15 W=0.975 nf=1 ad='int((nf+1)/2) * W/nf * 0.29' as='int((nf+2)/2) * W/nf * 0.29' pd='2*int((nf+1)/2) * (W/nf + 0.29)' ps='2*int((nf+2)/2) * (W/nf + 0.29)' nrd='0.29 / W' nrs='0.29 / W' sa=0 sb=0 sd=0 mult=1 m=1
XMSAMPBL BL SCLK SA_OUT VDD sky130_fd_pr__pfet_01v8 L=0.15 W=2.0 nf=1 ad='int((nf+1)/2) * W/nf * 0.29' as='int((nf+2)/2) * W/nf * 0.29' pd='2*int((nf+1)/2) * (W/nf + 0.29)' ps='2*int((nf+2)/2) * (W/nf + 0.29)' nrd='0.29 / W' nrs='0.29 / W' sa=0 sb=0 sd=0 mult=1 m=1
XMSAMPBLB SA_OUTB SCLK BLB VDD sky130_fd_pr__pfet_01v8 L=0.15 W=2.0 nf=1 ad='int((nf+1)/2) * W/nf * 0.29' as='int((nf+2)/2) * W/nf * 0.29' pd='2*int((nf+1)/2) * (W/nf + 0.29)' ps='2*int((nf+2)/2) * (W/nf + 0.29)' nrd='0.29 / W' nrs='0.29 / W' sa=0 sb=0 sd=0 mult=1 m=1
XMTAIL NTAIL SCLK VSS VSS sky130_fd_pr__nfet_01v8 L=0.15 W=0.975 nf=1 ad='int((nf+1)/2) * W/nf * 0.29' as='int((nf+2)/2) * W/nf * 0.29' pd='2*int((nf+1)/2) * (W/nf + 0.29)' ps='2*int((nf+2)/2) * (W/nf + 0.29)' nrd='0.29 / W' nrs='0.29 / W' sa=0 sb=0 sd=0 mult=1 m=1
.ends sense_amp

* Xschem-derived canonical electrical leaf; standalone stimuli omitted.
.subckt precharge VDD BL BLB PRECH VSS
XMPBL BL PRECH VDD VDD sky130_fd_pr__pfet_01v8 L=0.15 W=2.52 nf=1 ad='int((nf+1)/2) * W/nf * 0.29' as='int((nf+2)/2) * W/nf * 0.29' pd='2*int((nf+1)/2) * (W/nf + 0.29)' ps='2*int((nf+2)/2) * (W/nf + 0.29)' nrd='0.29 / W' nrs='0.29 / W' sa=0 sb=0 sd=0 mult=1 m=1
XMPBLB BLB PRECH VDD VDD sky130_fd_pr__pfet_01v8 L=0.15 W=2.52 nf=1 ad='int((nf+1)/2) * W/nf * 0.29' as='int((nf+2)/2) * W/nf * 0.29' pd='2*int((nf+1)/2) * (W/nf + 0.29)' ps='2*int((nf+2)/2) * (W/nf + 0.29)' nrd='0.29 / W' nrs='0.29 / W' sa=0 sb=0 sd=0 mult=1 m=1
XMEQ BL PRECH BLB VDD sky130_fd_pr__pfet_01v8 L=0.15 W=2.52 nf=1 ad='int((nf+1)/2) * W/nf * 0.29' as='int((nf+2)/2) * W/nf * 0.29' pd='2*int((nf+1)/2) * (W/nf + 0.29)' ps='2*int((nf+2)/2) * (W/nf + 0.29)' nrd='0.29 / W' nrs='0.29 / W' sa=0 sb=0 sd=0 mult=1 m=1
.ends precharge

* Xschem-derived canonical electrical leaf; standalone stimuli omitted.
.subckt wl_driver VDD VSS WL_IN WL
XMP1 WL_N WL_IN VDD VDD sky130_fd_pr__pfet_01v8 L=0.15 W=1.68 nf=1 ad='int((nf+1)/2) * W/nf * 0.29' as='int((nf+2)/2) * W/nf * 0.29' pd='2*int((nf+1)/2) * (W/nf + 0.29)' ps='2*int((nf+2)/2) * (W/nf + 0.29)' nrd='0.29 / W' nrs='0.29 / W' sa=0 sb=0 sd=0 mult=1 m=1
XMN1 WL_N WL_IN VSS VSS sky130_fd_pr__nfet_01v8 L=0.15 W=1.68 nf=1 ad='int((nf+1)/2) * W/nf * 0.29' as='int((nf+2)/2) * W/nf * 0.29' pd='2*int((nf+1)/2) * (W/nf + 0.29)' ps='2*int((nf+2)/2) * (W/nf + 0.29)' nrd='0.29 / W' nrs='0.29 / W' sa=0 sb=0 sd=0 mult=1 m=1
XMP2 WL WL_N VDD VDD sky130_fd_pr__pfet_01v8 L=0.15 W=5.04 nf=1 ad='int((nf+1)/2) * W/nf * 0.29' as='int((nf+2)/2) * W/nf * 0.29' pd='2*int((nf+1)/2) * (W/nf + 0.29)' ps='2*int((nf+2)/2) * (W/nf + 0.29)' nrd='0.29 / W' nrs='0.29 / W' sa=0 sb=0 sd=0 mult=1 m=1
XMN2 WL WL_N VSS VSS sky130_fd_pr__nfet_01v8 L=0.15 W=5.04 nf=1 ad='int((nf+1)/2) * W/nf * 0.29' as='int((nf+2)/2) * W/nf * 0.29' pd='2*int((nf+1)/2) * (W/nf + 0.29)' ps='2*int((nf+2)/2) * (W/nf + 0.29)' nrd='0.29 / W' nrs='0.29 / W' sa=0 sb=0 sd=0 mult=1 m=1
.ends wl_driver

* Xschem-derived canonical electrical leaf; standalone stimuli omitted.
.subckt write_driver DATA DATA_B WE BL BLB VDD VSS
XMPWEB WE_B WE VDD VDD sky130_fd_pr__pfet_01v8 L=0.15 W=0.84 nf=1 ad='int((nf+1)/2) * W/nf * 0.29' as='int((nf+2)/2) * W/nf * 0.29' pd='2*int((nf+1)/2) * (W/nf + 0.29)' ps='2*int((nf+2)/2) * (W/nf + 0.29)' nrd='0.29 / W' nrs='0.29 / W' sa=0 sb=0 sd=0 mult=1 m=1
XMNWEB WE_B WE VSS VSS sky130_fd_pr__nfet_01v8 L=0.15 W=0.84 nf=1 ad='int((nf+1)/2) * W/nf * 0.29' as='int((nf+2)/2) * W/nf * 0.29' pd='2*int((nf+1)/2) * (W/nf + 0.29)' ps='2*int((nf+2)/2) * (W/nf + 0.29)' nrd='0.29 / W' nrs='0.29 / W' sa=0 sb=0 sd=0 mult=1 m=1
XMPENBL net1 WE_B VDD VDD sky130_fd_pr__pfet_01v8 L=0.15 W=5.04 nf=1 ad='int((nf+1)/2) * W/nf * 0.29' as='int((nf+2)/2) * W/nf * 0.29' pd='2*int((nf+1)/2) * (W/nf + 0.29)' ps='2*int((nf+2)/2) * (W/nf + 0.29)' nrd='0.29 / W' nrs='0.29 / W' sa=0 sb=0 sd=0 mult=1 m=1
XMPDBL BL DATA_B net1 VDD sky130_fd_pr__pfet_01v8 L=0.15 W=5.04 nf=1 ad='int((nf+1)/2) * W/nf * 0.29' as='int((nf+2)/2) * W/nf * 0.29' pd='2*int((nf+1)/2) * (W/nf + 0.29)' ps='2*int((nf+2)/2) * (W/nf + 0.29)' nrd='0.29 / W' nrs='0.29 / W' sa=0 sb=0 sd=0 mult=1 m=1
XMNDBL BL DATA_B net2 VSS sky130_fd_pr__nfet_01v8 L=0.15 W=5.04 nf=1 ad='int((nf+1)/2) * W/nf * 0.29' as='int((nf+2)/2) * W/nf * 0.29' pd='2*int((nf+1)/2) * (W/nf + 0.29)' ps='2*int((nf+2)/2) * (W/nf + 0.29)' nrd='0.29 / W' nrs='0.29 / W' sa=0 sb=0 sd=0 mult=1 m=1
XMNENBL net2 WE VSS VSS sky130_fd_pr__nfet_01v8 L=0.15 W=5.04 nf=1 ad='int((nf+1)/2) * W/nf * 0.29' as='int((nf+2)/2) * W/nf * 0.29' pd='2*int((nf+1)/2) * (W/nf + 0.29)' ps='2*int((nf+2)/2) * (W/nf + 0.29)' nrd='0.29 / W' nrs='0.29 / W' sa=0 sb=0 sd=0 mult=1 m=1
XMPENBLB net3 WE_B VDD VDD sky130_fd_pr__pfet_01v8 L=0.15 W=5.04 nf=1 ad='int((nf+1)/2) * W/nf * 0.29' as='int((nf+2)/2) * W/nf * 0.29' pd='2*int((nf+1)/2) * (W/nf + 0.29)' ps='2*int((nf+2)/2) * (W/nf + 0.29)' nrd='0.29 / W' nrs='0.29 / W' sa=0 sb=0 sd=0 mult=1 m=1
XMPDBLB BLB DATA net3 VDD sky130_fd_pr__pfet_01v8 L=0.15 W=5.04 nf=1 ad='int((nf+1)/2) * W/nf * 0.29' as='int((nf+2)/2) * W/nf * 0.29' pd='2*int((nf+1)/2) * (W/nf + 0.29)' ps='2*int((nf+2)/2) * (W/nf + 0.29)' nrd='0.29 / W' nrs='0.29 / W' sa=0 sb=0 sd=0 mult=1 m=1
XMNDBLB BLB DATA net4 VSS sky130_fd_pr__nfet_01v8 L=0.15 W=5.04 nf=1 ad='int((nf+1)/2) * W/nf * 0.29' as='int((nf+2)/2) * W/nf * 0.29' pd='2*int((nf+1)/2) * (W/nf + 0.29)' ps='2*int((nf+2)/2) * (W/nf + 0.29)' nrd='0.29 / W' nrs='0.29 / W' sa=0 sb=0 sd=0 mult=1 m=1
XMNENBLB net4 WE VSS VSS sky130_fd_pr__nfet_01v8 L=0.15 W=5.04 nf=1 ad='int((nf+1)/2) * W/nf * 0.29' as='int((nf+2)/2) * W/nf * 0.29' pd='2*int((nf+1)/2) * (W/nf + 0.29)' ps='2*int((nf+2)/2) * (W/nf + 0.29)' nrd='0.29 / W' nrs='0.29 / W' sa=0 sb=0 sd=0 mult=1 m=1
.ends write_driver

* Xschem-derived canonical electrical leaf; standalone stimuli omitted.
.subckt row_decoder VDD PCLK A0 A1 DEC0 DEC1 DEC3 DEC2 VSS
XM1 A0B A0 VDD VDD sky130_fd_pr__pfet_01v8 L=0.15 W=0.84 nf=1 ad='int((nf+1)/2) * W/nf * 0.29' as='int((nf+2)/2) * W/nf * 0.29' pd='2*int((nf+1)/2) * (W/nf + 0.29)' ps='2*int((nf+2)/2) * (W/nf + 0.29)' nrd='0.29 / W' nrs='0.29 / W' sa=0 sb=0 sd=0 mult=1 m=1
XM2 A0B A0 VSS VSS sky130_fd_pr__nfet_01v8 L=0.15 W=0.84 nf=1 ad='int((nf+1)/2) * W/nf * 0.29' as='int((nf+2)/2) * W/nf * 0.29' pd='2*int((nf+1)/2) * (W/nf + 0.29)' ps='2*int((nf+2)/2) * (W/nf + 0.29)' nrd='0.29 / W' nrs='0.29 / W' sa=0 sb=0 sd=0 mult=1 m=1
XM3 A1B A1 VDD VDD sky130_fd_pr__pfet_01v8 L=0.15 W=0.84 nf=1 ad='int((nf+1)/2) * W/nf * 0.29' as='int((nf+2)/2) * W/nf * 0.29' pd='2*int((nf+1)/2) * (W/nf + 0.29)' ps='2*int((nf+2)/2) * (W/nf + 0.29)' nrd='0.29 / W' nrs='0.29 / W' sa=0 sb=0 sd=0 mult=1 m=1
XM4 A1B A1 VSS VSS sky130_fd_pr__nfet_01v8 L=0.15 W=0.84 nf=1 ad='int((nf+1)/2) * W/nf * 0.29' as='int((nf+2)/2) * W/nf * 0.29' pd='2*int((nf+1)/2) * (W/nf + 0.29)' ps='2*int((nf+2)/2) * (W/nf + 0.29)' nrd='0.29 / W' nrs='0.29 / W' sa=0 sb=0 sd=0 mult=1 m=1
XM5 N0 PCLK VDD VDD sky130_fd_pr__pfet_01v8 L=0.15 W=1.25 nf=1 ad='int((nf+1)/2) * W/nf * 0.29' as='int((nf+2)/2) * W/nf * 0.29' pd='2*int((nf+1)/2) * (W/nf + 0.29)' ps='2*int((nf+2)/2) * (W/nf + 0.29)' nrd='0.29 / W' nrs='0.29 / W' sa=0 sb=0 sd=0 mult=1 m=1
XM6 N0 A1B net1 VSS sky130_fd_pr__nfet_01v8 L=0.15 W=2 nf=1 ad='int((nf+1)/2) * W/nf * 0.29' as='int((nf+2)/2) * W/nf * 0.29' pd='2*int((nf+1)/2) * (W/nf + 0.29)' ps='2*int((nf+2)/2) * (W/nf + 0.29)' nrd='0.29 / W' nrs='0.29 / W' sa=0 sb=0 sd=0 mult=1 m=1
XM7 net1 A0B EVAL_GND VSS sky130_fd_pr__nfet_01v8 L=0.15 W=2 nf=1 ad='int((nf+1)/2) * W/nf * 0.29' as='int((nf+2)/2) * W/nf * 0.29' pd='2*int((nf+1)/2) * (W/nf + 0.29)' ps='2*int((nf+2)/2) * (W/nf + 0.29)' nrd='0.29 / W' nrs='0.29 / W' sa=0 sb=0 sd=0 mult=1 m=1
XM8 EVAL_GND PCLK VSS VSS sky130_fd_pr__nfet_01v8 L=0.15 W=1.5 nf=1 ad='int((nf+1)/2) * W/nf * 0.29' as='int((nf+2)/2) * W/nf * 0.29' pd='2*int((nf+1)/2) * (W/nf + 0.29)' ps='2*int((nf+2)/2) * (W/nf + 0.29)' nrd='0.29 / W' nrs='0.29 / W' sa=0 sb=0 sd=0 mult=1 m=1
XM9 DEC0 N0 VDD VDD sky130_fd_pr__pfet_01v8 L=0.15 W=3 nf=1 ad='int((nf+1)/2) * W/nf * 0.29' as='int((nf+2)/2) * W/nf * 0.29' pd='2*int((nf+1)/2) * (W/nf + 0.29)' ps='2*int((nf+2)/2) * (W/nf + 0.29)' nrd='0.29 / W' nrs='0.29 / W' sa=0 sb=0 sd=0 mult=1 m=1
XM10 DEC0 N0 VSS VSS sky130_fd_pr__nfet_01v8 L=0.15 W=2 nf=1 ad='int((nf+1)/2) * W/nf * 0.29' as='int((nf+2)/2) * W/nf * 0.29' pd='2*int((nf+1)/2) * (W/nf + 0.29)' ps='2*int((nf+2)/2) * (W/nf + 0.29)' nrd='0.29 / W' nrs='0.29 / W' sa=0 sb=0 sd=0 mult=1 m=1
XM11 N1 PCLK VDD VDD sky130_fd_pr__pfet_01v8 L=0.15 W=1.25 nf=1 ad='int((nf+1)/2) * W/nf * 0.29' as='int((nf+2)/2) * W/nf * 0.29' pd='2*int((nf+1)/2) * (W/nf + 0.29)' ps='2*int((nf+2)/2) * (W/nf + 0.29)' nrd='0.29 / W' nrs='0.29 / W' sa=0 sb=0 sd=0 mult=1 m=1
XM12 N1 A1B net2 VSS sky130_fd_pr__nfet_01v8 L=0.15 W=2 nf=1 ad='int((nf+1)/2) * W/nf * 0.29' as='int((nf+2)/2) * W/nf * 0.29' pd='2*int((nf+1)/2) * (W/nf + 0.29)' ps='2*int((nf+2)/2) * (W/nf + 0.29)' nrd='0.29 / W' nrs='0.29 / W' sa=0 sb=0 sd=0 mult=1 m=1
XM13 net2 A0T EVAL_GND VSS sky130_fd_pr__nfet_01v8 L=0.15 W=2 nf=1 ad='int((nf+1)/2) * W/nf * 0.29' as='int((nf+2)/2) * W/nf * 0.29' pd='2*int((nf+1)/2) * (W/nf + 0.29)' ps='2*int((nf+2)/2) * (W/nf + 0.29)' nrd='0.29 / W' nrs='0.29 / W' sa=0 sb=0 sd=0 mult=1 m=1
XM14 DEC1 N1 VDD VDD sky130_fd_pr__pfet_01v8 L=0.15 W=3 nf=1 ad='int((nf+1)/2) * W/nf * 0.29' as='int((nf+2)/2) * W/nf * 0.29' pd='2*int((nf+1)/2) * (W/nf + 0.29)' ps='2*int((nf+2)/2) * (W/nf + 0.29)' nrd='0.29 / W' nrs='0.29 / W' sa=0 sb=0 sd=0 mult=1 m=1
XM15 DEC1 N1 VSS VSS sky130_fd_pr__nfet_01v8 L=0.15 W=2 nf=1 ad='int((nf+1)/2) * W/nf * 0.29' as='int((nf+2)/2) * W/nf * 0.29' pd='2*int((nf+1)/2) * (W/nf + 0.29)' ps='2*int((nf+2)/2) * (W/nf + 0.29)' nrd='0.29 / W' nrs='0.29 / W' sa=0 sb=0 sd=0 mult=1 m=1
XM16 N2 PCLK VDD VDD sky130_fd_pr__pfet_01v8 L=0.15 W=1.25 nf=1 ad='int((nf+1)/2) * W/nf * 0.29' as='int((nf+2)/2) * W/nf * 0.29' pd='2*int((nf+1)/2) * (W/nf + 0.29)' ps='2*int((nf+2)/2) * (W/nf + 0.29)' nrd='0.29 / W' nrs='0.29 / W' sa=0 sb=0 sd=0 mult=1 m=1
XM17 N2 A1T net3 VSS sky130_fd_pr__nfet_01v8 L=0.15 W=2 nf=1 ad='int((nf+1)/2) * W/nf * 0.29' as='int((nf+2)/2) * W/nf * 0.29' pd='2*int((nf+1)/2) * (W/nf + 0.29)' ps='2*int((nf+2)/2) * (W/nf + 0.29)' nrd='0.29 / W' nrs='0.29 / W' sa=0 sb=0 sd=0 mult=1 m=1
XM18 net3 A0B EVAL_GND VSS sky130_fd_pr__nfet_01v8 L=0.15 W=2 nf=1 ad='int((nf+1)/2) * W/nf * 0.29' as='int((nf+2)/2) * W/nf * 0.29' pd='2*int((nf+1)/2) * (W/nf + 0.29)' ps='2*int((nf+2)/2) * (W/nf + 0.29)' nrd='0.29 / W' nrs='0.29 / W' sa=0 sb=0 sd=0 mult=1 m=1
XM19 DEC2 N2 VDD VDD sky130_fd_pr__pfet_01v8 L=0.15 W=3 nf=1 ad='int((nf+1)/2) * W/nf * 0.29' as='int((nf+2)/2) * W/nf * 0.29' pd='2*int((nf+1)/2) * (W/nf + 0.29)' ps='2*int((nf+2)/2) * (W/nf + 0.29)' nrd='0.29 / W' nrs='0.29 / W' sa=0 sb=0 sd=0 mult=1 m=1
XM20 DEC2 N2 VSS VSS sky130_fd_pr__nfet_01v8 L=0.15 W=2 nf=1 ad='int((nf+1)/2) * W/nf * 0.29' as='int((nf+2)/2) * W/nf * 0.29' pd='2*int((nf+1)/2) * (W/nf + 0.29)' ps='2*int((nf+2)/2) * (W/nf + 0.29)' nrd='0.29 / W' nrs='0.29 / W' sa=0 sb=0 sd=0 mult=1 m=1
XM21 N3 PCLK VDD VDD sky130_fd_pr__pfet_01v8 L=0.15 W=1.25 nf=1 ad='int((nf+1)/2) * W/nf * 0.29' as='int((nf+2)/2) * W/nf * 0.29' pd='2*int((nf+1)/2) * (W/nf + 0.29)' ps='2*int((nf+2)/2) * (W/nf + 0.29)' nrd='0.29 / W' nrs='0.29 / W' sa=0 sb=0 sd=0 mult=1 m=1
XM22 N3 A1T net4 VSS sky130_fd_pr__nfet_01v8 L=0.15 W=2 nf=1 ad='int((nf+1)/2) * W/nf * 0.29' as='int((nf+2)/2) * W/nf * 0.29' pd='2*int((nf+1)/2) * (W/nf + 0.29)' ps='2*int((nf+2)/2) * (W/nf + 0.29)' nrd='0.29 / W' nrs='0.29 / W' sa=0 sb=0 sd=0 mult=1 m=1
XM23 net4 A0T EVAL_GND VSS sky130_fd_pr__nfet_01v8 L=0.15 W=2 nf=1 ad='int((nf+1)/2) * W/nf * 0.29' as='int((nf+2)/2) * W/nf * 0.29' pd='2*int((nf+1)/2) * (W/nf + 0.29)' ps='2*int((nf+2)/2) * (W/nf + 0.29)' nrd='0.29 / W' nrs='0.29 / W' sa=0 sb=0 sd=0 mult=1 m=1
XM24 DEC3 N3 VDD VDD sky130_fd_pr__pfet_01v8 L=0.15 W=3 nf=1 ad='int((nf+1)/2) * W/nf * 0.29' as='int((nf+2)/2) * W/nf * 0.29' pd='2*int((nf+1)/2) * (W/nf + 0.29)' ps='2*int((nf+2)/2) * (W/nf + 0.29)' nrd='0.29 / W' nrs='0.29 / W' sa=0 sb=0 sd=0 mult=1 m=1
XM25 DEC3 N3 VSS VSS sky130_fd_pr__nfet_01v8 L=0.15 W=2 nf=1 ad='int((nf+1)/2) * W/nf * 0.29' as='int((nf+2)/2) * W/nf * 0.29' pd='2*int((nf+1)/2) * (W/nf + 0.29)' ps='2*int((nf+2)/2) * (W/nf + 0.29)' nrd='0.29 / W' nrs='0.29 / W' sa=0 sb=0 sd=0 mult=1 m=1
XM26 A0T A0B VDD VDD sky130_fd_pr__pfet_01v8 L=0.15 W=2 nf=1 ad='int((nf+1)/2) * W/nf * 0.29' as='int((nf+2)/2) * W/nf * 0.29' pd='2*int((nf+1)/2) * (W/nf + 0.29)' ps='2*int((nf+2)/2) * (W/nf + 0.29)' nrd='0.29 / W' nrs='0.29 / W' sa=0 sb=0 sd=0 mult=1 m=1
XM27 A0T A0B VSS VSS sky130_fd_pr__nfet_01v8 L=0.15 W=2 nf=1 ad='int((nf+1)/2) * W/nf * 0.29' as='int((nf+2)/2) * W/nf * 0.29' pd='2*int((nf+1)/2) * (W/nf + 0.29)' ps='2*int((nf+2)/2) * (W/nf + 0.29)' nrd='0.29 / W' nrs='0.29 / W' sa=0 sb=0 sd=0 mult=1 m=1
XM28 A1T A1B VDD VDD sky130_fd_pr__pfet_01v8 L=0.15 W=2 nf=1 ad='int((nf+1)/2) * W/nf * 0.29' as='int((nf+2)/2) * W/nf * 0.29' pd='2*int((nf+1)/2) * (W/nf + 0.29)' ps='2*int((nf+2)/2) * (W/nf + 0.29)' nrd='0.29 / W' nrs='0.29 / W' sa=0 sb=0 sd=0 mult=1 m=1
XM29 A1T A1B VSS VSS sky130_fd_pr__nfet_01v8 L=0.15 W=2 nf=1 ad='int((nf+1)/2) * W/nf * 0.29' as='int((nf+2)/2) * W/nf * 0.29' pd='2*int((nf+1)/2) * (W/nf + 0.29)' ps='2*int((nf+2)/2) * (W/nf + 0.29)' nrd='0.29 / W' nrs='0.29 / W' sa=0 sb=0 sd=0 mult=1 m=1
XM30 N0 DEC0 VDD VDD sky130_fd_pr__pfet_01v8 L=0.15 W=0.84 nf=1 ad='int((nf+1)/2) * W/nf * 0.29' as='int((nf+2)/2) * W/nf * 0.29' pd='2*int((nf+1)/2) * (W/nf + 0.29)' ps='2*int((nf+2)/2) * (W/nf + 0.29)' nrd='0.29 / W' nrs='0.29 / W' sa=0 sb=0 sd=0 mult=1 m=1
XM31 N1 DEC1 VDD VDD sky130_fd_pr__pfet_01v8 L=0.15 W=0.84 nf=1 ad='int((nf+1)/2) * W/nf * 0.29' as='int((nf+2)/2) * W/nf * 0.29' pd='2*int((nf+1)/2) * (W/nf + 0.29)' ps='2*int((nf+2)/2) * (W/nf + 0.29)' nrd='0.29 / W' nrs='0.29 / W' sa=0 sb=0 sd=0 mult=1 m=1
XM32 N2 DEC2 VDD VDD sky130_fd_pr__pfet_01v8 L=0.15 W=0.84 nf=1 ad='int((nf+1)/2) * W/nf * 0.29' as='int((nf+2)/2) * W/nf * 0.29' pd='2*int((nf+1)/2) * (W/nf + 0.29)' ps='2*int((nf+2)/2) * (W/nf + 0.29)' nrd='0.29 / W' nrs='0.29 / W' sa=0 sb=0 sd=0 mult=1 m=1
XM33 N3 DEC3 VDD VDD sky130_fd_pr__pfet_01v8 L=0.15 W=0.84 nf=1 ad='int((nf+1)/2) * W/nf * 0.29' as='int((nf+2)/2) * W/nf * 0.29' pd='2*int((nf+1)/2) * (W/nf + 0.29)' ps='2*int((nf+2)/2) * (W/nf + 0.29)' nrd='0.29 / W' nrs='0.29 / W' sa=0 sb=0 sd=0 mult=1 m=1
.ends row_decoder

.subckt leaf_fabric VDD VSS A0 A1 PCLK PRECH SCLK WE DIN0 DIN1 DIN2 DIN3 DIN4 DIN5 DIN6 DIN7 DIN_B0 DIN_B1 DIN_B2 DIN_B3 DIN_B4 DIN_B5 DIN_B6 DIN_B7 DOUT0 DOUT1 DOUT2 DOUT3 DOUT4 DOUT5 DOUT6 DOUT7 ROW0 ROW1 ROW2 ROW3 DEC0 DEC1 DEC2 DEC3
Xbit_r0_b0 VDD BL0 BLB0 VSS WL0 bitcell_6t
Xbit_r0_b1 VDD BL1 BLB1 VSS WL0 bitcell_6t
Xbit_r0_b2 VDD BL2 BLB2 VSS WL0 bitcell_6t
Xbit_r0_b3 VDD BL3 BLB3 VSS WL0 bitcell_6t
Xbit_r0_b4 VDD BL4 BLB4 VSS WL0 bitcell_6t
Xbit_r0_b5 VDD BL5 BLB5 VSS WL0 bitcell_6t
Xbit_r0_b6 VDD BL6 BLB6 VSS WL0 bitcell_6t
Xbit_r0_b7 VDD BL7 BLB7 VSS WL0 bitcell_6t
Xbit_r1_b0 VDD BL0 BLB0 VSS WL1 bitcell_6t
Xbit_r1_b1 VDD BL1 BLB1 VSS WL1 bitcell_6t
Xbit_r1_b2 VDD BL2 BLB2 VSS WL1 bitcell_6t
Xbit_r1_b3 VDD BL3 BLB3 VSS WL1 bitcell_6t
Xbit_r1_b4 VDD BL4 BLB4 VSS WL1 bitcell_6t
Xbit_r1_b5 VDD BL5 BLB5 VSS WL1 bitcell_6t
Xbit_r1_b6 VDD BL6 BLB6 VSS WL1 bitcell_6t
Xbit_r1_b7 VDD BL7 BLB7 VSS WL1 bitcell_6t
Xbit_r2_b0 VDD BL0 BLB0 VSS WL2 bitcell_6t
Xbit_r2_b1 VDD BL1 BLB1 VSS WL2 bitcell_6t
Xbit_r2_b2 VDD BL2 BLB2 VSS WL2 bitcell_6t
Xbit_r2_b3 VDD BL3 BLB3 VSS WL2 bitcell_6t
Xbit_r2_b4 VDD BL4 BLB4 VSS WL2 bitcell_6t
Xbit_r2_b5 VDD BL5 BLB5 VSS WL2 bitcell_6t
Xbit_r2_b6 VDD BL6 BLB6 VSS WL2 bitcell_6t
Xbit_r2_b7 VDD BL7 BLB7 VSS WL2 bitcell_6t
Xbit_r3_b0 VDD BL0 BLB0 VSS WL3 bitcell_6t
Xbit_r3_b1 VDD BL1 BLB1 VSS WL3 bitcell_6t
Xbit_r3_b2 VDD BL2 BLB2 VSS WL3 bitcell_6t
Xbit_r3_b3 VDD BL3 BLB3 VSS WL3 bitcell_6t
Xbit_r3_b4 VDD BL4 BLB4 VSS WL3 bitcell_6t
Xbit_r3_b5 VDD BL5 BLB5 VSS WL3 bitcell_6t
Xbit_r3_b6 VDD BL6 BLB6 VSS WL3 bitcell_6t
Xbit_r3_b7 VDD BL7 BLB7 VSS WL3 bitcell_6t
Xdecode VDD PCLK A0 A1 DEC0 DEC1 DEC3 DEC2 VSS row_decoder
Xdrive0 VDD VSS ROW0 WL0 wl_driver
Xdrive1 VDD VSS ROW1 WL1 wl_driver
Xdrive2 VDD VSS ROW2 WL2 wl_driver
Xdrive3 VDD VSS ROW3 WL3 wl_driver
Xprecharge0 VDD BL0 BLB0 PRECH VSS precharge
Xwrite0 DIN0 DIN_B0 WE BL0 BLB0 VDD VSS write_driver
Xsense0 VDD VSS BL0 BLB0 SCLK DOUT0 DOUT_B0 sense_amp
Xprecharge1 VDD BL1 BLB1 PRECH VSS precharge
Xwrite1 DIN1 DIN_B1 WE BL1 BLB1 VDD VSS write_driver
Xsense1 VDD VSS BL1 BLB1 SCLK DOUT1 DOUT_B1 sense_amp
Xprecharge2 VDD BL2 BLB2 PRECH VSS precharge
Xwrite2 DIN2 DIN_B2 WE BL2 BLB2 VDD VSS write_driver
Xsense2 VDD VSS BL2 BLB2 SCLK DOUT2 DOUT_B2 sense_amp
Xprecharge3 VDD BL3 BLB3 PRECH VSS precharge
Xwrite3 DIN3 DIN_B3 WE BL3 BLB3 VDD VSS write_driver
Xsense3 BL3 BLB3 SCLK VDD VSS ECO_SA3 ECO_SAB3 strongarm_tt_v0
Xbufsa3 ECO_SA3 VSS VSS VDD VDD DOUT3 sky130_fd_sc_hd__buf_1
Xbufsab3 ECO_SAB3 VSS VSS VDD VDD DOUT_B3 sky130_fd_sc_hd__buf_1
Xprecharge4 VDD BL4 BLB4 PRECH VSS precharge
Xwrite4 DIN4 DIN_B4 WE BL4 BLB4 VDD VSS write_driver
Xsense4 VDD VSS BL4 BLB4 SCLK DOUT4 DOUT_B4 sense_amp
Xprecharge5 VDD BL5 BLB5 PRECH VSS precharge
Xwrite5 DIN5 DIN_B5 WE BL5 BLB5 VDD VSS write_driver
Xsense5 VDD VSS BL5 BLB5 SCLK DOUT5 DOUT_B5 sense_amp
Xprecharge6 VDD BL6 BLB6 PRECH VSS precharge
Xwrite6 DIN6 DIN_B6 WE BL6 BLB6 VDD VSS write_driver
Xsense6 BL6 BLB6 SCLK VDD VSS ECO_SA6 ECO_SAB6 strongarm_tt_v0
Xbufsa6 ECO_SA6 VSS VSS VDD VDD DOUT6 sky130_fd_sc_hd__buf_1
Xbufsab6 ECO_SAB6 VSS VSS VDD VDD DOUT_B6 sky130_fd_sc_hd__buf_1
Xprecharge7 VDD BL7 BLB7 PRECH VSS precharge
Xwrite7 DIN7 DIN_B7 WE BL7 BLB7 VDD VSS write_driver
Xsense7 BL7 BLB7 SCLK VDD VSS ECO_SA7 ECO_SAB7 strongarm_tt_v0
Xbufsa7 ECO_SA7 VSS VSS VDD VDD DOUT7 sky130_fd_sc_hd__buf_1
Xbufsab7 ECO_SAB7 VSS VSS VDD VDD DOUT_B7 sky130_fd_sc_hd__buf_1
.ends leaf_fabric
